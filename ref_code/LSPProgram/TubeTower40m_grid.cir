.SUBCKT TubeTower40m_grid N_T0m N_BUS_GND N_BUS_2
**************************************
*   Model Generated by Chen Hongcai  *
*   Hong Kong Polytechic University  *
*         All Rights Reserved        *
*       Email:  hc.chen@live.com     *
**************************************
* Model generated on 21-Jun-2018
* MODEL FORMAT: PSpice
*  Node  N_T0m  to other nodes
* *  Node  N_T0m  to  Node  N_C0_93
R_R1  N_T0m  N_C0_93  3.311369e+05m  TC=0,0
R_V1  N_T0m  nV_1  5.753454e+01m  TC=0,0
L_V1  nV_1  N_C0_93  4.321286e+00uH
R_V2  N_T0m  nV_2  9.194456e-01m  TC=0,0
L_V2  nV_2  N_C0_93  1.489966e+00uH
R_V3  N_T0m  nV_3  2.733240e+01m  TC=0,0
L_V3  nV_3  N_C0_93  1.535618e+02uH
* *  Node  N_T0m  to  Node  N_C0_94
R_R2  N_T0m  N_C0_94  1.929561e+07m  TC=0,0
R_V4  N_T0m  nV_4  -1.968526e+04m  TC=0,0
L_V4  nV_4  N_C0_94  -1.478515e+03uH
R_V5  N_T0m  nV_5  2.689583e+04m  TC=0,0
L_V5  nV_5  N_C0_94  4.358481e+04uH
R_V6  N_T0m  nV_6  -8.558092e+04m  TC=0,0
L_V6  nV_6  N_C0_94  -4.808199e+05uH
* *  Node  N_T0m  to  Node  N_C0_95
R_R3  N_T0m  N_C0_95  7.290655e+07m  TC=0,0
R_V7  N_T0m  nV_7  -2.972018e+04m  TC=0,0
L_V7  nV_7  N_C0_95  -2.232214e+03uH
R_V8  N_T0m  nV_8  6.089555e+04m  TC=0,0
L_V8  nV_8  N_C0_95  9.868150e+04uH
R_V9  N_T0m  nV_9  -1.322723e+05m  TC=0,0
L_V9  nV_9  N_C0_95  -7.431464e+05uH
* *  Node  N_T0m  to  Node  N_C0_96
R_R4  N_T0m  N_C0_96  1.929561e+07m  TC=0,0
R_V10  N_T0m  nV_10  -1.968526e+04m  TC=0,0
L_V10  nV_10  N_C0_96  -1.478515e+03uH
R_V11  N_T0m  nV_11  2.689583e+04m  TC=0,0
L_V11  nV_11  N_C0_96  4.358481e+04uH
R_V12  N_T0m  nV_12  -8.558092e+04m  TC=0,0
L_V12  nV_12  N_C0_96  -4.808199e+05uH
* *  Node  N_T0m  to  Node  N_C0_97
R_R5  N_T0m  N_C0_97  1.589169e+07m  TC=0,0
R_V13  N_T0m  nV_13  -1.566857e+04m  TC=0,0
L_V13  nV_13  N_C0_97  -1.176830e+03uH
R_V14  N_T0m  nV_14  1.847131e+04m  TC=0,0
L_V14  nV_14  N_C0_97  2.993283e+04uH
R_V15  N_T0m  nV_15  -9.309683e+04m  TC=0,0
L_V15  nV_15  N_C0_97  -5.230466e+05uH
* *  Node  N_T0m  to  Node  N_C0_98
R_R6  N_T0m  N_C0_98  5.673567e+06m  TC=0,0
R_V16  N_T0m  nV_16  7.920833e+03m  TC=0,0
L_V16  nV_16  N_C0_98  5.949155e+02uH
R_V17  N_T0m  nV_17  6.862050e+01m  TC=0,0
L_V17  nV_17  N_C0_98  1.111998e+02uH
R_V18  N_T0m  nV_18  -7.094932e+01m  TC=0,0
L_V18  nV_18  N_C0_98  -3.986151e+02uH
* *  Node  N_T0m  to  Node  N_C0_99
R_R7  N_T0m  N_C0_99  2.734986e+07m  TC=0,0
R_V19  N_T0m  nV_19  8.946755e+03m  TC=0,0
L_V19  nV_19  N_C0_99  6.719701e+02uH
R_V20  N_T0m  nV_20  6.792547e+01m  TC=0,0
L_V20  nV_20  N_C0_99  1.100735e+02uH
R_V21  N_T0m  nV_21  -7.022211e+01m  TC=0,0
L_V21  nV_21  N_C0_99  -3.945294e+02uH
* *  Node  N_T0m  to  Node  N_C0_100
R_R8  N_T0m  N_C0_100  2.734986e+07m  TC=0,0
R_V22  N_T0m  nV_22  8.946755e+03m  TC=0,0
L_V22  nV_22  N_C0_100  6.719701e+02uH
R_V23  N_T0m  nV_23  6.792547e+01m  TC=0,0
L_V23  nV_23  N_C0_100  1.100735e+02uH
R_V24  N_T0m  nV_24  -7.022211e+01m  TC=0,0
L_V24  nV_24  N_C0_100  -3.945294e+02uH
* *  Node  N_T0m  to  Node  N_C0_101
R_R9  N_T0m  N_C0_101  5.673567e+06m  TC=0,0
R_V25  N_T0m  nV_25  7.920833e+03m  TC=0,0
L_V25  nV_25  N_C0_101  5.949155e+02uH
R_V26  N_T0m  nV_26  6.862050e+01m  TC=0,0
L_V26  nV_26  N_C0_101  1.111998e+02uH
R_V27  N_T0m  nV_27  -7.094932e+01m  TC=0,0
L_V27  nV_27  N_C0_101  -3.986151e+02uH
* *  Node  N_T0m  to  Node  N_C0_102
R_R10  N_T0m  N_C0_102  3.029630e+07m  TC=0,0
R_V28  N_T0m  nV_28  1.477471e+04m  TC=0,0
L_V28  nV_28  N_C0_102  1.109695e+03uH
R_V29  N_T0m  nV_29  1.841328e+02m  TC=0,0
L_V29  nV_29  N_C0_102  2.983881e+02uH
R_V30  N_T0m  nV_30  -1.942703e+02m  TC=0,0
L_V30  nV_30  N_C0_102  -1.091470e+03uH
* *  Node  N_T0m  to  Node  N_C0_103
R_R11  N_T0m  N_C0_103  -1.683560e+09m  TC=0,0
R_V31  N_T0m  nV_31  9.834939e+04m  TC=0,0
L_V31  nV_31  N_C0_103  7.386795e+03uH
R_V32  N_T0m  nV_32  -4.777270e+04m  TC=0,0
L_V32  nV_32  N_C0_103  -7.741587e+04uH
R_V33  N_T0m  nV_33  -1.058103e+06m  TC=0,0
L_V33  nV_33  N_C0_103  -5.944746e+06uH
* *  Node  N_T0m  to  Node  N_C0_104
R_R12  N_T0m  N_C0_104  3.029630e+07m  TC=0,0
R_V34  N_T0m  nV_34  1.477471e+04m  TC=0,0
L_V34  nV_34  N_C0_104  1.109695e+03uH
R_V35  N_T0m  nV_35  1.841328e+02m  TC=0,0
L_V35  nV_35  N_C0_104  2.983881e+02uH
R_V36  N_T0m  nV_36  -1.942703e+02m  TC=0,0
L_V36  nV_36  N_C0_104  -1.091470e+03uH
* *  Node  N_T0m  to  Node  NTMP0000000019
R_R13  N_T0m  NTMP0000000019  -1.226208e+08m  TC=0,0
R_V37  N_T0m  nV_37  -8.621647e+05m  TC=0,0
L_V37  nV_37  NTMP0000000019  -6.475520e+04uH
R_V38  N_T0m  nV_38  -3.896465e+04m  TC=0,0
L_V38  nV_38  NTMP0000000019  -6.314238e+04uH
R_V39  N_T0m  nV_39  1.116730e+05m  TC=0,0
L_V39  nV_39  NTMP0000000019  6.274134e+05uH
* *  Node  N_T0m  to  Node  N_C0_105
R_R14  N_T0m  N_C0_105  2.518572e+08m  TC=0,0
R_V40  N_T0m  nV_40  4.811206e+04m  TC=0,0
L_V40  nV_40  N_C0_105  3.613586e+03uH
R_V41  N_T0m  nV_41  3.800793e+02m  TC=0,0
L_V41  nV_41  N_C0_105  6.159201e+02uH
R_V42  N_T0m  nV_42  -4.076168e+02m  TC=0,0
L_V42  nV_42  N_C0_105  -2.290116e+03uH
* *  Node  N_T0m  to  Node  NTMP0000000021
R_R15  N_T0m  NTMP0000000021  -1.226208e+08m  TC=0,0
R_V43  N_T0m  nV_43  -8.621647e+05m  TC=0,0
L_V43  nV_43  NTMP0000000021  -6.475520e+04uH
R_V44  N_T0m  nV_44  -3.896465e+04m  TC=0,0
L_V44  nV_44  NTMP0000000021  -6.314238e+04uH
R_V45  N_T0m  nV_45  1.116730e+05m  TC=0,0
L_V45  nV_45  NTMP0000000021  6.274134e+05uH
* *  Node  N_T0m  to  Node  N_C0_106
R_R16  N_T0m  N_C0_106  2.518572e+08m  TC=0,0
R_V46  N_T0m  nV_46  4.811206e+04m  TC=0,0
L_V46  nV_46  N_C0_106  3.613586e+03uH
R_V47  N_T0m  nV_47  3.800793e+02m  TC=0,0
L_V47  nV_47  N_C0_106  6.159201e+02uH
R_V48  N_T0m  nV_48  -4.076168e+02m  TC=0,0
L_V48  nV_48  N_C0_106  -2.290116e+03uH
* *  Node  N_T0m  to  Node  N_C0_107
R_R17  N_T0m  N_C0_107  1.036552e+08m  TC=0,0
R_V49  N_T0m  nV_49  -6.359700e+04m  TC=0,0
L_V49  nV_49  N_C0_107  -4.776624e+03uH
R_V50  N_T0m  nV_50  1.106496e+05m  TC=0,0
L_V50  nV_50  N_C0_107  1.793081e+05uH
R_V51  N_T0m  nV_51  1.147265e+05m  TC=0,0
L_V51  nV_51  N_C0_107  6.445688e+05uH
* *  Node  N_T0m  to  Node  N_C0_108
R_R18  N_T0m  N_C0_108  -9.972640e+07m  TC=0,0
R_V52  N_T0m  nV_52  -5.434840e+03m  TC=0,0
L_V52  nV_52  N_C0_108  -4.081983e+02uH
R_V53  N_T0m  nV_53  -2.216385e+02m  TC=0,0
L_V53  nV_53  N_C0_108  -3.591662e+02uH
R_V54  N_T0m  nV_54  2.002544e+02m  TC=0,0
L_V54  nV_54  N_C0_108  1.125091e+03uH
* *  Node  N_T0m  to  Node  N_C0_109
R_R19  N_T0m  N_C0_109  -6.658392e+08m  TC=0,0
R_V55  N_T0m  nV_55  5.451794e+04m  TC=0,0
L_V55  nV_55  N_C0_109  4.094716e+03uH
R_V56  N_T0m  nV_56  -7.229801e+04m  TC=0,0
L_V56  nV_56  N_C0_109  -1.171592e+05uH
R_V57  N_T0m  nV_57  6.047897e+05m  TC=0,0
L_V57  nV_57  N_C0_109  3.397895e+06uH
* *  Node  N_T0m  to  Node  N_C0_110
R_R20  N_T0m  N_C0_110  -6.658392e+08m  TC=0,0
R_V58  N_T0m  nV_58  5.451794e+04m  TC=0,0
L_V58  nV_58  N_C0_110  4.094716e+03uH
R_V59  N_T0m  nV_59  -7.229801e+04m  TC=0,0
L_V59  nV_59  N_C0_110  -1.171592e+05uH
R_V60  N_T0m  nV_60  6.047897e+05m  TC=0,0
L_V60  nV_60  N_C0_110  3.397895e+06uH
* *  Node  N_T0m  to  Node  NTMP0000000028
R_R21  N_T0m  NTMP0000000028  -1.313548e+08m  TC=0,0
R_V61  N_T0m  nV_61  1.084220e+05m  TC=0,0
L_V61  nV_61  NTMP0000000028  8.143327e+03uH
R_V62  N_T0m  nV_62  -3.139751e+05m  TC=0,0
L_V62  nV_62  NTMP0000000028  -5.087979e+05uH
R_V63  N_T0m  nV_63  -1.024711e+05m  TC=0,0
L_V63  nV_63  NTMP0000000028  -5.757139e+05uH
* *  Node  N_T0m  to  Node  N_C0_111
R_R22  N_T0m  N_C0_111  3.746663e+08m  TC=0,0
R_V64  N_T0m  nV_64  -1.962872e+05m  TC=0,0
L_V64  nV_64  N_C0_111  -1.474268e+04uH
R_V65  N_T0m  nV_65  7.839578e+04m  TC=0,0
L_V65  nV_65  N_C0_111  1.270407e+05uH
R_V66  N_T0m  nV_66  -7.957724e+04m  TC=0,0
L_V66  nV_66  N_C0_111  -4.470894e+05uH
* *  Node  N_T0m  to  Node  NTMP0000000030
R_R23  N_T0m  NTMP0000000030  -1.313548e+08m  TC=0,0
R_V67  N_T0m  nV_67  1.084220e+05m  TC=0,0
L_V67  nV_67  NTMP0000000030  8.143327e+03uH
R_V68  N_T0m  nV_68  -3.139751e+05m  TC=0,0
L_V68  nV_68  NTMP0000000030  -5.087979e+05uH
R_V69  N_T0m  nV_69  -1.024711e+05m  TC=0,0
L_V69  nV_69  NTMP0000000030  -5.757139e+05uH
* *  Node  N_T0m  to  Node  N_C0_112
R_R24  N_T0m  N_C0_112  3.746663e+08m  TC=0,0
R_V70  N_T0m  nV_70  -1.962872e+05m  TC=0,0
L_V70  nV_70  N_C0_112  -1.474268e+04uH
R_V71  N_T0m  nV_71  7.839578e+04m  TC=0,0
L_V71  nV_71  N_C0_112  1.270407e+05uH
R_V72  N_T0m  nV_72  -7.957724e+04m  TC=0,0
L_V72  nV_72  N_C0_112  -4.470894e+05uH
* *  Node  N_T0m  to  Node  N_BUS_2
R_R25  N_T0m  N_BUS_2  1.163803e+08m  TC=0,0
R_V73  N_T0m  nV_73  -6.834203e+04m  TC=0,0
L_V73  nV_73  N_BUS_2  -5.133012e+03uH
R_V74  N_T0m  nV_74  7.721870e+04m  TC=0,0
L_V74  nV_74  N_BUS_2  1.251332e+05uH
R_V75  N_T0m  nV_75  -3.139779e+05m  TC=0,0
L_V75  nV_75  N_BUS_2  -1.764024e+06uH
* *  Node  N_T0m  to  Node  N_C0_114
R_R26  N_T0m  N_C0_114  -2.526333e+07m  TC=0,0
R_V76  N_T0m  nV_76  -1.186997e+04m  TC=0,0
L_V76  nV_76  N_C0_114  -8.915262e+02uH
R_V77  N_T0m  nV_77  -6.855951e+01m  TC=0,0
L_V77  nV_77  N_C0_114  -1.111010e+02uH
R_V78  N_T0m  nV_78  7.098063e+01m  TC=0,0
L_V78  nV_78  N_C0_114  3.987910e+02uH
* *  Node  N_T0m  to  Node  N_C0_115
R_R27  N_T0m  N_C0_115  -2.814250e+07m  TC=0,0
R_V79  N_T0m  nV_79  -1.313614e+04m  TC=0,0
L_V79  nV_79  N_C0_115  -9.866247e+02uH
R_V80  N_T0m  nV_80  -6.795690e+01m  TC=0,0
L_V80  nV_80  N_C0_115  -1.101244e+02uH
R_V81  N_T0m  nV_81  7.022359e+01m  TC=0,0
L_V81  nV_81  N_C0_115  3.945377e+02uH
* *  Node  N_T0m  to  Node  N_C0_116
R_R28  N_T0m  N_C0_116  -2.526333e+07m  TC=0,0
R_V82  N_T0m  nV_82  -1.186997e+04m  TC=0,0
L_V82  nV_82  N_C0_116  -8.915262e+02uH
R_V83  N_T0m  nV_83  -6.855951e+01m  TC=0,0
L_V83  nV_83  N_C0_116  -1.111010e+02uH
R_V84  N_T0m  nV_84  7.098063e+01m  TC=0,0
L_V84  nV_84  N_C0_116  3.987910e+02uH
* *  Node  N_T0m  to  Node  N_C0_117
R_R29  N_T0m  N_C0_117  -2.814250e+07m  TC=0,0
R_V85  N_T0m  nV_85  -1.313614e+04m  TC=0,0
L_V85  nV_85  N_C0_117  -9.866247e+02uH
R_V86  N_T0m  nV_86  -6.795690e+01m  TC=0,0
L_V86  nV_86  N_C0_117  -1.101244e+02uH
R_V87  N_T0m  nV_87  7.022359e+01m  TC=0,0
L_V87  nV_87  N_C0_117  3.945377e+02uH
* *  Node  N_T0m  to  Node  N_C0_118
R_R30  N_T0m  N_C0_118  -4.650450e+07m  TC=0,0
R_V88  N_T0m  nV_88  -3.510682e+04m  TC=0,0
L_V88  nV_88  N_C0_118  -2.636792e+03uH
R_V89  N_T0m  nV_89  -1.831599e+02m  TC=0,0
L_V89  nV_89  N_C0_118  -2.968114e+02uH
R_V90  N_T0m  nV_90  1.942793e+02m  TC=0,0
L_V90  nV_90  N_C0_118  1.091521e+03uH
* *  Node  N_T0m  to  Node  N_C0_119
R_R31  N_T0m  N_C0_119  -4.650450e+07m  TC=0,0
R_V91  N_T0m  nV_91  -3.510682e+04m  TC=0,0
L_V91  nV_91  N_C0_119  -2.636792e+03uH
R_V92  N_T0m  nV_92  -1.831599e+02m  TC=0,0
L_V92  nV_92  N_C0_119  -2.968114e+02uH
R_V93  N_T0m  nV_93  1.942793e+02m  TC=0,0
L_V93  nV_93  N_C0_119  1.091521e+03uH
* *  Node  N_T0m  to  Node  N_C0_120
R_R32  N_T0m  N_C0_120  -1.014204e+08m  TC=0,0
R_V94  N_T0m  nV_94  -1.626842e+05m  TC=0,0
L_V94  nV_94  N_C0_120  -1.221883e+04uH
R_V95  N_T0m  nV_95  -3.786601e+02m  TC=0,0
L_V95  nV_95  N_C0_120  -6.136203e+02uH
R_V96  N_T0m  nV_96  4.022939e+02m  TC=0,0
L_V96  nV_96  N_C0_120  2.260211e+03uH
* *  Node  N_T0m  to  Node  N_C0_121
R_R33  N_T0m  N_C0_121  -1.014204e+08m  TC=0,0
R_V97  N_T0m  nV_97  -1.626842e+05m  TC=0,0
L_V97  nV_97  N_C0_121  -1.221883e+04uH
R_V98  N_T0m  nV_98  -3.786601e+02m  TC=0,0
L_V98  nV_98  N_C0_121  -6.136203e+02uH
R_V99  N_T0m  nV_99  4.022939e+02m  TC=0,0
L_V99  nV_99  N_C0_121  2.260211e+03uH
* *  Node  N_T0m  to  Node  N_BUS_GND
R_R34  N_T0m  N_BUS_GND  4.500434e+07m  TC=0,0
R_V100  N_T0m  nV_100  4.679259e+03m  TC=0,0
L_V100  nV_100  N_BUS_GND  3.514483e+02uH
R_V101  N_T0m  nV_101  2.242694e+02m  TC=0,0
L_V101  nV_101  N_BUS_GND  3.634296e+02uH
R_V102  N_T0m  nV_102  -2.020144e+02m  TC=0,0
L_V102  nV_102  N_BUS_GND  -1.134979e+03uH
*  Node  N_C0_93  to other nodes
* *  Node  N_C0_93  to  Node  N_C0_94
R_R35  N_C0_93  N_C0_94  6.946452e+05m  TC=0,0
R_V103  N_C0_93  nV_103  1.481920e+02m  TC=0,0
L_V103  nV_103  N_C0_94  1.113036e+01uH
R_V104  N_C0_93  nV_104  2.117355e+00m  TC=0,0
L_V104  nV_104  N_C0_94  3.431183e+00uH
R_V105  N_C0_93  nV_105  1.757113e+01m  TC=0,0
L_V105  nV_105  N_C0_94  9.872002e+01uH
* *  Node  N_C0_93  to  Node  N_C0_95
R_R36  N_C0_93  N_C0_95  6.292757e+05m  TC=0,0
R_V106  N_C0_93  nV_106  1.416494e+02m  TC=0,0
L_V106  nV_106  N_C0_95  1.063896e+01uH
R_V107  N_C0_93  nV_107  2.078042e+00m  TC=0,0
L_V107  nV_107  N_C0_95  3.367477e+00uH
R_V108  N_C0_93  nV_108  2.126808e+01m  TC=0,0
L_V108  nV_108  N_C0_95  1.194906e+02uH
* *  Node  N_C0_93  to  Node  N_C0_96
R_R37  N_C0_93  N_C0_96  6.946452e+05m  TC=0,0
R_V109  N_C0_93  nV_109  1.481920e+02m  TC=0,0
L_V109  nV_109  N_C0_96  1.113036e+01uH
R_V110  N_C0_93  nV_110  2.117355e+00m  TC=0,0
L_V110  nV_110  N_C0_96  3.431183e+00uH
R_V111  N_C0_93  nV_111  1.757113e+01m  TC=0,0
L_V111  nV_111  N_C0_96  9.872002e+01uH
* *  Node  N_C0_93  to  Node  N_C0_97
R_R38  N_C0_93  N_C0_97  7.012469e+05m  TC=0,0
R_V112  N_C0_93  nV_112  1.484865e+02m  TC=0,0
L_V112  nV_112  N_C0_97  1.115248e+01uH
R_V113  N_C0_93  nV_113  2.118056e+00m  TC=0,0
L_V113  nV_113  N_C0_97  3.432319e+00uH
R_V114  N_C0_93  nV_114  1.751318e+01m  TC=0,0
L_V114  nV_114  N_C0_97  9.839445e+01uH
* *  Node  N_C0_93  to  Node  N_C0_98
R_R39  N_C0_93  N_C0_98  -6.271330e+07m  TC=0,0
R_V115  N_C0_93  nV_115  -2.085622e+03m  TC=0,0
L_V115  nV_115  N_C0_98  -1.566463e+02uH
R_V116  N_C0_93  nV_116  -4.647813e+01m  TC=0,0
L_V116  nV_116  N_C0_98  -7.531802e+01uH
R_V117  N_C0_93  nV_117  4.565467e+01m  TC=0,0
L_V117  nV_117  N_C0_98  2.565020e+02uH
* *  Node  N_C0_93  to  Node  N_C0_99
R_R40  N_C0_93  N_C0_99  6.290177e+06m  TC=0,0
R_V118  N_C0_93  nV_118  -1.574206e+03m  TC=0,0
L_V118  nV_118  N_C0_99  -1.182350e+02uH
R_V119  N_C0_93  nV_119  -3.976070e+01m  TC=0,0
L_V119  nV_119  N_C0_99  -6.443239e+01uH
R_V120  N_C0_93  nV_120  3.849430e+01m  TC=0,0
L_V120  nV_120  N_C0_99  2.162728e+02uH
* *  Node  N_C0_93  to  Node  N_C0_100
R_R41  N_C0_93  N_C0_100  6.290177e+06m  TC=0,0
R_V121  N_C0_93  nV_121  -1.574206e+03m  TC=0,0
L_V121  nV_121  N_C0_100  -1.182350e+02uH
R_V122  N_C0_93  nV_122  -3.976070e+01m  TC=0,0
L_V122  nV_122  N_C0_100  -6.443239e+01uH
R_V123  N_C0_93  nV_123  3.849430e+01m  TC=0,0
L_V123  nV_123  N_C0_100  2.162728e+02uH
* *  Node  N_C0_93  to  Node  N_C0_101
R_R42  N_C0_93  N_C0_101  -6.271330e+07m  TC=0,0
R_V124  N_C0_93  nV_124  -2.085622e+03m  TC=0,0
L_V124  nV_124  N_C0_101  -1.566463e+02uH
R_V125  N_C0_93  nV_125  -4.647813e+01m  TC=0,0
L_V125  nV_125  N_C0_101  -7.531802e+01uH
R_V126  N_C0_93  nV_126  4.565467e+01m  TC=0,0
L_V126  nV_126  N_C0_101  2.565020e+02uH
* *  Node  N_C0_93  to  Node  N_C0_102
R_R43  N_C0_93  N_C0_102  -2.665973e+07m  TC=0,0
R_V127  N_C0_93  nV_127  -8.552720e+03m  TC=0,0
L_V127  nV_127  N_C0_102  -6.423750e+02uH
R_V128  N_C0_93  nV_128  -1.220675e+02m  TC=0,0
L_V128  nV_128  N_C0_102  -1.978110e+02uH
R_V129  N_C0_93  nV_129  1.229703e+02m  TC=0,0
L_V129  nV_129  N_C0_102  6.908850e+02uH
* *  Node  N_C0_93  to  Node  N_C0_103
R_R44  N_C0_93  N_C0_103  7.644680e+07m  TC=0,0
R_V130  N_C0_93  nV_130  -4.348721e+03m  TC=0,0
L_V130  nV_130  N_C0_103  -3.266224e+02uH
R_V131  N_C0_93  nV_131  -1.469412e+02m  TC=0,0
L_V131  nV_131  N_C0_103  -2.381189e+02uH
R_V132  N_C0_93  nV_132  1.329465e+02m  TC=0,0
L_V132  nV_132  N_C0_103  7.469343e+02uH
* *  Node  N_C0_93  to  Node  N_C0_104
R_R45  N_C0_93  N_C0_104  -2.665973e+07m  TC=0,0
R_V133  N_C0_93  nV_133  -8.552720e+03m  TC=0,0
L_V133  nV_133  N_C0_104  -6.423750e+02uH
R_V134  N_C0_93  nV_134  -1.220675e+02m  TC=0,0
L_V134  nV_134  N_C0_104  -1.978110e+02uH
R_V135  N_C0_93  nV_135  1.229703e+02m  TC=0,0
L_V135  nV_135  N_C0_104  6.908850e+02uH
* *  Node  N_C0_93  to  Node  NTMP0000000019
R_R46  N_C0_93  NTMP0000000019  5.136505e+07m  TC=0,0
R_V136  N_C0_93  nV_136  4.149575e+05m  TC=0,0
L_V136  nV_136  NTMP0000000019  3.116650e+04uH
R_V137  N_C0_93  nV_137  -5.352482e+03m  TC=0,0
L_V137  nV_137  NTMP0000000019  -8.673721e+03uH
R_V138  N_C0_93  nV_138  5.639508e+03m  TC=0,0
L_V138  nV_138  NTMP0000000019  3.168449e+04uH
* *  Node  N_C0_93  to  Node  N_C0_105
R_R47  N_C0_93  N_C0_105  2.409530e+08m  TC=0,0
R_V139  N_C0_93  nV_139  -3.633624e+04m  TC=0,0
L_V139  nV_139  N_C0_105  -2.729131e+03uH
R_V140  N_C0_93  nV_140  -3.590982e+02m  TC=0,0
L_V140  nV_140  N_C0_105  -5.819201e+02uH
R_V141  N_C0_93  nV_141  3.829750e+02m  TC=0,0
L_V141  nV_141  N_C0_105  2.151671e+03uH
* *  Node  N_C0_93  to  Node  NTMP0000000021
R_R48  N_C0_93  NTMP0000000021  5.136505e+07m  TC=0,0
R_V142  N_C0_93  nV_142  4.149575e+05m  TC=0,0
L_V142  nV_142  NTMP0000000021  3.116650e+04uH
R_V143  N_C0_93  nV_143  -5.352482e+03m  TC=0,0
L_V143  nV_143  NTMP0000000021  -8.673721e+03uH
R_V144  N_C0_93  nV_144  5.639508e+03m  TC=0,0
L_V144  nV_144  NTMP0000000021  3.168449e+04uH
* *  Node  N_C0_93  to  Node  N_C0_106
R_R49  N_C0_93  N_C0_106  2.409530e+08m  TC=0,0
R_V145  N_C0_93  nV_145  -3.633624e+04m  TC=0,0
L_V145  nV_145  N_C0_106  -2.729131e+03uH
R_V146  N_C0_93  nV_146  -3.590982e+02m  TC=0,0
L_V146  nV_146  N_C0_106  -5.819201e+02uH
R_V147  N_C0_93  nV_147  3.829750e+02m  TC=0,0
L_V147  nV_147  N_C0_106  2.151671e+03uH
* *  Node  N_C0_93  to  Node  N_C0_107
R_R50  N_C0_93  N_C0_107  -1.082352e+08m  TC=0,0
R_V148  N_C0_93  nV_148  -1.120335e+05m  TC=0,0
L_V148  nV_148  N_C0_107  -8.414579e+03uH
R_V149  N_C0_93  nV_149  -1.935926e+04m  TC=0,0
L_V149  nV_149  N_C0_107  -3.137176e+04uH
R_V150  N_C0_93  nV_150  2.465175e+04m  TC=0,0
L_V150  nV_150  N_C0_107  1.385011e+05uH
* *  Node  N_C0_93  to  Node  N_C0_108
R_R51  N_C0_93  N_C0_108  6.483369e+07m  TC=0,0
R_V151  N_C0_93  nV_151  4.288715e+03m  TC=0,0
L_V151  nV_151  N_C0_108  3.221154e+02uH
R_V152  N_C0_93  nV_152  2.462742e+02m  TC=0,0
L_V152  nV_152  N_C0_108  3.990883e+02uH
R_V153  N_C0_93  nV_153  -2.162525e+02m  TC=0,0
L_V153  nV_153  N_C0_108  -1.214973e+03uH
* *  Node  N_C0_93  to  Node  N_C0_109
R_R52  N_C0_93  N_C0_109  9.385324e+07m  TC=0,0
R_V154  N_C0_93  nV_154  9.172879e+04m  TC=0,0
L_V154  nV_154  N_C0_109  6.889537e+03uH
R_V155  N_C0_93  nV_155  8.564272e+03m  TC=0,0
L_V155  nV_155  N_C0_109  1.387844e+04uH
R_V156  N_C0_93  nV_156  -8.475292e+03m  TC=0,0
L_V156  nV_156  N_C0_109  -4.761680e+04uH
* *  Node  N_C0_93  to  Node  N_C0_110
R_R53  N_C0_93  N_C0_110  9.385324e+07m  TC=0,0
R_V157  N_C0_93  nV_157  9.172879e+04m  TC=0,0
L_V157  nV_157  N_C0_110  6.889537e+03uH
R_V158  N_C0_93  nV_158  8.564272e+03m  TC=0,0
L_V158  nV_158  N_C0_110  1.387844e+04uH
R_V159  N_C0_93  nV_159  -8.475292e+03m  TC=0,0
L_V159  nV_159  N_C0_110  -4.761680e+04uH
* *  Node  N_C0_93  to  Node  NTMP0000000028
R_R54  N_C0_93  NTMP0000000028  6.265526e+07m  TC=0,0
R_V160  N_C0_93  nV_160  1.708660e+05m  TC=0,0
L_V160  nV_160  NTMP0000000028  1.283335e+04uH
R_V161  N_C0_93  nV_161  -5.648614e+03m  TC=0,0
L_V161  nV_161  NTMP0000000028  -9.153603e+03uH
R_V162  N_C0_93  nV_162  5.211365e+03m  TC=0,0
L_V162  nV_162  NTMP0000000028  2.927905e+04uH
* *  Node  N_C0_93  to  Node  N_C0_111
R_R55  N_C0_93  N_C0_111  -1.033125e+09m  TC=0,0
R_V163  N_C0_93  nV_163  -2.459890e+05m  TC=0,0
L_V163  nV_163  N_C0_111  -1.847566e+04uH
R_V164  N_C0_93  nV_164  -6.038294e+03m  TC=0,0
L_V164  nV_164  N_C0_111  -9.785081e+03uH
R_V165  N_C0_93  nV_165  5.767199e+03m  TC=0,0
L_V165  nV_165  N_C0_111  3.240190e+04uH
* *  Node  N_C0_93  to  Node  NTMP0000000030
R_R56  N_C0_93  NTMP0000000030  6.265526e+07m  TC=0,0
R_V166  N_C0_93  nV_166  1.708660e+05m  TC=0,0
L_V166  nV_166  NTMP0000000030  1.283335e+04uH
R_V167  N_C0_93  nV_167  -5.648614e+03m  TC=0,0
L_V167  nV_167  NTMP0000000030  -9.153603e+03uH
R_V168  N_C0_93  nV_168  5.211365e+03m  TC=0,0
L_V168  nV_168  NTMP0000000030  2.927905e+04uH
* *  Node  N_C0_93  to  Node  N_C0_112
R_R57  N_C0_93  N_C0_112  -1.033125e+09m  TC=0,0
R_V169  N_C0_93  nV_169  -2.459890e+05m  TC=0,0
L_V169  nV_169  N_C0_112  -1.847566e+04uH
R_V170  N_C0_93  nV_170  -6.038294e+03m  TC=0,0
L_V170  nV_170  N_C0_112  -9.785081e+03uH
R_V171  N_C0_93  nV_171  5.767199e+03m  TC=0,0
L_V171  nV_171  N_C0_112  3.240190e+04uH
* *  Node  N_C0_93  to  Node  N_BUS_2
R_R58  N_C0_93  N_BUS_2  -1.113685e+08m  TC=0,0
R_V172  N_C0_93  nV_172  -8.087245e+04m  TC=0,0
L_V172  nV_172  N_BUS_2  -6.074143e+03uH
R_V173  N_C0_93  nV_173  5.066078e+03m  TC=0,0
L_V173  nV_173  N_BUS_2  8.209601e+03uH
R_V174  N_C0_93  nV_174  -5.111009e+03m  TC=0,0
L_V174  nV_174  N_BUS_2  -2.871522e+04uH
* *  Node  N_C0_93  to  Node  N_C0_114
R_R59  N_C0_93  N_C0_114  9.604820e+06m  TC=0,0
R_V175  N_C0_93  nV_175  4.559301e+03m  TC=0,0
L_V175  nV_175  N_C0_114  3.424386e+02uH
R_V176  N_C0_93  nV_176  6.874429e+01m  TC=0,0
L_V176  nV_176  N_C0_114  1.114004e+02uH
R_V177  N_C0_93  nV_177  -7.087771e+01m  TC=0,0
L_V177  nV_177  N_C0_114  -3.982128e+02uH
* *  Node  N_C0_93  to  Node  N_C0_115
R_R60  N_C0_93  N_C0_115  9.691081e+06m  TC=0,0
R_V178  N_C0_93  nV_178  4.323832e+03m  TC=0,0
L_V178  nV_178  N_C0_115  3.247530e+02uH
R_V179  N_C0_93  nV_179  6.811001e+01m  TC=0,0
L_V179  nV_179  N_C0_115  1.103726e+02uH
R_V180  N_C0_93  nV_180  -7.009216e+01m  TC=0,0
L_V180  nV_180  N_C0_115  -3.937993e+02uH
* *  Node  N_C0_93  to  Node  N_C0_116
R_R61  N_C0_93  N_C0_116  9.604820e+06m  TC=0,0
R_V181  N_C0_93  nV_181  4.559301e+03m  TC=0,0
L_V181  nV_181  N_C0_116  3.424386e+02uH
R_V182  N_C0_93  nV_182  6.874429e+01m  TC=0,0
L_V182  nV_182  N_C0_116  1.114004e+02uH
R_V183  N_C0_93  nV_183  -7.087771e+01m  TC=0,0
L_V183  nV_183  N_C0_116  -3.982128e+02uH
* *  Node  N_C0_93  to  Node  N_C0_117
R_R62  N_C0_93  N_C0_117  9.691081e+06m  TC=0,0
R_V184  N_C0_93  nV_184  4.323832e+03m  TC=0,0
L_V184  nV_184  N_C0_117  3.247530e+02uH
R_V185  N_C0_93  nV_185  6.811001e+01m  TC=0,0
L_V185  nV_185  N_C0_117  1.103726e+02uH
R_V186  N_C0_93  nV_186  -7.009216e+01m  TC=0,0
L_V186  nV_186  N_C0_117  -3.937993e+02uH
* *  Node  N_C0_93  to  Node  N_C0_118
R_R63  N_C0_93  N_C0_118  2.344964e+07m  TC=0,0
R_V187  N_C0_93  nV_187  1.337115e+04m  TC=0,0
L_V187  nV_187  N_C0_118  1.004276e+03uH
R_V188  N_C0_93  nV_188  1.841471e+02m  TC=0,0
L_V188  nV_188  N_C0_118  2.984112e+02uH
R_V189  N_C0_93  nV_189  -1.943830e+02m  TC=0,0
L_V189  nV_189  N_C0_118  -1.092104e+03uH
* *  Node  N_C0_93  to  Node  N_C0_119
R_R64  N_C0_93  N_C0_119  2.344964e+07m  TC=0,0
R_V190  N_C0_93  nV_190  1.337115e+04m  TC=0,0
L_V190  nV_190  N_C0_119  1.004276e+03uH
R_V191  N_C0_93  nV_191  1.841471e+02m  TC=0,0
L_V191  nV_191  N_C0_119  2.984112e+02uH
R_V192  N_C0_93  nV_192  -1.943830e+02m  TC=0,0
L_V192  nV_192  N_C0_119  -1.092104e+03uH
* *  Node  N_C0_93  to  Node  N_C0_120
R_R65  N_C0_93  N_C0_120  5.756694e+07m  TC=0,0
R_V193  N_C0_93  nV_193  2.409320e+04m  TC=0,0
L_V193  nV_193  N_C0_120  1.809585e+03uH
R_V194  N_C0_93  nV_194  3.801184e+02m  TC=0,0
L_V194  nV_194  N_C0_120  6.159835e+02uH
R_V195  N_C0_93  nV_195  -4.058092e+02m  TC=0,0
L_V195  nV_195  N_C0_120  -2.279961e+03uH
* *  Node  N_C0_93  to  Node  N_C0_121
R_R66  N_C0_93  N_C0_121  5.756694e+07m  TC=0,0
R_V196  N_C0_93  nV_196  2.409320e+04m  TC=0,0
L_V196  nV_196  N_C0_121  1.809585e+03uH
R_V197  N_C0_93  nV_197  3.801184e+02m  TC=0,0
L_V197  nV_197  N_C0_121  6.159835e+02uH
R_V198  N_C0_93  nV_198  -4.058092e+02m  TC=0,0
L_V198  nV_198  N_C0_121  -2.279961e+03uH
* *  Node  N_C0_93  to  Node  N_BUS_GND
R_R67  N_C0_93  N_BUS_GND  -5.085236e+07m  TC=0,0
R_V199  N_C0_93  nV_199  -5.379201e+03m  TC=0,0
L_V199  nV_199  N_BUS_GND  -4.040194e+02uH
R_V200  N_C0_93  nV_200  -2.216512e+02m  TC=0,0
L_V200  nV_200  N_BUS_GND  -3.591868e+02uH
R_V201  N_C0_93  nV_201  2.004637e+02m  TC=0,0
L_V201  nV_201  N_BUS_GND  1.126267e+03uH
*  Node  N_C0_94  to other nodes
* *  Node  N_C0_94  to  Node  N_C0_95
R_R68  N_C0_94  N_C0_95  5.554138e+06m  TC=0,0
R_V202  N_C0_94  nV_202  -2.950403e+03m  TC=0,0
L_V202  nV_202  N_C0_95  -2.215980e+02uH
R_V203  N_C0_94  nV_203  -1.491269e+02m  TC=0,0
L_V203  nV_203  N_C0_95  -2.416608e+02uH
R_V204  N_C0_94  nV_204  1.316811e+02m  TC=0,0
L_V204  nV_204  N_C0_95  7.398249e+02uH
* *  Node  N_C0_94  to  Node  N_C0_96
R_R69  N_C0_94  N_C0_96  -2.067336e+07m  TC=0,0
R_V205  N_C0_94  nV_205  -1.146148e+03m  TC=0,0
L_V205  nV_205  N_C0_96  -8.608456e+01uH
R_V206  N_C0_94  nV_206  -3.771596e+01m  TC=0,0
L_V206  nV_206  N_C0_96  -6.111888e+01uH
R_V207  N_C0_94  nV_207  3.426151e+01m  TC=0,0
L_V207  nV_207  N_C0_96  1.924917e+02uH
* *  Node  N_C0_94  to  Node  N_C0_97
R_R70  N_C0_94  N_C0_97  1.945098e+07m  TC=0,0
R_V208  N_C0_94  nV_208  -2.131134e+03m  TC=0,0
L_V208  nV_208  N_C0_97  -1.600646e+02uH
R_V209  N_C0_94  nV_209  -9.625436e+01m  TC=0,0
L_V209  nV_209  N_C0_97  -1.559806e+02uH
R_V210  N_C0_94  nV_210  8.571292e+01m  TC=0,0
L_V210  nV_210  N_C0_97  4.815616e+02uH
* *  Node  N_C0_94  to  Node  N_C0_98
R_R71  N_C0_94  N_C0_98  5.776352e+05m  TC=0,0
R_V211  N_C0_94  nV_211  1.414363e+02m  TC=0,0
L_V211  nV_211  N_C0_98  1.062296e+01uH
R_V212  N_C0_94  nV_212  2.066876e+00m  TC=0,0
L_V212  nV_212  N_C0_98  3.349381e+00uH
R_V213  N_C0_94  nV_213  2.256588e+01m  TC=0,0
L_V213  nV_213  N_C0_98  1.267821e+02uH
* *  Node  N_C0_94  to  Node  N_C0_99
R_R72  N_C0_94  N_C0_99  6.102750e+05m  TC=0,0
R_V214  N_C0_94  nV_214  1.449543e+02m  TC=0,0
L_V214  nV_214  N_C0_99  1.088719e+01uH
R_V215  N_C0_94  nV_215  2.079689e+00m  TC=0,0
L_V215  nV_215  N_C0_99  3.370145e+00uH
R_V216  N_C0_94  nV_216  2.094091e+01m  TC=0,0
L_V216  nV_216  N_C0_99  1.176525e+02uH
* *  Node  N_C0_94  to  Node  N_C0_100
R_R73  N_C0_94  N_C0_100  3.109799e+07m  TC=0,0
R_V217  N_C0_94  nV_217  -2.179878e+03m  TC=0,0
L_V217  nV_217  N_C0_100  -1.637256e+02uH
R_V218  N_C0_94  nV_218  -6.711893e+01m  TC=0,0
L_V218  nV_218  N_C0_100  -1.087665e+02uH
R_V219  N_C0_94  nV_219  6.138096e+01m  TC=0,0
L_V219  nV_219  N_C0_100  3.448571e+02uH
* *  Node  N_C0_94  to  Node  N_C0_101
R_R74  N_C0_94  N_C0_101  -2.337067e+06m  TC=0,0
R_V220  N_C0_94  nV_220  -3.111387e+03m  TC=0,0
L_V220  nV_220  N_C0_101  -2.336891e+02uH
R_V221  N_C0_94  nV_221  -9.237294e+01m  TC=0,0
L_V221  nV_221  N_C0_101  -1.496907e+02uH
R_V222  N_C0_94  nV_222  8.444346e+01m  TC=0,0
L_V222  nV_222  N_C0_101  4.744293e+02uH
* *  Node  N_C0_94  to  Node  N_C0_102
R_R75  N_C0_94  N_C0_102  1.686388e+07m  TC=0,0
R_V223  N_C0_94  nV_223  -8.339208e+04m  TC=0,0
L_V223  nV_223  N_C0_102  -6.263387e+03uH
R_V224  N_C0_94  nV_224  4.741928e+02m  TC=0,0
L_V224  nV_224  N_C0_102  7.684315e+02uH
R_V225  N_C0_94  nV_225  -4.831891e+02m  TC=0,0
L_V225  nV_225  N_C0_102  -2.714705e+03uH
* *  Node  N_C0_94  to  Node  N_C0_103
R_R76  N_C0_94  N_C0_103  2.916109e+07m  TC=0,0
R_V226  N_C0_94  nV_226  -1.228267e+04m  TC=0,0
L_V226  nV_226  N_C0_103  -9.225228e+02uH
R_V227  N_C0_94  nV_227  -3.624026e+02m  TC=0,0
L_V227  nV_227  N_C0_103  -5.872749e+02uH
R_V228  N_C0_94  nV_228  3.300836e+02m  TC=0,0
L_V228  nV_228  N_C0_103  1.854511e+03uH
* *  Node  N_C0_94  to  Node  N_C0_104
R_R77  N_C0_94  N_C0_104  -9.965584e+06m  TC=0,0
R_V229  N_C0_94  nV_229  -9.527052e+03m  TC=0,0
L_V229  nV_229  N_C0_104  -7.155548e+02uH
R_V230  N_C0_94  nV_230  -1.468687e+02m  TC=0,0
L_V230  nV_230  N_C0_104  -2.380014e+02uH
R_V231  N_C0_94  nV_231  1.387966e+02m  TC=0,0
L_V231  nV_231  N_C0_104  7.798022e+02uH
* *  Node  N_C0_94  to  Node  NTMP0000000019
R_R78  N_C0_94  NTMP0000000019  4.663714e+07m  TC=0,0
R_V232  N_C0_94  nV_232  -5.411751e+05m  TC=0,0
L_V232  nV_232  NTMP0000000019  -4.064641e+04uH
R_V233  N_C0_94  nV_233  -2.845647e+03m  TC=0,0
L_V233  nV_233  NTMP0000000019  -4.611383e+03uH
R_V234  N_C0_94  nV_234  2.736578e+03m  TC=0,0
L_V234  nV_234  NTMP0000000019  1.537494e+04uH
* *  Node  N_C0_94  to  Node  N_C0_105
R_R79  N_C0_94  N_C0_105  3.625864e+07m  TC=0,0
R_V235  N_C0_94  nV_235  4.747573e+04m  TC=0,0
L_V235  nV_235  N_C0_105  3.565792e+03uH
R_V236  N_C0_94  nV_236  7.189203e+02m  TC=0,0
L_V236  nV_236  N_C0_105  1.165013e+03uH
R_V237  N_C0_94  nV_237  -6.804217e+02m  TC=0,0
L_V237  nV_237  N_C0_105  -3.822818e+03uH
* *  Node  N_C0_94  to  Node  NTMP0000000021
R_R80  N_C0_94  NTMP0000000021  4.519926e+07m  TC=0,0
R_V238  N_C0_94  nV_238  2.219154e+05m  TC=0,0
L_V238  nV_238  NTMP0000000021  1.666755e+04uH
R_V239  N_C0_94  nV_239  -1.088767e+04m  TC=0,0
L_V239  nV_239  NTMP0000000021  -1.764352e+04uH
R_V240  N_C0_94  nV_240  1.243140e+04m  TC=0,0
L_V240  nV_240  NTMP0000000021  6.984343e+04uH
* *  Node  N_C0_94  to  Node  N_C0_106
R_R81  N_C0_94  N_C0_106  -1.865398e+08m  TC=0,0
R_V241  N_C0_94  nV_241  -4.166256e+04m  TC=0,0
L_V241  nV_241  N_C0_106  -3.129179e+03uH
R_V242  N_C0_94  nV_242  -6.010136e+02m  TC=0,0
L_V242  nV_242  N_C0_106  -9.739451e+02uH
R_V243  N_C0_94  nV_243  5.779586e+02m  TC=0,0
L_V243  nV_243  N_C0_106  3.247149e+03uH
* *  Node  N_C0_94  to  Node  N_C0_107
R_R82  N_C0_94  N_C0_107  -1.029606e+08m  TC=0,0
R_V244  N_C0_94  nV_244  -7.836859e+04m  TC=0,0
L_V244  nV_244  N_C0_107  -5.886084e+03uH
R_V245  N_C0_94  nV_245  -5.160493e+03m  TC=0,0
L_V245  nV_245  N_C0_107  -8.362601e+03uH
R_V246  N_C0_94  nV_246  5.080331e+03m  TC=0,0
L_V246  nV_246  N_C0_107  2.854286e+04uH
* *  Node  N_C0_94  to  Node  N_C0_108
R_R83  N_C0_94  N_C0_108  -6.171117e+07m  TC=0,0
R_V247  N_C0_94  nV_247  -9.176575e+04m  TC=0,0
L_V247  nV_247  N_C0_108  -6.892313e+03uH
R_V248  N_C0_94  nV_248  -8.146129e+02m  TC=0,0
L_V248  nV_248  N_C0_108  -1.320084e+03uH
R_V249  N_C0_94  nV_249  7.750516e+02m  TC=0,0
L_V249  nV_249  N_C0_108  4.354478e+03uH
* *  Node  N_C0_94  to  Node  N_C0_109
R_R84  N_C0_94  N_C0_109  -2.535554e+08m  TC=0,0
R_V250  N_C0_94  nV_250  1.197966e+04m  TC=0,0
L_V250  nV_250  N_C0_109  8.997642e+02uH
R_V251  N_C0_94  nV_251  2.518862e+02m  TC=0,0
L_V251  nV_251  N_C0_109  4.081826e+02uH
R_V252  N_C0_94  nV_252  -2.371819e+02m  TC=0,0
L_V252  nV_252  N_C0_109  -1.332561e+03uH
* *  Node  N_C0_94  to  Node  N_C0_110
R_R85  N_C0_94  N_C0_110  3.109960e+07m  TC=0,0
R_V253  N_C0_94  nV_253  -2.752754e+04m  TC=0,0
L_V253  nV_253  N_C0_110  -2.067530e+03uH
R_V254  N_C0_94  nV_254  -3.356099e+02m  TC=0,0
L_V254  nV_254  N_C0_110  -5.438573e+02uH
R_V255  N_C0_94  nV_255  3.190165e+02m  TC=0,0
L_V255  nV_255  N_C0_110  1.792333e+03uH
* *  Node  N_C0_94  to  Node  NTMP0000000028
R_R86  N_C0_94  NTMP0000000028  5.655863e+07m  TC=0,0
R_V256  N_C0_94  nV_256  7.422757e+05m  TC=0,0
L_V256  nV_256  NTMP0000000028  5.575061e+04uH
R_V257  N_C0_94  nV_257  -3.484904e+03m  TC=0,0
L_V257  nV_257  NTMP0000000028  -5.647301e+03uH
R_V258  N_C0_94  nV_258  3.186365e+03m  TC=0,0
L_V258  nV_258  NTMP0000000028  1.790198e+04uH
* *  Node  N_C0_94  to  Node  N_C0_111
R_R87  N_C0_94  N_C0_111  5.422810e+07m  TC=0,0
R_V259  N_C0_94  nV_259  4.681631e+04m  TC=0,0
L_V259  nV_259  N_C0_111  3.516265e+03uH
R_V260  N_C0_94  nV_260  6.562350e+02m  TC=0,0
L_V260  nV_260  N_C0_111  1.063432e+03uH
R_V261  N_C0_94  nV_261  -6.271809e+02m  TC=0,0
L_V261  nV_261  N_C0_111  -3.523695e+03uH
* *  Node  N_C0_94  to  Node  NTMP0000000030
R_R88  N_C0_94  NTMP0000000030  5.824701e+07m  TC=0,0
R_V262  N_C0_94  nV_262  1.707471e+05m  TC=0,0
L_V262  nV_262  NTMP0000000030  1.282442e+04uH
R_V263  N_C0_94  nV_263  -8.573442e+03m  TC=0,0
L_V263  nV_263  NTMP0000000030  -1.389330e+04uH
R_V264  N_C0_94  nV_264  7.886468e+03m  TC=0,0
L_V264  nV_264  NTMP0000000030  4.430860e+04uH
* *  Node  N_C0_94  to  Node  N_C0_112
R_R89  N_C0_94  N_C0_112  -5.099696e+07m  TC=0,0
R_V265  N_C0_94  nV_265  -3.333604e+04m  TC=0,0
L_V265  nV_265  N_C0_112  -2.503793e+03uH
R_V266  N_C0_94  nV_266  -5.430337e+02m  TC=0,0
L_V266  nV_266  N_C0_112  -8.799884e+02uH
R_V267  N_C0_94  nV_267  5.160842e+02m  TC=0,0
L_V267  nV_267  N_C0_112  2.899520e+03uH
* *  Node  N_C0_94  to  Node  N_BUS_2
R_R90  N_C0_94  N_BUS_2  -1.117267e+08m  TC=0,0
R_V268  N_C0_94  nV_268  -9.499737e+04m  TC=0,0
L_V268  nV_268  N_BUS_2  -7.135033e+03uH
R_V269  N_C0_94  nV_269  7.418622e+03m  TC=0,0
L_V269  nV_269  N_BUS_2  1.202191e+04uH
R_V270  N_C0_94  nV_270  -7.702981e+03m  TC=0,0
L_V270  nV_270  N_BUS_2  -4.327772e+04uH
* *  Node  N_C0_94  to  Node  N_C0_114
R_R91  N_C0_94  N_C0_114  1.137150e+07m  TC=0,0
R_V271  N_C0_94  nV_271  1.906727e+04m  TC=0,0
L_V271  nV_271  N_C0_114  1.432098e+03uH
R_V272  N_C0_94  nV_272  -5.287280e+04m  TC=0,0
L_V272  nV_272  N_C0_114  -8.568059e+04uH
R_V273  N_C0_94  nV_273  -6.544090e+04m  TC=0,0
L_V273  nV_273  N_C0_114  -3.676671e+05uH
* *  Node  N_C0_94  to  Node  N_C0_115
R_R92  N_C0_94  N_C0_115  1.116895e+07m  TC=0,0
R_V274  N_C0_94  nV_274  1.632983e+04m  TC=0,0
L_V274  nV_274  N_C0_115  1.226496e+03uH
R_V275  N_C0_94  nV_275  -6.186040e+04m  TC=0,0
L_V275  nV_275  N_C0_115  -1.002450e+05uH
R_V276  N_C0_94  nV_276  -4.076639e+04m  TC=0,0
L_V276  nV_276  N_C0_115  -2.290381e+05uH
* *  Node  N_C0_94  to  Node  N_C0_116
R_R93  N_C0_94  N_C0_116  1.609891e+07m  TC=0,0
R_V277  N_C0_94  nV_277  1.882078e+04m  TC=0,0
L_V277  nV_277  N_C0_116  1.413586e+03uH
R_V278  N_C0_94  nV_278  -4.998423e+04m  TC=0,0
L_V278  nV_278  N_C0_116  -8.099967e+04uH
R_V279  N_C0_94  nV_279  -6.870094e+04m  TC=0,0
L_V279  nV_279  N_C0_116  -3.859830e+05uH
* *  Node  N_C0_94  to  Node  N_C0_117
R_R94  N_C0_94  N_C0_117  1.728230e+07m  TC=0,0
R_V280  N_C0_94  nV_280  1.612442e+04m  TC=0,0
L_V280  nV_280  N_C0_117  1.211068e+03uH
R_V281  N_C0_94  nV_281  -5.745957e+04m  TC=0,0
L_V281  nV_281  N_C0_117  -9.311348e+04uH
R_V282  N_C0_94  nV_282  -4.217677e+04m  TC=0,0
L_V282  nV_282  N_C0_117  -2.369621e+05uH
* *  Node  N_C0_94  to  Node  N_C0_118
R_R95  N_C0_94  N_C0_118  2.728723e+07m  TC=0,0
R_V283  N_C0_94  nV_283  6.027222e+04m  TC=0,0
L_V283  nV_283  N_C0_118  4.526907e+03uH
R_V284  N_C0_94  nV_284  -7.020051e+04m  TC=0,0
L_V284  nV_284  N_C0_118  -1.137602e+05uH
R_V285  N_C0_94  nV_285  2.340810e+05m  TC=0,0
L_V285  nV_285  N_C0_118  1.315139e+06uH
* *  Node  N_C0_94  to  Node  N_C0_119
R_R96  N_C0_94  N_C0_119  2.718036e+07m  TC=0,0
R_V286  N_C0_94  nV_286  5.993552e+04m  TC=0,0
L_V286  nV_286  N_C0_119  4.501618e+03uH
R_V287  N_C0_94  nV_287  -6.945086e+04m  TC=0,0
L_V287  nV_287  N_C0_119  -1.125454e+05uH
R_V288  N_C0_94  nV_288  2.285255e+05m  TC=0,0
L_V288  nV_288  N_C0_119  1.283926e+06uH
* *  Node  N_C0_94  to  Node  N_C0_120
R_R97  N_C0_94  N_C0_120  8.197521e+07m  TC=0,0
R_V289  N_C0_94  nV_289  7.358610e+04m  TC=0,0
L_V289  nV_289  N_C0_120  5.526882e+03uH
R_V290  N_C0_94  nV_290  -1.989087e+05m  TC=0,0
L_V290  nV_290  N_C0_120  -3.223325e+05uH
R_V291  N_C0_94  nV_291  3.059386e+05m  TC=0,0
L_V291  nV_291  N_C0_120  1.718857e+06uH
* *  Node  N_C0_94  to  Node  N_C0_121
R_R98  N_C0_94  N_C0_121  6.417339e+07m  TC=0,0
R_V292  N_C0_94  nV_292  7.377125e+04m  TC=0,0
L_V292  nV_292  N_C0_121  5.540788e+03uH
R_V293  N_C0_94  nV_293  -2.009552e+05m  TC=0,0
L_V293  nV_293  N_C0_121  -3.256488e+05uH
R_V294  N_C0_94  nV_294  3.090515e+05m  TC=0,0
L_V294  nV_294  N_C0_121  1.736346e+06uH
* *  Node  N_C0_94  to  Node  N_BUS_GND
R_R99  N_C0_94  N_BUS_GND  1.460654e+08m  TC=0,0
R_V295  N_C0_94  nV_295  7.380449e+04m  TC=0,0
L_V295  nV_295  N_BUS_GND  5.543285e+03uH
R_V296  N_C0_94  nV_296  -4.836141e+04m  TC=0,0
L_V296  nV_296  N_BUS_GND  -7.836988e+04uH
R_V297  N_C0_94  nV_297  -2.667958e+05m  TC=0,0
L_V297  nV_297  N_BUS_GND  -1.498941e+06uH
*  Node  N_C0_95  to other nodes
* *  Node  N_C0_95  to  Node  N_C0_96
R_R100  N_C0_95  N_C0_96  5.554138e+06m  TC=0,0
R_V298  N_C0_95  nV_298  -2.950403e+03m  TC=0,0
L_V298  nV_298  N_C0_96  -2.215980e+02uH
R_V299  N_C0_95  nV_299  -1.491269e+02m  TC=0,0
L_V299  nV_299  N_C0_96  -2.416608e+02uH
R_V300  N_C0_95  nV_300  1.316811e+02m  TC=0,0
L_V300  nV_300  N_C0_96  7.398249e+02uH
* *  Node  N_C0_95  to  Node  N_C0_97
R_R101  N_C0_95  N_C0_97  1.361575e+07m  TC=0,0
R_V301  N_C0_95  nV_301  -1.336102e+03m  TC=0,0
L_V301  nV_301  N_C0_97  -1.003516e+02uH
R_V302  N_C0_95  nV_302  -4.974363e+01m  TC=0,0
L_V302  nV_302  N_C0_97  -8.060976e+01uH
R_V303  N_C0_95  nV_303  4.477738e+01m  TC=0,0
L_V303  nV_303  N_C0_97  2.515731e+02uH
* *  Node  N_C0_95  to  Node  N_C0_98
R_R102  N_C0_95  N_C0_98  4.143849e+05m  TC=0,0
R_V304  N_C0_95  nV_304  1.460711e+02m  TC=0,0
L_V304  nV_304  N_C0_98  1.097106e+01uH
R_V305  N_C0_95  nV_305  2.097580e+00m  TC=0,0
L_V305  nV_305  N_C0_98  3.399138e+00uH
R_V306  N_C0_95  nV_306  1.919695e+01m  TC=0,0
L_V306  nV_306  N_C0_98  1.078544e+02uH
* *  Node  N_C0_95  to  Node  N_C0_99
R_R103  N_C0_95  N_C0_99  -2.747786e+07m  TC=0,0
R_V307  N_C0_95  nV_307  -3.298676e+03m  TC=0,0
L_V307  nV_307  N_C0_99  -2.477559e+02uH
R_V308  N_C0_95  nV_308  -1.129348e+02m  TC=0,0
L_V308  nV_308  N_C0_99  -1.830114e+02uH
R_V309  N_C0_95  nV_309  1.022368e+02m  TC=0,0
L_V309  nV_309  N_C0_99  5.743979e+02uH
* *  Node  N_C0_95  to  Node  N_C0_100
R_R104  N_C0_95  N_C0_100  -2.747786e+07m  TC=0,0
R_V310  N_C0_95  nV_310  -3.298676e+03m  TC=0,0
L_V310  nV_310  N_C0_100  -2.477559e+02uH
R_V311  N_C0_95  nV_311  -1.129348e+02m  TC=0,0
L_V311  nV_311  N_C0_100  -1.830114e+02uH
R_V312  N_C0_95  nV_312  1.022368e+02m  TC=0,0
L_V312  nV_312  N_C0_100  5.743979e+02uH
* *  Node  N_C0_95  to  Node  N_C0_101
R_R105  N_C0_95  N_C0_101  4.143849e+05m  TC=0,0
R_V313  N_C0_95  nV_313  1.460711e+02m  TC=0,0
L_V313  nV_313  N_C0_101  1.097106e+01uH
R_V314  N_C0_95  nV_314  2.097580e+00m  TC=0,0
L_V314  nV_314  N_C0_101  3.399138e+00uH
R_V315  N_C0_95  nV_315  1.919695e+01m  TC=0,0
L_V315  nV_315  N_C0_101  1.078544e+02uH
* *  Node  N_C0_95  to  Node  N_C0_102
R_R106  N_C0_95  N_C0_102  6.287206e+06m  TC=0,0
R_V316  N_C0_95  nV_316  -6.648915e+03m  TC=0,0
L_V316  nV_316  N_C0_102  -4.993846e+02uH
R_V317  N_C0_95  nV_317  -2.159361e+02m  TC=0,0
L_V317  nV_317  N_C0_102  -3.499253e+02uH
R_V318  N_C0_95  nV_318  1.959954e+02m  TC=0,0
L_V318  nV_318  N_C0_102  1.101163e+03uH
* *  Node  N_C0_95  to  Node  N_C0_103
R_R107  N_C0_95  N_C0_103  1.234232e+06m  TC=0,0
R_V319  N_C0_95  nV_319  4.703057e+02m  TC=0,0
L_V319  nV_319  N_C0_103  3.532357e+01uH
R_V320  N_C0_95  nV_320  6.121350e+00m  TC=0,0
L_V320  nV_320  N_C0_103  9.919674e+00uH
R_V321  N_C0_95  nV_321  2.740773e+01m  TC=0,0
L_V321  nV_321  N_C0_103  1.539851e+02uH
* *  Node  N_C0_95  to  Node  N_C0_104
R_R108  N_C0_95  N_C0_104  6.287206e+06m  TC=0,0
R_V322  N_C0_95  nV_322  -6.648915e+03m  TC=0,0
L_V322  nV_322  N_C0_104  -4.993846e+02uH
R_V323  N_C0_95  nV_323  -2.159361e+02m  TC=0,0
L_V323  nV_323  N_C0_104  -3.499253e+02uH
R_V324  N_C0_95  nV_324  1.959954e+02m  TC=0,0
L_V324  nV_324  N_C0_104  1.101163e+03uH
* *  Node  N_C0_95  to  Node  NTMP0000000019
R_R109  N_C0_95  NTMP0000000019  -4.137409e+07m  TC=0,0
R_V325  N_C0_95  nV_325  -4.704103e+04m  TC=0,0
L_V325  nV_325  NTMP0000000019  -3.533143e+03uH
R_V326  N_C0_95  nV_326  -1.926971e+03m  TC=0,0
L_V326  nV_326  NTMP0000000019  -3.122665e+03uH
R_V327  N_C0_95  nV_327  1.836919e+03m  TC=0,0
L_V327  nV_327  NTMP0000000019  1.032037e+04uH
* *  Node  N_C0_95  to  Node  N_C0_105
R_R110  N_C0_95  N_C0_105  1.610866e+08m  TC=0,0
R_V328  N_C0_95  nV_328  -1.298791e+05m  TC=0,0
L_V328  nV_328  N_C0_105  -9.754916e+03uH
R_V329  N_C0_95  nV_329  -2.010634e+03m  TC=0,0
L_V329  nV_329  N_C0_105  -3.258241e+03uH
R_V330  N_C0_95  nV_330  2.003504e+03m  TC=0,0
L_V330  nV_330  N_C0_105  1.125630e+04uH
* *  Node  N_C0_95  to  Node  NTMP0000000021
R_R111  N_C0_95  NTMP0000000021  -4.137409e+07m  TC=0,0
R_V331  N_C0_95  nV_331  -4.704103e+04m  TC=0,0
L_V331  nV_331  NTMP0000000021  -3.533143e+03uH
R_V332  N_C0_95  nV_332  -1.926971e+03m  TC=0,0
L_V332  nV_332  NTMP0000000021  -3.122665e+03uH
R_V333  N_C0_95  nV_333  1.836919e+03m  TC=0,0
L_V333  nV_333  NTMP0000000021  1.032037e+04uH
* *  Node  N_C0_95  to  Node  N_C0_106
R_R112  N_C0_95  N_C0_106  1.610866e+08m  TC=0,0
R_V334  N_C0_95  nV_334  -1.298791e+05m  TC=0,0
L_V334  nV_334  N_C0_106  -9.754916e+03uH
R_V335  N_C0_95  nV_335  -2.010634e+03m  TC=0,0
L_V335  nV_335  N_C0_106  -3.258241e+03uH
R_V336  N_C0_95  nV_336  2.003504e+03m  TC=0,0
L_V336  nV_336  N_C0_106  1.125630e+04uH
* *  Node  N_C0_95  to  Node  N_C0_107
R_R113  N_C0_95  N_C0_107  1.857735e+07m  TC=0,0
R_V337  N_C0_95  nV_337  -1.162027e+05m  TC=0,0
L_V337  nV_337  N_C0_107  -8.727715e+03uH
R_V338  N_C0_95  nV_338  -2.273804e+03m  TC=0,0
L_V338  nV_338  N_C0_107  -3.684710e+03uH
R_V339  N_C0_95  nV_339  2.188396e+03m  TC=0,0
L_V339  nV_339  N_C0_107  1.229508e+04uH
* *  Node  N_C0_95  to  Node  N_C0_108
R_R114  N_C0_95  N_C0_108  1.335765e+07m  TC=0,0
R_V340  N_C0_95  nV_340  -2.298857e+03m  TC=0,0
L_V340  nV_340  N_C0_108  -1.726618e+02uH
R_V341  N_C0_95  nV_341  -7.787502e+01m  TC=0,0
L_V341  nV_341  N_C0_108  -1.261968e+02uH
R_V342  N_C0_95  nV_342  7.055231e+01m  TC=0,0
L_V342  nV_342  N_C0_108  3.963846e+02uH
* *  Node  N_C0_95  to  Node  N_C0_109
R_R115  N_C0_95  N_C0_109  3.614148e+07m  TC=0,0
R_V343  N_C0_95  nV_343  4.952783e+04m  TC=0,0
L_V343  nV_343  N_C0_109  3.719921e+03uH
R_V344  N_C0_95  nV_344  1.018449e+03m  TC=0,0
L_V344  nV_344  N_C0_109  1.650401e+03uH
R_V345  N_C0_95  nV_345  -9.731360e+02m  TC=0,0
L_V345  nV_345  N_C0_109  -5.467377e+03uH
* *  Node  N_C0_95  to  Node  N_C0_110
R_R116  N_C0_95  N_C0_110  3.614148e+07m  TC=0,0
R_V346  N_C0_95  nV_346  4.952783e+04m  TC=0,0
L_V346  nV_346  N_C0_110  3.719921e+03uH
R_V347  N_C0_95  nV_347  1.018449e+03m  TC=0,0
L_V347  nV_347  N_C0_110  1.650401e+03uH
R_V348  N_C0_95  nV_348  -9.731360e+02m  TC=0,0
L_V348  nV_348  N_C0_110  -5.467377e+03uH
* *  Node  N_C0_95  to  Node  NTMP0000000028
R_R117  N_C0_95  NTMP0000000028  -3.828177e+07m  TC=0,0
R_V349  N_C0_95  nV_349  -2.842920e+05m  TC=0,0
L_V349  nV_349  NTMP0000000028  -2.135252e+04uH
R_V350  N_C0_95  nV_350  -1.292497e+03m  TC=0,0
L_V350  nV_350  NTMP0000000028  -2.094497e+03uH
R_V351  N_C0_95  nV_351  1.210059e+03m  TC=0,0
L_V351  nV_351  NTMP0000000028  6.798484e+03uH
* *  Node  N_C0_95  to  Node  N_C0_111
R_R118  N_C0_95  N_C0_111  5.686443e+07m  TC=0,0
R_V352  N_C0_95  nV_352  2.951554e+05m  TC=0,0
L_V352  nV_352  N_C0_111  2.216844e+04uH
R_V353  N_C0_95  nV_353  -1.522459e+03m  TC=0,0
L_V353  nV_353  N_C0_111  -2.467152e+03uH
R_V354  N_C0_95  nV_354  1.498912e+03m  TC=0,0
L_V354  nV_354  N_C0_111  8.421347e+03uH
* *  Node  N_C0_95  to  Node  NTMP0000000030
R_R119  N_C0_95  NTMP0000000030  -3.828177e+07m  TC=0,0
R_V355  N_C0_95  nV_355  -2.842920e+05m  TC=0,0
L_V355  nV_355  NTMP0000000030  -2.135252e+04uH
R_V356  N_C0_95  nV_356  -1.292497e+03m  TC=0,0
L_V356  nV_356  NTMP0000000030  -2.094497e+03uH
R_V357  N_C0_95  nV_357  1.210059e+03m  TC=0,0
L_V357  nV_357  NTMP0000000030  6.798484e+03uH
* *  Node  N_C0_95  to  Node  N_C0_112
R_R120  N_C0_95  N_C0_112  5.686443e+07m  TC=0,0
R_V358  N_C0_95  nV_358  2.951554e+05m  TC=0,0
L_V358  nV_358  N_C0_112  2.216844e+04uH
R_V359  N_C0_95  nV_359  -1.522459e+03m  TC=0,0
L_V359  nV_359  N_C0_112  -2.467152e+03uH
R_V360  N_C0_95  nV_360  1.498912e+03m  TC=0,0
L_V360  nV_360  N_C0_112  8.421347e+03uH
* *  Node  N_C0_95  to  Node  N_BUS_2
R_R121  N_C0_95  N_BUS_2  1.994792e+07m  TC=0,0
R_V361  N_C0_95  nV_361  1.227854e+05m  TC=0,0
L_V361  nV_361  N_BUS_2  9.222131e+03uH
R_V362  N_C0_95  nV_362  1.631412e+03m  TC=0,0
L_V362  nV_362  N_BUS_2  2.643711e+03uH
R_V363  N_C0_95  nV_363  -1.547550e+03m  TC=0,0
L_V363  nV_363  N_BUS_2  -8.694611e+03uH
* *  Node  N_C0_95  to  Node  N_C0_114
R_R122  N_C0_95  N_C0_114  2.713267e+07m  TC=0,0
R_V364  N_C0_95  nV_364  2.249065e+04m  TC=0,0
L_V364  nV_364  N_C0_114  1.689221e+03uH
R_V365  N_C0_95  nV_365  -5.402688e+04m  TC=0,0
L_V365  nV_365  N_C0_114  -8.755078e+04uH
R_V366  N_C0_95  nV_366  -9.873919e+04m  TC=0,0
L_V366  nV_366  N_C0_114  -5.547472e+05uH
* *  Node  N_C0_95  to  Node  N_C0_115
R_R123  N_C0_95  N_C0_115  -2.406061e+08m  TC=0,0
R_V367  N_C0_95  nV_367  2.057532e+04m  TC=0,0
L_V367  nV_367  N_C0_115  1.545365e+03uH
R_V368  N_C0_95  nV_368  -5.373140e+04m  TC=0,0
L_V368  nV_368  N_C0_115  -8.707197e+04uH
R_V369  N_C0_95  nV_369  -1.288748e+05m  TC=0,0
L_V369  nV_369  N_C0_115  -7.240581e+05uH
* *  Node  N_C0_95  to  Node  N_C0_116
R_R124  N_C0_95  N_C0_116  2.713267e+07m  TC=0,0
R_V370  N_C0_95  nV_370  2.249065e+04m  TC=0,0
L_V370  nV_370  N_C0_116  1.689221e+03uH
R_V371  N_C0_95  nV_371  -5.402688e+04m  TC=0,0
L_V371  nV_371  N_C0_116  -8.755078e+04uH
R_V372  N_C0_95  nV_372  -9.873919e+04m  TC=0,0
L_V372  nV_372  N_C0_116  -5.547472e+05uH
* *  Node  N_C0_95  to  Node  N_C0_117
R_R125  N_C0_95  N_C0_117  -2.406061e+08m  TC=0,0
R_V373  N_C0_95  nV_373  2.057532e+04m  TC=0,0
L_V373  nV_373  N_C0_117  1.545365e+03uH
R_V374  N_C0_95  nV_374  -5.373140e+04m  TC=0,0
L_V374  nV_374  N_C0_117  -8.707197e+04uH
R_V375  N_C0_95  nV_375  -1.288748e+05m  TC=0,0
L_V375  nV_375  N_C0_117  -7.240581e+05uH
* *  Node  N_C0_95  to  Node  N_C0_118
R_R126  N_C0_95  N_C0_118  -6.309901e+07m  TC=0,0
R_V376  N_C0_95  nV_376  4.584167e+04m  TC=0,0
L_V376  nV_376  N_C0_118  3.443062e+03uH
R_V377  N_C0_95  nV_377  -7.445852e+04m  TC=0,0
L_V377  nV_377  N_C0_118  -1.206603e+05uH
R_V378  N_C0_95  nV_378  -2.354640e+05m  TC=0,0
L_V378  nV_378  N_C0_118  -1.322909e+06uH
* *  Node  N_C0_95  to  Node  N_C0_119
R_R127  N_C0_95  N_C0_119  -6.309901e+07m  TC=0,0
R_V379  N_C0_95  nV_379  4.584167e+04m  TC=0,0
L_V379  nV_379  N_C0_119  3.443062e+03uH
R_V380  N_C0_95  nV_380  -7.445852e+04m  TC=0,0
L_V380  nV_380  N_C0_119  -1.206603e+05uH
R_V381  N_C0_95  nV_381  -2.354640e+05m  TC=0,0
L_V381  nV_381  N_C0_119  -1.322909e+06uH
* *  Node  N_C0_95  to  Node  N_C0_120
R_R128  N_C0_95  N_C0_120  -6.885096e+07m  TC=0,0
R_V382  N_C0_95  nV_382  6.802138e+04m  TC=0,0
L_V382  nV_382  N_C0_120  5.108929e+03uH
R_V383  N_C0_95  nV_383  -1.277554e+05m  TC=0,0
L_V383  nV_383  N_C0_120  -2.070282e+05uH
R_V384  N_C0_95  nV_384  1.981274e+05m  TC=0,0
L_V384  nV_384  N_C0_120  1.113141e+06uH
* *  Node  N_C0_95  to  Node  N_C0_121
R_R129  N_C0_95  N_C0_121  -6.885096e+07m  TC=0,0
R_V385  N_C0_95  nV_385  6.802138e+04m  TC=0,0
L_V385  nV_385  N_C0_121  5.108929e+03uH
R_V386  N_C0_95  nV_386  -1.277554e+05m  TC=0,0
L_V386  nV_386  N_C0_121  -2.070282e+05uH
R_V387  N_C0_95  nV_387  1.981274e+05m  TC=0,0
L_V387  nV_387  N_C0_121  1.113141e+06uH
* *  Node  N_C0_95  to  Node  N_BUS_GND
R_R130  N_C0_95  N_BUS_GND  -6.727769e+07m  TC=0,0
R_V388  N_C0_95  nV_388  -1.233324e+06m  TC=0,0
L_V388  nV_388  N_BUS_GND  -9.263215e+04uH
R_V389  N_C0_95  nV_389  -4.311382e+05m  TC=0,0
L_V389  nV_389  N_BUS_GND  -6.986613e+05uH
R_V390  N_C0_95  nV_390  -8.552802e+05m  TC=0,0
L_V390  nV_390  N_BUS_GND  -4.805227e+06uH
*  Node  N_C0_96  to other nodes
* *  Node  N_C0_96  to  Node  N_C0_97
R_R131  N_C0_96  N_C0_97  1.945098e+07m  TC=0,0
R_V391  N_C0_96  nV_391  -2.131134e+03m  TC=0,0
L_V391  nV_391  N_C0_97  -1.600646e+02uH
R_V392  N_C0_96  nV_392  -9.625436e+01m  TC=0,0
L_V392  nV_392  N_C0_97  -1.559806e+02uH
R_V393  N_C0_96  nV_393  8.571292e+01m  TC=0,0
L_V393  nV_393  N_C0_97  4.815616e+02uH
* *  Node  N_C0_96  to  Node  N_C0_98
R_R132  N_C0_96  N_C0_98  -2.337067e+06m  TC=0,0
R_V394  N_C0_96  nV_394  -3.111387e+03m  TC=0,0
L_V394  nV_394  N_C0_98  -2.336891e+02uH
R_V395  N_C0_96  nV_395  -9.237294e+01m  TC=0,0
L_V395  nV_395  N_C0_98  -1.496907e+02uH
R_V396  N_C0_96  nV_396  8.444346e+01m  TC=0,0
L_V396  nV_396  N_C0_98  4.744293e+02uH
* *  Node  N_C0_96  to  Node  N_C0_99
R_R133  N_C0_96  N_C0_99  3.109799e+07m  TC=0,0
R_V397  N_C0_96  nV_397  -2.179878e+03m  TC=0,0
L_V397  nV_397  N_C0_99  -1.637256e+02uH
R_V398  N_C0_96  nV_398  -6.711893e+01m  TC=0,0
L_V398  nV_398  N_C0_99  -1.087665e+02uH
R_V399  N_C0_96  nV_399  6.138096e+01m  TC=0,0
L_V399  nV_399  N_C0_99  3.448571e+02uH
* *  Node  N_C0_96  to  Node  N_C0_100
R_R134  N_C0_96  N_C0_100  6.102750e+05m  TC=0,0
R_V400  N_C0_96  nV_400  1.449543e+02m  TC=0,0
L_V400  nV_400  N_C0_100  1.088719e+01uH
R_V401  N_C0_96  nV_401  2.079689e+00m  TC=0,0
L_V401  nV_401  N_C0_100  3.370145e+00uH
R_V402  N_C0_96  nV_402  2.094091e+01m  TC=0,0
L_V402  nV_402  N_C0_100  1.176525e+02uH
* *  Node  N_C0_96  to  Node  N_C0_101
R_R135  N_C0_96  N_C0_101  5.776352e+05m  TC=0,0
R_V403  N_C0_96  nV_403  1.414363e+02m  TC=0,0
L_V403  nV_403  N_C0_101  1.062296e+01uH
R_V404  N_C0_96  nV_404  2.066876e+00m  TC=0,0
L_V404  nV_404  N_C0_101  3.349381e+00uH
R_V405  N_C0_96  nV_405  2.256588e+01m  TC=0,0
L_V405  nV_405  N_C0_101  1.267821e+02uH
* *  Node  N_C0_96  to  Node  N_C0_102
R_R136  N_C0_96  N_C0_102  -9.965584e+06m  TC=0,0
R_V406  N_C0_96  nV_406  -9.527052e+03m  TC=0,0
L_V406  nV_406  N_C0_102  -7.155548e+02uH
R_V407  N_C0_96  nV_407  -1.468687e+02m  TC=0,0
L_V407  nV_407  N_C0_102  -2.380014e+02uH
R_V408  N_C0_96  nV_408  1.387966e+02m  TC=0,0
L_V408  nV_408  N_C0_102  7.798022e+02uH
* *  Node  N_C0_96  to  Node  N_C0_103
R_R137  N_C0_96  N_C0_103  2.916109e+07m  TC=0,0
R_V409  N_C0_96  nV_409  -1.228267e+04m  TC=0,0
L_V409  nV_409  N_C0_103  -9.225228e+02uH
R_V410  N_C0_96  nV_410  -3.624026e+02m  TC=0,0
L_V410  nV_410  N_C0_103  -5.872749e+02uH
R_V411  N_C0_96  nV_411  3.300836e+02m  TC=0,0
L_V411  nV_411  N_C0_103  1.854511e+03uH
* *  Node  N_C0_96  to  Node  N_C0_104
R_R138  N_C0_96  N_C0_104  1.686388e+07m  TC=0,0
R_V412  N_C0_96  nV_412  -8.339208e+04m  TC=0,0
L_V412  nV_412  N_C0_104  -6.263387e+03uH
R_V413  N_C0_96  nV_413  4.741928e+02m  TC=0,0
L_V413  nV_413  N_C0_104  7.684315e+02uH
R_V414  N_C0_96  nV_414  -4.831891e+02m  TC=0,0
L_V414  nV_414  N_C0_104  -2.714705e+03uH
* *  Node  N_C0_96  to  Node  NTMP0000000019
R_R139  N_C0_96  NTMP0000000019  4.519926e+07m  TC=0,0
R_V415  N_C0_96  nV_415  2.219154e+05m  TC=0,0
L_V415  nV_415  NTMP0000000019  1.666755e+04uH
R_V416  N_C0_96  nV_416  -1.088767e+04m  TC=0,0
L_V416  nV_416  NTMP0000000019  -1.764352e+04uH
R_V417  N_C0_96  nV_417  1.243140e+04m  TC=0,0
L_V417  nV_417  NTMP0000000019  6.984343e+04uH
* *  Node  N_C0_96  to  Node  N_C0_105
R_R140  N_C0_96  N_C0_105  -1.865398e+08m  TC=0,0
R_V418  N_C0_96  nV_418  -4.166256e+04m  TC=0,0
L_V418  nV_418  N_C0_105  -3.129179e+03uH
R_V419  N_C0_96  nV_419  -6.010136e+02m  TC=0,0
L_V419  nV_419  N_C0_105  -9.739451e+02uH
R_V420  N_C0_96  nV_420  5.779586e+02m  TC=0,0
L_V420  nV_420  N_C0_105  3.247149e+03uH
* *  Node  N_C0_96  to  Node  NTMP0000000021
R_R141  N_C0_96  NTMP0000000021  4.663714e+07m  TC=0,0
R_V421  N_C0_96  nV_421  -5.411751e+05m  TC=0,0
L_V421  nV_421  NTMP0000000021  -4.064641e+04uH
R_V422  N_C0_96  nV_422  -2.845647e+03m  TC=0,0
L_V422  nV_422  NTMP0000000021  -4.611383e+03uH
R_V423  N_C0_96  nV_423  2.736578e+03m  TC=0,0
L_V423  nV_423  NTMP0000000021  1.537494e+04uH
* *  Node  N_C0_96  to  Node  N_C0_106
R_R142  N_C0_96  N_C0_106  3.625864e+07m  TC=0,0
R_V424  N_C0_96  nV_424  4.747573e+04m  TC=0,0
L_V424  nV_424  N_C0_106  3.565792e+03uH
R_V425  N_C0_96  nV_425  7.189203e+02m  TC=0,0
L_V425  nV_425  N_C0_106  1.165013e+03uH
R_V426  N_C0_96  nV_426  -6.804217e+02m  TC=0,0
L_V426  nV_426  N_C0_106  -3.822818e+03uH
* *  Node  N_C0_96  to  Node  N_C0_107
R_R143  N_C0_96  N_C0_107  -1.029606e+08m  TC=0,0
R_V427  N_C0_96  nV_427  -7.836859e+04m  TC=0,0
L_V427  nV_427  N_C0_107  -5.886084e+03uH
R_V428  N_C0_96  nV_428  -5.160493e+03m  TC=0,0
L_V428  nV_428  N_C0_107  -8.362601e+03uH
R_V429  N_C0_96  nV_429  5.080331e+03m  TC=0,0
L_V429  nV_429  N_C0_107  2.854286e+04uH
* *  Node  N_C0_96  to  Node  N_C0_108
R_R144  N_C0_96  N_C0_108  -6.171117e+07m  TC=0,0
R_V430  N_C0_96  nV_430  -9.176575e+04m  TC=0,0
L_V430  nV_430  N_C0_108  -6.892313e+03uH
R_V431  N_C0_96  nV_431  -8.146129e+02m  TC=0,0
L_V431  nV_431  N_C0_108  -1.320084e+03uH
R_V432  N_C0_96  nV_432  7.750516e+02m  TC=0,0
L_V432  nV_432  N_C0_108  4.354478e+03uH
* *  Node  N_C0_96  to  Node  N_C0_109
R_R145  N_C0_96  N_C0_109  3.109960e+07m  TC=0,0
R_V433  N_C0_96  nV_433  -2.752754e+04m  TC=0,0
L_V433  nV_433  N_C0_109  -2.067530e+03uH
R_V434  N_C0_96  nV_434  -3.356099e+02m  TC=0,0
L_V434  nV_434  N_C0_109  -5.438573e+02uH
R_V435  N_C0_96  nV_435  3.190165e+02m  TC=0,0
L_V435  nV_435  N_C0_109  1.792333e+03uH
* *  Node  N_C0_96  to  Node  N_C0_110
R_R146  N_C0_96  N_C0_110  -2.535554e+08m  TC=0,0
R_V436  N_C0_96  nV_436  1.197966e+04m  TC=0,0
L_V436  nV_436  N_C0_110  8.997642e+02uH
R_V437  N_C0_96  nV_437  2.518862e+02m  TC=0,0
L_V437  nV_437  N_C0_110  4.081826e+02uH
R_V438  N_C0_96  nV_438  -2.371819e+02m  TC=0,0
L_V438  nV_438  N_C0_110  -1.332561e+03uH
* *  Node  N_C0_96  to  Node  NTMP0000000028
R_R147  N_C0_96  NTMP0000000028  5.824701e+07m  TC=0,0
R_V439  N_C0_96  nV_439  1.707471e+05m  TC=0,0
L_V439  nV_439  NTMP0000000028  1.282442e+04uH
R_V440  N_C0_96  nV_440  -8.573442e+03m  TC=0,0
L_V440  nV_440  NTMP0000000028  -1.389330e+04uH
R_V441  N_C0_96  nV_441  7.886468e+03m  TC=0,0
L_V441  nV_441  NTMP0000000028  4.430860e+04uH
* *  Node  N_C0_96  to  Node  N_C0_111
R_R148  N_C0_96  N_C0_111  -5.099696e+07m  TC=0,0
R_V442  N_C0_96  nV_442  -3.333604e+04m  TC=0,0
L_V442  nV_442  N_C0_111  -2.503793e+03uH
R_V443  N_C0_96  nV_443  -5.430337e+02m  TC=0,0
L_V443  nV_443  N_C0_111  -8.799884e+02uH
R_V444  N_C0_96  nV_444  5.160842e+02m  TC=0,0
L_V444  nV_444  N_C0_111  2.899520e+03uH
* *  Node  N_C0_96  to  Node  NTMP0000000030
R_R149  N_C0_96  NTMP0000000030  5.655863e+07m  TC=0,0
R_V445  N_C0_96  nV_445  7.422757e+05m  TC=0,0
L_V445  nV_445  NTMP0000000030  5.575061e+04uH
R_V446  N_C0_96  nV_446  -3.484904e+03m  TC=0,0
L_V446  nV_446  NTMP0000000030  -5.647301e+03uH
R_V447  N_C0_96  nV_447  3.186365e+03m  TC=0,0
L_V447  nV_447  NTMP0000000030  1.790198e+04uH
* *  Node  N_C0_96  to  Node  N_C0_112
R_R150  N_C0_96  N_C0_112  5.422810e+07m  TC=0,0
R_V448  N_C0_96  nV_448  4.681631e+04m  TC=0,0
L_V448  nV_448  N_C0_112  3.516265e+03uH
R_V449  N_C0_96  nV_449  6.562350e+02m  TC=0,0
L_V449  nV_449  N_C0_112  1.063432e+03uH
R_V450  N_C0_96  nV_450  -6.271809e+02m  TC=0,0
L_V450  nV_450  N_C0_112  -3.523695e+03uH
* *  Node  N_C0_96  to  Node  N_BUS_2
R_R151  N_C0_96  N_BUS_2  -1.117267e+08m  TC=0,0
R_V451  N_C0_96  nV_451  -9.499737e+04m  TC=0,0
L_V451  nV_451  N_BUS_2  -7.135033e+03uH
R_V452  N_C0_96  nV_452  7.418622e+03m  TC=0,0
L_V452  nV_452  N_BUS_2  1.202191e+04uH
R_V453  N_C0_96  nV_453  -7.702981e+03m  TC=0,0
L_V453  nV_453  N_BUS_2  -4.327772e+04uH
* *  Node  N_C0_96  to  Node  N_C0_114
R_R152  N_C0_96  N_C0_114  1.609891e+07m  TC=0,0
R_V454  N_C0_96  nV_454  1.882078e+04m  TC=0,0
L_V454  nV_454  N_C0_114  1.413586e+03uH
R_V455  N_C0_96  nV_455  -4.998423e+04m  TC=0,0
L_V455  nV_455  N_C0_114  -8.099967e+04uH
R_V456  N_C0_96  nV_456  -6.870094e+04m  TC=0,0
L_V456  nV_456  N_C0_114  -3.859830e+05uH
* *  Node  N_C0_96  to  Node  N_C0_115
R_R153  N_C0_96  N_C0_115  1.728230e+07m  TC=0,0
R_V457  N_C0_96  nV_457  1.612442e+04m  TC=0,0
L_V457  nV_457  N_C0_115  1.211068e+03uH
R_V458  N_C0_96  nV_458  -5.745957e+04m  TC=0,0
L_V458  nV_458  N_C0_115  -9.311348e+04uH
R_V459  N_C0_96  nV_459  -4.217677e+04m  TC=0,0
L_V459  nV_459  N_C0_115  -2.369621e+05uH
* *  Node  N_C0_96  to  Node  N_C0_116
R_R154  N_C0_96  N_C0_116  1.137150e+07m  TC=0,0
R_V460  N_C0_96  nV_460  1.906727e+04m  TC=0,0
L_V460  nV_460  N_C0_116  1.432098e+03uH
R_V461  N_C0_96  nV_461  -5.287280e+04m  TC=0,0
L_V461  nV_461  N_C0_116  -8.568059e+04uH
R_V462  N_C0_96  nV_462  -6.544090e+04m  TC=0,0
L_V462  nV_462  N_C0_116  -3.676671e+05uH
* *  Node  N_C0_96  to  Node  N_C0_117
R_R155  N_C0_96  N_C0_117  1.116895e+07m  TC=0,0
R_V463  N_C0_96  nV_463  1.632983e+04m  TC=0,0
L_V463  nV_463  N_C0_117  1.226496e+03uH
R_V464  N_C0_96  nV_464  -6.186040e+04m  TC=0,0
L_V464  nV_464  N_C0_117  -1.002450e+05uH
R_V465  N_C0_96  nV_465  -4.076639e+04m  TC=0,0
L_V465  nV_465  N_C0_117  -2.290381e+05uH
* *  Node  N_C0_96  to  Node  N_C0_118
R_R156  N_C0_96  N_C0_118  2.718036e+07m  TC=0,0
R_V466  N_C0_96  nV_466  5.993552e+04m  TC=0,0
L_V466  nV_466  N_C0_118  4.501618e+03uH
R_V467  N_C0_96  nV_467  -6.945086e+04m  TC=0,0
L_V467  nV_467  N_C0_118  -1.125454e+05uH
R_V468  N_C0_96  nV_468  2.285255e+05m  TC=0,0
L_V468  nV_468  N_C0_118  1.283926e+06uH
* *  Node  N_C0_96  to  Node  N_C0_119
R_R157  N_C0_96  N_C0_119  2.728723e+07m  TC=0,0
R_V469  N_C0_96  nV_469  6.027222e+04m  TC=0,0
L_V469  nV_469  N_C0_119  4.526907e+03uH
R_V470  N_C0_96  nV_470  -7.020051e+04m  TC=0,0
L_V470  nV_470  N_C0_119  -1.137602e+05uH
R_V471  N_C0_96  nV_471  2.340810e+05m  TC=0,0
L_V471  nV_471  N_C0_119  1.315139e+06uH
* *  Node  N_C0_96  to  Node  N_C0_120
R_R158  N_C0_96  N_C0_120  6.417339e+07m  TC=0,0
R_V472  N_C0_96  nV_472  7.377125e+04m  TC=0,0
L_V472  nV_472  N_C0_120  5.540788e+03uH
R_V473  N_C0_96  nV_473  -2.009552e+05m  TC=0,0
L_V473  nV_473  N_C0_120  -3.256488e+05uH
R_V474  N_C0_96  nV_474  3.090515e+05m  TC=0,0
L_V474  nV_474  N_C0_120  1.736346e+06uH
* *  Node  N_C0_96  to  Node  N_C0_121
R_R159  N_C0_96  N_C0_121  8.197521e+07m  TC=0,0
R_V475  N_C0_96  nV_475  7.358610e+04m  TC=0,0
L_V475  nV_475  N_C0_121  5.526882e+03uH
R_V476  N_C0_96  nV_476  -1.989087e+05m  TC=0,0
L_V476  nV_476  N_C0_121  -3.223325e+05uH
R_V477  N_C0_96  nV_477  3.059386e+05m  TC=0,0
L_V477  nV_477  N_C0_121  1.718857e+06uH
* *  Node  N_C0_96  to  Node  N_BUS_GND
R_R160  N_C0_96  N_BUS_GND  1.460654e+08m  TC=0,0
R_V478  N_C0_96  nV_478  7.380449e+04m  TC=0,0
L_V478  nV_478  N_BUS_GND  5.543285e+03uH
R_V479  N_C0_96  nV_479  -4.836141e+04m  TC=0,0
L_V479  nV_479  N_BUS_GND  -7.836988e+04uH
R_V480  N_C0_96  nV_480  -2.667958e+05m  TC=0,0
L_V480  nV_480  N_BUS_GND  -1.498941e+06uH
*  Node  N_C0_97  to other nodes
* *  Node  N_C0_97  to  Node  N_C0_98
R_R161  N_C0_97  N_C0_98  -3.061068e+06m  TC=0,0
R_V481  N_C0_97  nV_481  -3.330555e+03m  TC=0,0
L_V481  nV_481  N_C0_98  -2.501503e+02uH
R_V482  N_C0_97  nV_482  -1.038806e+02m  TC=0,0
L_V482  nV_482  N_C0_98  -1.683389e+02uH
R_V483  N_C0_97  nV_483  9.466846e+01m  TC=0,0
L_V483  nV_483  N_C0_98  5.318765e+02uH
* *  Node  N_C0_97  to  Node  N_C0_99
R_R162  N_C0_97  N_C0_99  6.027365e+05m  TC=0,0
R_V484  N_C0_97  nV_484  1.453689e+02m  TC=0,0
L_V484  nV_484  N_C0_99  1.091832e+01uH
R_V485  N_C0_97  nV_485  2.079751e+00m  TC=0,0
L_V485  nV_485  N_C0_99  3.370245e+00uH
R_V486  N_C0_97  nV_486  2.092013e+01m  TC=0,0
L_V486  nV_486  N_C0_99  1.175357e+02uH
* *  Node  N_C0_97  to  Node  N_C0_100
R_R163  N_C0_97  N_C0_100  6.027365e+05m  TC=0,0
R_V487  N_C0_97  nV_487  1.453689e+02m  TC=0,0
L_V487  nV_487  N_C0_100  1.091832e+01uH
R_V488  N_C0_97  nV_488  2.079751e+00m  TC=0,0
L_V488  nV_488  N_C0_100  3.370245e+00uH
R_V489  N_C0_97  nV_489  2.092013e+01m  TC=0,0
L_V489  nV_489  N_C0_100  1.175357e+02uH
* *  Node  N_C0_97  to  Node  N_C0_101
R_R164  N_C0_97  N_C0_101  -3.061068e+06m  TC=0,0
R_V490  N_C0_97  nV_490  -3.330555e+03m  TC=0,0
L_V490  nV_490  N_C0_101  -2.501503e+02uH
R_V491  N_C0_97  nV_491  -1.038806e+02m  TC=0,0
L_V491  nV_491  N_C0_101  -1.683389e+02uH
R_V492  N_C0_97  nV_492  9.466846e+01m  TC=0,0
L_V492  nV_492  N_C0_101  5.318765e+02uH
* *  Node  N_C0_97  to  Node  N_C0_102
R_R165  N_C0_97  N_C0_102  -1.649124e+07m  TC=0,0
R_V493  N_C0_97  nV_493  -3.692208e+04m  TC=0,0
L_V493  nV_493  N_C0_102  -2.773132e+03uH
R_V494  N_C0_97  nV_494  -4.111180e+02m  TC=0,0
L_V494  nV_494  N_C0_102  -6.662184e+02uH
R_V495  N_C0_97  nV_495  3.871945e+02m  TC=0,0
L_V495  nV_495  N_C0_102  2.175378e+03uH
* *  Node  N_C0_97  to  Node  N_C0_103
R_R166  N_C0_97  N_C0_103  3.454843e+07m  TC=0,0
R_V496  N_C0_97  nV_496  -9.677527e+04m  TC=0,0
L_V496  nV_496  N_C0_103  -7.268567e+03uH
R_V497  N_C0_97  nV_497  -4.402575e+02m  TC=0,0
L_V497  nV_497  N_C0_103  -7.134392e+02uH
R_V498  N_C0_97  nV_498  4.227590e+02m  TC=0,0
L_V498  nV_498  N_C0_103  2.375190e+03uH
* *  Node  N_C0_97  to  Node  N_C0_104
R_R167  N_C0_97  N_C0_104  -1.649124e+07m  TC=0,0
R_V499  N_C0_97  nV_499  -3.692208e+04m  TC=0,0
L_V499  nV_499  N_C0_104  -2.773132e+03uH
R_V500  N_C0_97  nV_500  -4.111180e+02m  TC=0,0
L_V500  nV_500  N_C0_104  -6.662184e+02uH
R_V501  N_C0_97  nV_501  3.871945e+02m  TC=0,0
L_V501  nV_501  N_C0_104  2.175378e+03uH
* *  Node  N_C0_97  to  Node  NTMP0000000019
R_R168  N_C0_97  NTMP0000000019  3.041071e+07m  TC=0,0
R_V502  N_C0_97  nV_502  7.995121e+04m  TC=0,0
L_V502  nV_502  NTMP0000000019  6.004951e+03uH
R_V503  N_C0_97  nV_503  -1.380850e+03m  TC=0,0
L_V503  nV_503  NTMP0000000019  -2.237674e+03uH
R_V504  N_C0_97  nV_504  1.362349e+03m  TC=0,0
L_V504  nV_504  NTMP0000000019  7.654098e+03uH
* *  Node  N_C0_97  to  Node  N_C0_105
R_R169  N_C0_97  N_C0_105  9.591903e+07m  TC=0,0
R_V505  N_C0_97  nV_505  -5.431973e+04m  TC=0,0
L_V505  nV_505  N_C0_105  -4.079829e+03uH
R_V506  N_C0_97  nV_506  -6.382602e+02m  TC=0,0
L_V506  nV_506  N_C0_105  -1.034303e+03uH
R_V507  N_C0_97  nV_507  6.172074e+02m  TC=0,0
L_V507  nV_507  N_C0_105  3.467661e+03uH
* *  Node  N_C0_97  to  Node  NTMP0000000021
R_R170  N_C0_97  NTMP0000000021  3.041071e+07m  TC=0,0
R_V508  N_C0_97  nV_508  7.995121e+04m  TC=0,0
L_V508  nV_508  NTMP0000000021  6.004951e+03uH
R_V509  N_C0_97  nV_509  -1.380850e+03m  TC=0,0
L_V509  nV_509  NTMP0000000021  -2.237674e+03uH
R_V510  N_C0_97  nV_510  1.362349e+03m  TC=0,0
L_V510  nV_510  NTMP0000000021  7.654098e+03uH
* *  Node  N_C0_97  to  Node  N_C0_106
R_R171  N_C0_97  N_C0_106  9.591903e+07m  TC=0,0
R_V511  N_C0_97  nV_511  -5.431973e+04m  TC=0,0
L_V511  nV_511  N_C0_106  -4.079829e+03uH
R_V512  N_C0_97  nV_512  -6.382602e+02m  TC=0,0
L_V512  nV_512  N_C0_106  -1.034303e+03uH
R_V513  N_C0_97  nV_513  6.172074e+02m  TC=0,0
L_V513  nV_513  N_C0_106  3.467661e+03uH
* *  Node  N_C0_97  to  Node  N_C0_107
R_R172  N_C0_97  N_C0_107  -3.519615e+07m  TC=0,0
R_V514  N_C0_97  nV_514  -2.114050e+04m  TC=0,0
L_V514  nV_514  N_C0_107  -1.587814e+03uH
R_V515  N_C0_97  nV_515  -6.079637e+02m  TC=0,0
L_V515  nV_515  N_C0_107  -9.852078e+02uH
R_V516  N_C0_97  nV_516  5.687317e+02m  TC=0,0
L_V516  nV_516  N_C0_107  3.195310e+03uH
* *  Node  N_C0_97  to  Node  N_C0_108
R_R173  N_C0_97  N_C0_108  -2.072972e+07m  TC=0,0
R_V517  N_C0_97  nV_517  -3.062081e+04m  TC=0,0
L_V517  nV_517  N_C0_108  -2.299859e+03uH
R_V518  N_C0_97  nV_518  -3.027590e+02m  TC=0,0
L_V518  nV_518  N_C0_108  -4.906223e+02uH
R_V519  N_C0_97  nV_519  2.892431e+02m  TC=0,0
L_V519  nV_519  N_C0_108  1.625057e+03uH
* *  Node  N_C0_97  to  Node  N_C0_109
R_R174  N_C0_97  N_C0_109  5.807007e+07m  TC=0,0
R_V520  N_C0_97  nV_520  2.240515e+04m  TC=0,0
L_V520  nV_520  N_C0_109  1.682799e+03uH
R_V521  N_C0_97  nV_521  4.732019e+02m  TC=0,0
L_V521  nV_521  N_C0_109  7.668257e+02uH
R_V522  N_C0_97  nV_522  -4.510113e+02m  TC=0,0
L_V522  nV_522  N_C0_109  -2.533920e+03uH
* *  Node  N_C0_97  to  Node  N_C0_110
R_R175  N_C0_97  N_C0_110  5.807007e+07m  TC=0,0
R_V523  N_C0_97  nV_523  2.240515e+04m  TC=0,0
L_V523  nV_523  N_C0_110  1.682799e+03uH
R_V524  N_C0_97  nV_524  4.732019e+02m  TC=0,0
L_V524  nV_524  N_C0_110  7.668257e+02uH
R_V525  N_C0_97  nV_525  -4.510113e+02m  TC=0,0
L_V525  nV_525  N_C0_110  -2.533920e+03uH
* *  Node  N_C0_97  to  Node  NTMP0000000028
R_R176  N_C0_97  NTMP0000000028  3.563948e+07m  TC=0,0
R_V526  N_C0_97  nV_526  -1.355818e+05m  TC=0,0
L_V526  nV_526  NTMP0000000028  -1.018323e+04uH
R_V527  N_C0_97  nV_527  -1.744003e+03m  TC=0,0
L_V527  nV_527  NTMP0000000028  -2.826164e+03uH
R_V528  N_C0_97  nV_528  1.622565e+03m  TC=0,0
L_V528  nV_528  NTMP0000000028  9.116069e+03uH
* *  Node  N_C0_97  to  Node  N_C0_111
R_R177  N_C0_97  N_C0_111  -1.297709e+08m  TC=0,0
R_V529  N_C0_97  nV_529  -2.660203e+04m  TC=0,0
L_V529  nV_529  N_C0_111  -1.998017e+03uH
R_V530  N_C0_97  nV_530  -6.098521e+02m  TC=0,0
L_V530  nV_530  N_C0_111  -9.882679e+02uH
R_V531  N_C0_97  nV_531  5.802141e+02m  TC=0,0
L_V531  nV_531  N_C0_111  3.259821e+03uH
* *  Node  N_C0_97  to  Node  NTMP0000000030
R_R178  N_C0_97  NTMP0000000030  3.563948e+07m  TC=0,0
R_V532  N_C0_97  nV_532  -1.355818e+05m  TC=0,0
L_V532  nV_532  NTMP0000000030  -1.018323e+04uH
R_V533  N_C0_97  nV_533  -1.744003e+03m  TC=0,0
L_V533  nV_533  NTMP0000000030  -2.826164e+03uH
R_V534  N_C0_97  nV_534  1.622565e+03m  TC=0,0
L_V534  nV_534  NTMP0000000030  9.116069e+03uH
* *  Node  N_C0_97  to  Node  N_C0_112
R_R179  N_C0_97  N_C0_112  -1.297709e+08m  TC=0,0
R_V535  N_C0_97  nV_535  -2.660203e+04m  TC=0,0
L_V535  nV_535  N_C0_112  -1.998017e+03uH
R_V536  N_C0_97  nV_536  -6.098521e+02m  TC=0,0
L_V536  nV_536  N_C0_112  -9.882679e+02uH
R_V537  N_C0_97  nV_537  5.802141e+02m  TC=0,0
L_V537  nV_537  N_C0_112  3.259821e+03uH
* *  Node  N_C0_97  to  Node  N_BUS_2
R_R180  N_C0_97  N_BUS_2  -5.664507e+07m  TC=0,0
R_V538  N_C0_97  nV_538  5.734803e+04m  TC=0,0
L_V538  nV_538  N_BUS_2  4.307278e+03uH
R_V539  N_C0_97  nV_539  5.674454e+02m  TC=0,0
L_V539  nV_539  N_BUS_2  9.195477e+02uH
R_V540  N_C0_97  nV_540  -5.375290e+02m  TC=0,0
L_V540  nV_540  N_BUS_2  -3.020003e+03uH
* *  Node  N_C0_97  to  Node  N_C0_114
R_R181  N_C0_97  N_C0_114  1.189561e+07m  TC=0,0
R_V541  N_C0_97  nV_541  1.684125e+04m  TC=0,0
L_V541  nV_541  N_C0_114  1.264907e+03uH
R_V542  N_C0_97  nV_542  -4.949458e+04m  TC=0,0
L_V542  nV_542  N_C0_114  -8.020618e+04uH
R_V543  N_C0_97  nV_543  -8.154450e+04m  TC=0,0
L_V543  nV_543  N_C0_114  -4.581421e+05uH
* *  Node  N_C0_97  to  Node  N_C0_115
R_R182  N_C0_97  N_C0_115  8.846953e+06m  TC=0,0
R_V544  N_C0_97  nV_544  1.400641e+04m  TC=0,0
L_V544  nV_544  N_C0_115  1.051989e+03uH
R_V545  N_C0_97  nV_545  -6.315404e+04m  TC=0,0
L_V545  nV_545  N_C0_115  -1.023414e+05uH
R_V546  N_C0_97  nV_546  -3.821803e+04m  TC=0,0
L_V546  nV_546  N_C0_115  -2.147206e+05uH
* *  Node  N_C0_97  to  Node  N_C0_116
R_R183  N_C0_97  N_C0_116  1.189561e+07m  TC=0,0
R_V547  N_C0_97  nV_547  1.684125e+04m  TC=0,0
L_V547  nV_547  N_C0_116  1.264907e+03uH
R_V548  N_C0_97  nV_548  -4.949458e+04m  TC=0,0
L_V548  nV_548  N_C0_116  -8.020618e+04uH
R_V549  N_C0_97  nV_549  -8.154450e+04m  TC=0,0
L_V549  nV_549  N_C0_116  -4.581421e+05uH
* *  Node  N_C0_97  to  Node  N_C0_117
R_R184  N_C0_97  N_C0_117  8.846953e+06m  TC=0,0
R_V550  N_C0_97  nV_550  1.400641e+04m  TC=0,0
L_V550  nV_550  N_C0_117  1.051989e+03uH
R_V551  N_C0_97  nV_551  -6.315404e+04m  TC=0,0
L_V551  nV_551  N_C0_117  -1.023414e+05uH
R_V552  N_C0_97  nV_552  -3.821803e+04m  TC=0,0
L_V552  nV_552  N_C0_117  -2.147206e+05uH
* *  Node  N_C0_97  to  Node  N_C0_118
R_R185  N_C0_97  N_C0_118  1.954792e+07m  TC=0,0
R_V553  N_C0_97  nV_553  7.451446e+04m  TC=0,0
L_V553  nV_553  N_C0_118  5.596609e+03uH
R_V554  N_C0_97  nV_554  -6.691818e+04m  TC=0,0
L_V554  nV_554  N_C0_118  -1.084412e+05uH
R_V555  N_C0_97  nV_555  1.072547e+05m  TC=0,0
L_V555  nV_555  N_C0_118  6.025900e+05uH
* *  Node  N_C0_97  to  Node  N_C0_119
R_R186  N_C0_97  N_C0_119  1.954792e+07m  TC=0,0
R_V556  N_C0_97  nV_556  7.451446e+04m  TC=0,0
L_V556  nV_556  N_C0_119  5.596609e+03uH
R_V557  N_C0_97  nV_557  -6.691818e+04m  TC=0,0
L_V557  nV_557  N_C0_119  -1.084412e+05uH
R_V558  N_C0_97  nV_558  1.072547e+05m  TC=0,0
L_V558  nV_558  N_C0_119  6.025900e+05uH
* *  Node  N_C0_97  to  Node  N_C0_120
R_R187  N_C0_97  N_C0_120  4.610155e+07m  TC=0,0
R_V559  N_C0_97  nV_559  8.145686e+04m  TC=0,0
L_V559  nV_559  N_C0_120  6.118037e+03uH
R_V560  N_C0_97  nV_560  -2.851159e+05m  TC=0,0
L_V560  nV_560  N_C0_120  -4.620316e+05uH
R_V561  N_C0_97  nV_561  -1.508882e+06m  TC=0,0
L_V561  nV_561  N_C0_120  -8.477364e+06uH
* *  Node  N_C0_97  to  Node  N_C0_121
R_R188  N_C0_97  N_C0_121  4.610155e+07m  TC=0,0
R_V562  N_C0_97  nV_562  8.145686e+04m  TC=0,0
L_V562  nV_562  N_C0_121  6.118037e+03uH
R_V563  N_C0_97  nV_563  -2.851159e+05m  TC=0,0
L_V563  nV_563  N_C0_121  -4.620316e+05uH
R_V564  N_C0_97  nV_564  -1.508882e+06m  TC=0,0
L_V564  nV_564  N_C0_121  -8.477364e+06uH
* *  Node  N_C0_97  to  Node  N_BUS_GND
R_R189  N_C0_97  N_BUS_GND  7.882155e+07m  TC=0,0
R_V565  N_C0_97  nV_565  4.372804e+04m  TC=0,0
L_V565  nV_565  N_BUS_GND  3.284312e+03uH
R_V566  N_C0_97  nV_566  -2.645666e+04m  TC=0,0
L_V566  nV_566  N_BUS_GND  -4.287313e+04uH
R_V567  N_C0_97  nV_567  -2.230058e+05m  TC=0,0
L_V567  nV_567  N_BUS_GND  -1.252915e+06uH
*  Node  N_C0_98  to other nodes
* *  Node  N_C0_98  to  Node  N_C0_99
R_R190  N_C0_98  N_C0_99  2.914002e+06m  TC=0,0
R_V568  N_C0_98  nV_568  -1.209864e+03m  TC=0,0
L_V568  nV_568  N_C0_99  -9.087005e+01uH
R_V569  N_C0_98  nV_569  -2.078823e+03m  TC=0,0
L_V569  nV_569  N_C0_99  -3.368742e+03uH
R_V570  N_C0_98  nV_570  1.114701e+02m  TC=0,0
L_V570  nV_570  N_C0_99  6.262731e+02uH
* *  Node  N_C0_98  to  Node  N_C0_100
R_R191  N_C0_98  N_C0_100  2.069706e+06m  TC=0,0
R_V571  N_C0_98  nV_571  -2.572341e+03m  TC=0,0
L_V571  nV_571  N_C0_100  -1.932026e+02uH
R_V572  N_C0_98  nV_572  1.003252e+03m  TC=0,0
L_V572  nV_572  N_C0_100  1.625774e+03uH
R_V573  N_C0_98  nV_573  2.094048e+02m  TC=0,0
L_V573  nV_573  N_C0_100  1.176501e+03uH
* *  Node  N_C0_98  to  Node  N_C0_101
R_R192  N_C0_98  N_C0_101  1.055727e+06m  TC=0,0
R_V574  N_C0_98  nV_574  -1.119281e+03m  TC=0,0
L_V574  nV_574  N_C0_101  -8.406663e+01uH
R_V575  N_C0_98  nV_575  -3.131910e+02m  TC=0,0
L_V575  nV_575  N_C0_101  -5.075273e+02uH
R_V576  N_C0_98  nV_576  8.401661e+01m  TC=0,0
L_V576  nV_576  N_C0_101  4.720311e+02uH
* *  Node  N_C0_98  to  Node  N_C0_102
R_R193  N_C0_98  N_C0_102  2.552575e+06m  TC=0,0
R_V577  N_C0_98  nV_577  7.129146e+02m  TC=0,0
L_V577  nV_577  N_C0_102  5.354537e+01uH
R_V578  N_C0_98  nV_578  7.057741e+00m  TC=0,0
L_V578  nV_578  N_C0_102  1.143710e+01uH
R_V579  N_C0_98  nV_579  3.021354e+01m  TC=0,0
L_V579  nV_579  N_C0_102  1.697490e+02uH
* *  Node  N_C0_98  to  Node  N_C0_103
R_R194  N_C0_98  N_C0_103  3.159990e+06m  TC=0,0
R_V580  N_C0_98  nV_580  5.238174e+03m  TC=0,0
L_V580  nV_580  N_C0_103  3.934271e+02uH
R_V581  N_C0_98  nV_581  1.402109e+02m  TC=0,0
L_V581  nV_581  N_C0_103  2.272124e+02uH
R_V582  N_C0_98  nV_582  -1.284534e+02m  TC=0,0
L_V582  nV_582  N_C0_103  -7.216909e+02uH
* *  Node  N_C0_98  to  Node  N_C0_104
R_R195  N_C0_98  N_C0_104  3.527210e+06m  TC=0,0
R_V583  N_C0_98  nV_583  -6.380108e+03m  TC=0,0
L_V583  nV_583  N_C0_104  -4.791952e+02uH
R_V584  N_C0_98  nV_584  3.412509e+02m  TC=0,0
L_V584  nV_584  N_C0_104  5.529985e+02uH
R_V585  N_C0_98  nV_585  1.909120e+03m  TC=0,0
L_V585  nV_585  N_C0_104  1.072602e+04uH
* *  Node  N_C0_98  to  Node  NTMP0000000019
R_R196  N_C0_98  NTMP0000000019  5.607142e+06m  TC=0,0
R_V586  N_C0_98  nV_586  -8.663368e+03m  TC=0,0
L_V586  nV_586  NTMP0000000019  -6.506856e+02uH
R_V587  N_C0_98  nV_587  -2.905729e+02m  TC=0,0
L_V587  nV_587  NTMP0000000019  -4.708746e+02uH
R_V588  N_C0_98  nV_588  2.657209e+02m  TC=0,0
L_V588  nV_588  NTMP0000000019  1.492902e+03uH
* *  Node  N_C0_98  to  Node  N_C0_105
R_R197  N_C0_98  N_C0_105  -1.768950e+07m  TC=0,0
R_V589  N_C0_98  nV_589  -3.095026e+04m  TC=0,0
L_V589  nV_589  N_C0_105  -2.324602e+03uH
R_V590  N_C0_98  nV_590  2.421919e+02m  TC=0,0
L_V590  nV_590  N_C0_105  3.924730e+02uH
R_V591  N_C0_98  nV_591  -4.228919e+02m  TC=0,0
L_V591  nV_591  N_C0_105  -2.375937e+03uH
* *  Node  N_C0_98  to  Node  NTMP0000000021
R_R198  N_C0_98  NTMP0000000021  7.295765e+06m  TC=0,0
R_V592  N_C0_98  nV_592  -7.333293e+04m  TC=0,0
L_V592  nV_592  NTMP0000000021  -5.507867e+03uH
R_V593  N_C0_98  nV_593  4.745527e+03m  TC=0,0
L_V593  nV_593  NTMP0000000021  7.690147e+03uH
R_V594  N_C0_98  nV_594  -4.528203e+03m  TC=0,0
L_V594  nV_594  NTMP0000000021  -2.544084e+04uH
* *  Node  N_C0_98  to  Node  N_C0_106
R_R199  N_C0_98  N_C0_106  6.021179e+06m  TC=0,0
R_V595  N_C0_98  nV_595  -1.969899e+04m  TC=0,0
L_V595  nV_595  N_C0_106  -1.479545e+03uH
R_V596  N_C0_98  nV_596  3.554853e+02m  TC=0,0
L_V596  nV_596  N_C0_106  5.760654e+02uH
R_V597  N_C0_98  nV_597  -9.000260e+02m  TC=0,0
L_V597  nV_597  N_C0_106  -5.056623e+03uH
* *  Node  N_C0_98  to  Node  N_C0_107
R_R200  N_C0_98  N_C0_107  -7.756465e+06m  TC=0,0
R_V598  N_C0_98  nV_598  5.608108e+05m  TC=0,0
L_V598  nV_598  N_C0_107  4.212121e+04uH
R_V599  N_C0_98  nV_599  -1.737077e+05m  TC=0,0
L_V599  nV_599  N_C0_107  -2.814940e+05uH
R_V600  N_C0_98  nV_600  9.596580e+05m  TC=0,0
L_V600  nV_600  N_C0_107  5.391654e+06uH
* *  Node  N_C0_98  to  Node  N_C0_108
R_R201  N_C0_98  N_C0_108  -4.937618e+06m  TC=0,0
R_V601  N_C0_98  nV_601  -1.174604e+04m  TC=0,0
L_V601  nV_601  N_C0_108  -8.822177e+02uH
R_V602  N_C0_98  nV_602  -1.383997e+02m  TC=0,0
L_V602  nV_602  N_C0_108  -2.242772e+02uH
R_V603  N_C0_98  nV_603  1.438660e+02m  TC=0,0
L_V603  nV_603  N_C0_108  8.082837e+02uH
* *  Node  N_C0_98  to  Node  N_C0_109
R_R202  N_C0_98  N_C0_109  2.811878e+06m  TC=0,0
R_V604  N_C0_98  nV_604  1.636168e+04m  TC=0,0
L_V604  nV_604  N_C0_109  1.228888e+03uH
R_V605  N_C0_98  nV_605  3.757299e+02m  TC=0,0
L_V605  nV_605  N_C0_109  6.088719e+02uH
R_V606  N_C0_98  nV_606  -3.506484e+02m  TC=0,0
L_V606  nV_606  N_C0_109  -1.970051e+03uH
* *  Node  N_C0_98  to  Node  N_C0_110
R_R203  N_C0_98  N_C0_110  -4.335380e+06m  TC=0,0
R_V607  N_C0_98  nV_607  -3.190554e+04m  TC=0,0
L_V607  nV_607  N_C0_110  -2.396351e+03uH
R_V608  N_C0_98  nV_608  -4.579652e+02m  TC=0,0
L_V608  nV_608  N_C0_110  -7.421346e+02uH
R_V609  N_C0_98  nV_609  4.282007e+02m  TC=0,0
L_V609  nV_609  N_C0_110  2.405763e+03uH
* *  Node  N_C0_98  to  Node  NTMP0000000028
R_R204  N_C0_98  NTMP0000000028  6.857919e+06m  TC=0,0
R_V610  N_C0_98  nV_610  -3.602851e+04m  TC=0,0
L_V610  nV_610  NTMP0000000028  -2.706018e+03uH
R_V611  N_C0_98  nV_611  -6.686750e+02m  TC=0,0
L_V611  nV_611  NTMP0000000028  -1.083591e+03uH
R_V612  N_C0_98  nV_612  6.207257e+02m  TC=0,0
L_V612  nV_612  NTMP0000000028  3.487428e+03uH
* *  Node  N_C0_98  to  Node  N_C0_111
R_R205  N_C0_98  N_C0_111  -5.994472e+06m  TC=0,0
R_V613  N_C0_98  nV_613  4.691705e+04m  TC=0,0
L_V613  nV_613  N_C0_111  3.523831e+03uH
R_V614  N_C0_98  nV_614  3.289167e+03m  TC=0,0
L_V614  nV_614  N_C0_111  5.330109e+03uH
R_V615  N_C0_98  nV_615  -2.958543e+03m  TC=0,0
L_V615  nV_615  N_C0_111  -1.662200e+04uH
* *  Node  N_C0_98  to  Node  NTMP0000000030
R_R206  N_C0_98  NTMP0000000030  7.264238e+06m  TC=0,0
R_V616  N_C0_98  nV_616  8.097978e+04m  TC=0,0
L_V616  nV_616  NTMP0000000030  6.082204e+03uH
R_V617  N_C0_98  nV_617  1.186549e+04m  TC=0,0
L_V617  nV_617  NTMP0000000030  1.922807e+04uH
R_V618  N_C0_98  nV_618  -9.688848e+03m  TC=0,0
L_V618  nV_618  NTMP0000000030  -5.443493e+04uH
* *  Node  N_C0_98  to  Node  N_C0_112
R_R207  N_C0_98  N_C0_112  8.693442e+06m  TC=0,0
R_V619  N_C0_98  nV_619  -2.625773e+05m  TC=0,0
L_V619  nV_619  N_C0_112  -1.972158e+04uH
R_V620  N_C0_98  nV_620  -1.267550e+03m  TC=0,0
L_V620  nV_620  N_C0_112  -2.054070e+03uH
R_V621  N_C0_98  nV_621  1.212522e+03m  TC=0,0
L_V621  nV_621  N_C0_112  6.812319e+03uH
* *  Node  N_C0_98  to  Node  N_BUS_2
R_R208  N_C0_98  N_BUS_2  -8.715081e+06m  TC=0,0
R_V622  N_C0_98  nV_622  1.339941e+05m  TC=0,0
L_V622  nV_622  N_BUS_2  1.006399e+04uH
R_V623  N_C0_98  nV_623  5.316160e+03m  TC=0,0
L_V623  nV_623  N_BUS_2  8.614860e+03uH
R_V624  N_C0_98  nV_624  -5.032271e+03m  TC=0,0
L_V624  nV_624  N_BUS_2  -2.827285e+04uH
* *  Node  N_C0_98  to  Node  N_C0_114
R_R209  N_C0_98  N_C0_114  1.279869e+06m  TC=0,0
R_V625  N_C0_98  nV_625  1.955138e+03m  TC=0,0
L_V625  nV_625  N_C0_114  1.468459e+02uH
R_V626  N_C0_98  nV_626  -3.309389e+01m  TC=0,0
L_V626  nV_626  N_C0_114  -5.362879e+01uH
R_V627  N_C0_98  nV_627  1.286739e+00m  TC=0,0
L_V627  nV_627  N_C0_114  7.229293e+00uH
* *  Node  N_C0_98  to  Node  N_C0_115
R_R210  N_C0_98  N_C0_115  3.001357e+06m  TC=0,0
R_V628  N_C0_98  nV_628  5.628638e+03m  TC=0,0
L_V628  nV_628  N_C0_115  4.227540e+02uH
R_V629  N_C0_98  nV_629  -6.062815e+01m  TC=0,0
L_V629  nV_629  N_C0_115  -9.824817e+01uH
R_V630  N_C0_98  nV_630  1.002538e+02m  TC=0,0
L_V630  nV_630  N_C0_115  5.632567e+02uH
* *  Node  N_C0_98  to  Node  N_C0_116
R_R211  N_C0_98  N_C0_116  3.444412e+06m  TC=0,0
R_V631  N_C0_98  nV_631  5.742034e+03m  TC=0,0
L_V631  nV_631  N_C0_116  4.312709e+02uH
R_V632  N_C0_98  nV_632  -6.142166e+01m  TC=0,0
L_V632  nV_632  N_C0_116  -9.953406e+01uH
R_V633  N_C0_98  nV_633  1.025613e+02m  TC=0,0
L_V633  nV_633  N_C0_116  5.762209e+02uH
* *  Node  N_C0_98  to  Node  N_C0_117
R_R212  N_C0_98  N_C0_117  4.530674e+06m  TC=0,0
R_V634  N_C0_98  nV_634  7.302953e+03m  TC=0,0
L_V634  nV_634  N_C0_117  5.485079e+02uH
R_V635  N_C0_98  nV_635  -9.082448e+01m  TC=0,0
L_V635  nV_635  N_C0_117  -1.471815e+02uH
R_V636  N_C0_98  nV_636  1.636792e+02m  TC=0,0
L_V636  nV_636  N_C0_117  9.196001e+02uH
* *  Node  N_C0_98  to  Node  N_C0_118
R_R213  N_C0_98  N_C0_118  3.004214e+06m  TC=0,0
R_V637  N_C0_98  nV_637  9.356313e+03m  TC=0,0
L_V637  nV_637  N_C0_118  7.027310e+02uH
R_V638  N_C0_98  nV_638  -9.170703e+01m  TC=0,0
L_V638  nV_638  N_C0_118  -1.486116e+02uH
R_V639  N_C0_98  nV_639  1.534686e+02m  TC=0,0
L_V639  nV_639  N_C0_118  8.622336e+02uH
* *  Node  N_C0_98  to  Node  N_C0_119
R_R214  N_C0_98  N_C0_119  6.097149e+06m  TC=0,0
R_V640  N_C0_98  nV_640  1.272828e+04m  TC=0,0
L_V640  nV_640  N_C0_119  9.559920e+02uH
R_V641  N_C0_98  nV_641  -1.435177e+02m  TC=0,0
L_V641  nV_641  N_C0_119  -2.325710e+02uH
R_V642  N_C0_98  nV_642  2.629433e+02m  TC=0,0
L_V642  nV_642  N_C0_119  1.477296e+03uH
* *  Node  N_C0_98  to  Node  N_C0_120
R_R215  N_C0_98  N_C0_120  8.347495e+06m  TC=0,0
R_V643  N_C0_98  nV_643  2.170561e+04m  TC=0,0
L_V643  nV_643  N_C0_120  1.630258e+03uH
R_V644  N_C0_98  nV_644  -2.611189e+02m  TC=0,0
L_V644  nV_644  N_C0_120  -4.231443e+02uH
R_V645  N_C0_98  nV_645  4.915716e+02m  TC=0,0
L_V645  nV_645  N_C0_120  2.761801e+03uH
* *  Node  N_C0_98  to  Node  N_C0_121
R_R216  N_C0_98  N_C0_121  1.417244e+07m  TC=0,0
R_V646  N_C0_98  nV_646  2.276715e+04m  TC=0,0
L_V646  nV_646  N_C0_121  1.709988e+03uH
R_V647  N_C0_98  nV_647  -2.876212e+02m  TC=0,0
L_V647  nV_647  N_C0_121  -4.660914e+02uH
R_V648  N_C0_98  nV_648  5.547218e+02m  TC=0,0
L_V648  nV_648  N_C0_121  3.116598e+03uH
* *  Node  N_C0_98  to  Node  N_BUS_GND
R_R217  N_C0_98  N_BUS_GND  1.232050e+07m  TC=0,0
R_V649  N_C0_98  nV_649  1.270664e+04m  TC=0,0
L_V649  nV_649  N_BUS_GND  9.543665e+02uH
R_V650  N_C0_98  nV_650  1.341946e+02m  TC=0,0
L_V650  nV_650  N_BUS_GND  2.174630e+02uH
R_V651  N_C0_98  nV_651  -1.395803e+02m  TC=0,0
L_V651  nV_651  N_BUS_GND  -7.842052e+02uH
*  Node  N_C0_99  to other nodes
* *  Node  N_C0_99  to  Node  N_C0_100
R_R218  N_C0_99  N_C0_100  1.138438e+07m  TC=0,0
R_V652  N_C0_99  nV_652  -1.079107e+03m  TC=0,0
L_V652  nV_652  N_C0_100  -8.104923e+01uH
R_V653  N_C0_99  nV_653  -2.912031e+02m  TC=0,0
L_V653  nV_653  N_C0_100  -4.718958e+02uH
R_V654  N_C0_99  nV_654  8.196695e+01m  TC=0,0
L_V654  nV_654  N_C0_100  4.605156e+02uH
* *  Node  N_C0_99  to  Node  N_C0_101
R_R219  N_C0_99  N_C0_101  2.069706e+06m  TC=0,0
R_V655  N_C0_99  nV_655  -2.572341e+03m  TC=0,0
L_V655  nV_655  N_C0_101  -1.932026e+02uH
R_V656  N_C0_99  nV_656  1.003252e+03m  TC=0,0
L_V656  nV_656  N_C0_101  1.625774e+03uH
R_V657  N_C0_99  nV_657  2.094048e+02m  TC=0,0
L_V657  nV_657  N_C0_101  1.176501e+03uH
* *  Node  N_C0_99  to  Node  N_C0_102
R_R220  N_C0_99  N_C0_102  9.424555e+06m  TC=0,0
R_V658  N_C0_99  nV_658  5.381863e+04m  TC=0,0
L_V658  nV_658  N_C0_102  4.042193e+03uH
R_V659  N_C0_99  nV_659  1.036192e+02m  TC=0,0
L_V659  nV_659  N_C0_102  1.679153e+02uH
R_V660  N_C0_99  nV_660  -1.439203e+02m  TC=0,0
L_V660  nV_660  N_C0_102  -8.085886e+02uH
* *  Node  N_C0_99  to  Node  N_C0_103
R_R221  N_C0_99  N_C0_103  3.504524e+07m  TC=0,0
R_V661  N_C0_99  nV_661  -3.900754e+04m  TC=0,0
L_V661  nV_661  N_C0_103  -2.929766e+03uH
R_V662  N_C0_99  nV_662  -4.082425e+02m  TC=0,0
L_V662  nV_662  N_C0_103  -6.615587e+02uH
R_V663  N_C0_99  nV_663  3.868743e+02m  TC=0,0
L_V663  nV_663  N_C0_103  2.173579e+03uH
* *  Node  N_C0_99  to  Node  N_C0_104
R_R222  N_C0_99  N_C0_104  9.037913e+06m  TC=0,0
R_V664  N_C0_99  nV_664  -7.441112e+03m  TC=0,0
L_V664  nV_664  N_C0_104  -5.588847e+02uH
R_V665  N_C0_99  nV_665  -7.795391e+02m  TC=0,0
L_V665  nV_665  N_C0_104  -1.263246e+03uH
R_V666  N_C0_99  nV_666  2.446392e+02m  TC=0,0
L_V666  nV_666  N_C0_104  1.374458e+03uH
* *  Node  N_C0_99  to  Node  NTMP0000000019
R_R223  N_C0_99  NTMP0000000019  -2.498294e+08m  TC=0,0
R_V667  N_C0_99  nV_667  1.433785e+05m  TC=0,0
L_V667  nV_667  NTMP0000000019  1.076882e+04uH
R_V668  N_C0_99  nV_668  -1.071519e+03m  TC=0,0
L_V668  nV_668  NTMP0000000019  -1.736401e+03uH
R_V669  N_C0_99  nV_669  1.033717e+03m  TC=0,0
L_V669  nV_669  NTMP0000000019  5.807742e+03uH
* *  Node  N_C0_99  to  Node  N_C0_105
R_R224  N_C0_99  N_C0_105  7.622352e+07m  TC=0,0
R_V670  N_C0_99  nV_670  -3.850810e+04m  TC=0,0
L_V670  nV_670  N_C0_105  -2.892255e+03uH
R_V671  N_C0_99  nV_671  3.614186e+02m  TC=0,0
L_V671  nV_671  N_C0_105  5.856803e+02uH
R_V672  N_C0_99  nV_672  -7.498733e+02m  TC=0,0
L_V672  nV_672  N_C0_105  -4.213019e+03uH
* *  Node  N_C0_99  to  Node  NTMP0000000021
R_R225  N_C0_99  NTMP0000000021  -8.740339e+07m  TC=0,0
R_V673  N_C0_99  nV_673  5.443418e+04m  TC=0,0
L_V673  nV_673  NTMP0000000021  4.088425e+03uH
R_V674  N_C0_99  nV_674  -1.754833e+03m  TC=0,0
L_V674  nV_674  NTMP0000000021  -2.843714e+03uH
R_V675  N_C0_99  nV_675  1.768329e+03m  TC=0,0
L_V675  nV_675  NTMP0000000021  9.935016e+03uH
* *  Node  N_C0_99  to  Node  N_C0_106
R_R226  N_C0_99  N_C0_106  7.252347e+07m  TC=0,0
R_V676  N_C0_99  nV_676  -1.529019e+04m  TC=0,0
L_V676  nV_676  N_C0_106  -1.148411e+03uH
R_V677  N_C0_99  nV_677  -7.701522e+03m  TC=0,0
L_V677  nV_677  N_C0_106  -1.248035e+04uH
R_V678  N_C0_99  nV_678  6.142028e+02m  TC=0,0
L_V678  nV_678  N_C0_106  3.450780e+03uH
* *  Node  N_C0_99  to  Node  N_C0_107
R_R227  N_C0_99  N_C0_107  3.247787e+07m  TC=0,0
R_V679  N_C0_99  nV_679  -1.930022e+04m  TC=0,0
L_V679  nV_679  N_C0_107  -1.449595e+03uH
R_V680  N_C0_99  nV_680  -5.679296e+02m  TC=0,0
L_V680  nV_680  N_C0_107  -9.203323e+02uH
R_V681  N_C0_99  nV_681  5.273487e+02m  TC=0,0
L_V681  nV_681  N_C0_107  2.962807e+03uH
* *  Node  N_C0_99  to  Node  N_C0_108
R_R228  N_C0_99  N_C0_108  2.680605e+07m  TC=0,0
R_V682  N_C0_99  nV_682  -1.027406e+04m  TC=0,0
L_V682  nV_682  N_C0_108  -7.716611e+02uH
R_V683  N_C0_99  nV_683  -1.208822e+02m  TC=0,0
L_V683  nV_683  N_C0_108  -1.958901e+02uH
R_V684  N_C0_99  nV_684  1.214558e+02m  TC=0,0
L_V684  nV_684  N_C0_108  6.823761e+02uH
* *  Node  N_C0_99  to  Node  N_C0_109
R_R229  N_C0_99  N_C0_109  2.798071e+07m  TC=0,0
R_V685  N_C0_99  nV_685  9.873404e+03m  TC=0,0
L_V685  nV_685  N_C0_109  7.415686e+02uH
R_V686  N_C0_99  nV_686  1.904608e+02m  TC=0,0
L_V686  nV_686  N_C0_109  3.086426e+02uH
R_V687  N_C0_99  nV_687  -1.803311e+02m  TC=0,0
L_V687  nV_687  N_C0_109  -1.013155e+03uH
* *  Node  N_C0_99  to  Node  N_C0_110
R_R230  N_C0_99  N_C0_110  -1.119572e+08m  TC=0,0
R_V688  N_C0_99  nV_688  3.419737e+05m  TC=0,0
L_V688  nV_688  N_C0_110  2.568485e+04uH
R_V689  N_C0_99  nV_689  -1.739276e+03m  TC=0,0
L_V689  nV_689  N_C0_110  -2.818505e+03uH
R_V690  N_C0_99  nV_690  1.632061e+03m  TC=0,0
L_V690  nV_690  N_C0_110  9.169420e+03uH
* *  Node  N_C0_99  to  Node  NTMP0000000028
R_R231  N_C0_99  NTMP0000000028  -9.423348e+07m  TC=0,0
R_V691  N_C0_99  nV_691  -8.456918e+04m  TC=0,0
L_V691  nV_691  NTMP0000000028  -6.351796e+03uH
R_V692  N_C0_99  nV_692  -1.446421e+03m  TC=0,0
L_V692  nV_692  NTMP0000000028  -2.343932e+03uH
R_V693  N_C0_99  nV_693  1.355129e+03m  TC=0,0
L_V693  nV_693  NTMP0000000028  7.613530e+03uH
* *  Node  N_C0_99  to  Node  N_C0_111
R_R232  N_C0_99  N_C0_111  1.306822e+08m  TC=0,0
R_V694  N_C0_99  nV_694  -6.412760e+04m  TC=0,0
L_V694  nV_694  N_C0_111  -4.816476e+03uH
R_V695  N_C0_99  nV_695  -6.190957e+03m  TC=0,0
L_V695  nV_695  N_C0_111  -1.003247e+04uH
R_V696  N_C0_99  nV_696  5.664858e+03m  TC=0,0
L_V696  nV_696  N_C0_111  3.182691e+04uH
* *  Node  N_C0_99  to  Node  NTMP0000000030
R_R233  N_C0_99  NTMP0000000030  -7.546774e+07m  TC=0,0
R_V697  N_C0_99  nV_697  -1.783903e+05m  TC=0,0
L_V697  nV_697  NTMP0000000030  -1.339848e+04uH
R_V698  N_C0_99  nV_698  -2.086865e+03m  TC=0,0
L_V698  nV_698  NTMP0000000030  -3.381774e+03uH
R_V699  N_C0_99  nV_699  1.982419e+03m  TC=0,0
L_V699  nV_699  NTMP0000000030  1.113784e+04uH
* *  Node  N_C0_99  to  Node  N_C0_112
R_R234  N_C0_99  N_C0_112  7.647435e+07m  TC=0,0
R_V700  N_C0_99  nV_700  -1.608053e+04m  TC=0,0
L_V700  nV_700  N_C0_112  -1.207771e+03uH
R_V701  N_C0_99  nV_701  -3.196478e+02m  TC=0,0
L_V701  nV_701  N_C0_112  -5.179906e+02uH
R_V702  N_C0_99  nV_702  3.036038e+02m  TC=0,0
L_V702  nV_702  N_C0_112  1.705740e+03uH
* *  Node  N_C0_99  to  Node  N_BUS_2
R_R235  N_C0_99  N_BUS_2  2.850257e+07m  TC=0,0
R_V703  N_C0_99  nV_703  5.178316e+04m  TC=0,0
L_V703  nV_703  N_BUS_2  3.889313e+03uH
R_V704  N_C0_99  nV_704  5.766647e+02m  TC=0,0
L_V704  nV_704  N_BUS_2  9.344877e+02uH
R_V705  N_C0_99  nV_705  -5.479948e+02m  TC=0,0
L_V705  nV_705  N_BUS_2  -3.078803e+03uH
* *  Node  N_C0_99  to  Node  N_C0_114
R_R236  N_C0_99  N_C0_114  1.528496e+07m  TC=0,0
R_V706  N_C0_99  nV_706  5.155296e+03m  TC=0,0
L_V706  nV_706  N_C0_114  3.872024e+02uH
R_V707  N_C0_99  nV_707  -6.058522e+01m  TC=0,0
L_V707  nV_707  N_C0_114  -9.817861e+01uH
R_V708  N_C0_99  nV_708  1.002038e+02m  TC=0,0
L_V708  nV_708  N_C0_114  5.629756e+02uH
* *  Node  N_C0_99  to  Node  N_C0_115
R_R237  N_C0_99  N_C0_115  2.184172e+06m  TC=0,0
R_V709  N_C0_99  nV_709  1.834437e+03m  TC=0,0
L_V709  nV_709  N_C0_115  1.377803e+02uH
R_V710  N_C0_99  nV_710  -3.260814e+01m  TC=0,0
L_V710  nV_710  N_C0_115  -5.284164e+01uH
R_V711  N_C0_99  nV_711  1.285974e+00m  TC=0,0
L_V711  nV_711  N_C0_115  7.224996e+00uH
* *  Node  N_C0_99  to  Node  N_C0_116
R_R238  N_C0_99  N_C0_116  7.102185e+07m  TC=0,0
R_V712  N_C0_99  nV_712  6.570457e+03m  TC=0,0
L_V712  nV_712  N_C0_116  4.934918e+02uH
R_V713  N_C0_99  nV_713  -9.074163e+01m  TC=0,0
L_V713  nV_713  N_C0_116  -1.470472e+02uH
R_V714  N_C0_99  nV_714  1.635746e+02m  TC=0,0
L_V714  nV_714  N_C0_116  9.190124e+02uH
* *  Node  N_C0_99  to  Node  N_C0_117
R_R239  N_C0_99  N_C0_117  1.268676e+07m  TC=0,0
R_V715  N_C0_99  nV_715  4.860973e+03m  TC=0,0
L_V715  nV_715  N_C0_117  3.650964e+02uH
R_V716  N_C0_99  nV_716  -5.994255e+01m  TC=0,0
L_V716  nV_716  N_C0_117  -9.713717e+01uH
R_V717  N_C0_99  nV_717  9.840507e+01m  TC=0,0
L_V717  nV_717  N_C0_117  5.528699e+02uH
* *  Node  N_C0_99  to  Node  N_C0_118
R_R240  N_C0_99  N_C0_118  1.305652e+08m  TC=0,0
R_V718  N_C0_99  nV_718  1.447450e+04m  TC=0,0
L_V718  nV_718  N_C0_118  1.087146e+03uH
R_V719  N_C0_99  nV_719  -1.563015e+02m  TC=0,0
L_V719  nV_719  N_C0_118  -2.532873e+02uH
R_V720  N_C0_99  nV_720  2.856597e+02m  TC=0,0
L_V720  nV_720  N_C0_118  1.604924e+03uH
* *  Node  N_C0_99  to  Node  N_C0_119
R_R241  N_C0_99  N_C0_119  -6.835926e+07m  TC=0,0
R_V721  N_C0_99  nV_721  1.709807e+04m  TC=0,0
L_V721  nV_721  N_C0_119  1.284196e+03uH
R_V722  N_C0_99  nV_722  -1.984896e+02m  TC=0,0
L_V722  nV_722  N_C0_119  -3.216532e+02uH
R_V723  N_C0_99  nV_723  3.866273e+02m  TC=0,0
L_V723  nV_723  N_C0_119  2.172191e+03uH
* *  Node  N_C0_99  to  Node  N_C0_120
R_R242  N_C0_99  N_C0_120  -7.301624e+10m  TC=0,0
R_V724  N_C0_99  nV_724  2.604828e+04m  TC=0,0
L_V724  nV_724  N_C0_120  1.956426e+03uH
R_V725  N_C0_99  nV_725  -3.344704e+02m  TC=0,0
L_V725  nV_725  N_C0_120  -5.420107e+02uH
R_V726  N_C0_99  nV_726  6.501290e+02m  TC=0,0
L_V726  nV_726  N_C0_120  3.652625e+03uH
* *  Node  N_C0_99  to  Node  N_C0_121
R_R243  N_C0_99  N_C0_121  -2.287471e+08m  TC=0,0
R_V727  N_C0_99  nV_727  2.712881e+04m  TC=0,0
L_V727  nV_727  N_C0_121  2.037582e+03uH
R_V728  N_C0_99  nV_728  -3.578307e+02m  TC=0,0
L_V728  nV_728  N_C0_121  -5.798662e+02uH
R_V729  N_C0_99  nV_729  7.094586e+02m  TC=0,0
L_V729  nV_729  N_C0_121  3.985957e+03uH
* *  Node  N_C0_99  to  Node  N_BUS_GND
R_R244  N_C0_99  N_BUS_GND  -2.006688e+09m  TC=0,0
R_V730  N_C0_99  nV_730  1.436136e+04m  TC=0,0
L_V730  nV_730  N_BUS_GND  1.078648e+03uH
R_V731  N_C0_99  nV_731  2.190725e+02m  TC=0,0
L_V731  nV_731  N_BUS_GND  3.550080e+02uH
R_V732  N_C0_99  nV_732  -2.296953e+02m  TC=0,0
L_V732  nV_732  N_BUS_GND  -1.290499e+03uH
*  Node  N_C0_100  to other nodes
* *  Node  N_C0_100  to  Node  N_C0_101
R_R245  N_C0_100  N_C0_101  2.914002e+06m  TC=0,0
R_V733  N_C0_100  nV_733  -1.209864e+03m  TC=0,0
L_V733  nV_733  N_C0_101  -9.087005e+01uH
R_V734  N_C0_100  nV_734  -2.078823e+03m  TC=0,0
L_V734  nV_734  N_C0_101  -3.368742e+03uH
R_V735  N_C0_100  nV_735  1.114701e+02m  TC=0,0
L_V735  nV_735  N_C0_101  6.262731e+02uH
* *  Node  N_C0_100  to  Node  N_C0_102
R_R246  N_C0_100  N_C0_102  9.037913e+06m  TC=0,0
R_V736  N_C0_100  nV_736  -7.441112e+03m  TC=0,0
L_V736  nV_736  N_C0_102  -5.588847e+02uH
R_V737  N_C0_100  nV_737  -7.795391e+02m  TC=0,0
L_V737  nV_737  N_C0_102  -1.263246e+03uH
R_V738  N_C0_100  nV_738  2.446392e+02m  TC=0,0
L_V738  nV_738  N_C0_102  1.374458e+03uH
* *  Node  N_C0_100  to  Node  N_C0_103
R_R247  N_C0_100  N_C0_103  3.504524e+07m  TC=0,0
R_V739  N_C0_100  nV_739  -3.900754e+04m  TC=0,0
L_V739  nV_739  N_C0_103  -2.929766e+03uH
R_V740  N_C0_100  nV_740  -4.082425e+02m  TC=0,0
L_V740  nV_740  N_C0_103  -6.615587e+02uH
R_V741  N_C0_100  nV_741  3.868743e+02m  TC=0,0
L_V741  nV_741  N_C0_103  2.173579e+03uH
* *  Node  N_C0_100  to  Node  N_C0_104
R_R248  N_C0_100  N_C0_104  9.424555e+06m  TC=0,0
R_V742  N_C0_100  nV_742  5.381863e+04m  TC=0,0
L_V742  nV_742  N_C0_104  4.042193e+03uH
R_V743  N_C0_100  nV_743  1.036192e+02m  TC=0,0
L_V743  nV_743  N_C0_104  1.679153e+02uH
R_V744  N_C0_100  nV_744  -1.439203e+02m  TC=0,0
L_V744  nV_744  N_C0_104  -8.085886e+02uH
* *  Node  N_C0_100  to  Node  NTMP0000000019
R_R249  N_C0_100  NTMP0000000019  -8.740339e+07m  TC=0,0
R_V745  N_C0_100  nV_745  5.443418e+04m  TC=0,0
L_V745  nV_745  NTMP0000000019  4.088425e+03uH
R_V746  N_C0_100  nV_746  -1.754833e+03m  TC=0,0
L_V746  nV_746  NTMP0000000019  -2.843714e+03uH
R_V747  N_C0_100  nV_747  1.768329e+03m  TC=0,0
L_V747  nV_747  NTMP0000000019  9.935016e+03uH
* *  Node  N_C0_100  to  Node  N_C0_105
R_R250  N_C0_100  N_C0_105  7.252347e+07m  TC=0,0
R_V748  N_C0_100  nV_748  -1.529019e+04m  TC=0,0
L_V748  nV_748  N_C0_105  -1.148411e+03uH
R_V749  N_C0_100  nV_749  -7.701522e+03m  TC=0,0
L_V749  nV_749  N_C0_105  -1.248035e+04uH
R_V750  N_C0_100  nV_750  6.142028e+02m  TC=0,0
L_V750  nV_750  N_C0_105  3.450780e+03uH
* *  Node  N_C0_100  to  Node  NTMP0000000021
R_R251  N_C0_100  NTMP0000000021  -2.498294e+08m  TC=0,0
R_V751  N_C0_100  nV_751  1.433785e+05m  TC=0,0
L_V751  nV_751  NTMP0000000021  1.076882e+04uH
R_V752  N_C0_100  nV_752  -1.071519e+03m  TC=0,0
L_V752  nV_752  NTMP0000000021  -1.736401e+03uH
R_V753  N_C0_100  nV_753  1.033717e+03m  TC=0,0
L_V753  nV_753  NTMP0000000021  5.807742e+03uH
* *  Node  N_C0_100  to  Node  N_C0_106
R_R252  N_C0_100  N_C0_106  7.622352e+07m  TC=0,0
R_V754  N_C0_100  nV_754  -3.850810e+04m  TC=0,0
L_V754  nV_754  N_C0_106  -2.892255e+03uH
R_V755  N_C0_100  nV_755  3.614186e+02m  TC=0,0
L_V755  nV_755  N_C0_106  5.856803e+02uH
R_V756  N_C0_100  nV_756  -7.498733e+02m  TC=0,0
L_V756  nV_756  N_C0_106  -4.213019e+03uH
* *  Node  N_C0_100  to  Node  N_C0_107
R_R253  N_C0_100  N_C0_107  3.247787e+07m  TC=0,0
R_V757  N_C0_100  nV_757  -1.930022e+04m  TC=0,0
L_V757  nV_757  N_C0_107  -1.449595e+03uH
R_V758  N_C0_100  nV_758  -5.679296e+02m  TC=0,0
L_V758  nV_758  N_C0_107  -9.203323e+02uH
R_V759  N_C0_100  nV_759  5.273487e+02m  TC=0,0
L_V759  nV_759  N_C0_107  2.962807e+03uH
* *  Node  N_C0_100  to  Node  N_C0_108
R_R254  N_C0_100  N_C0_108  2.680605e+07m  TC=0,0
R_V760  N_C0_100  nV_760  -1.027406e+04m  TC=0,0
L_V760  nV_760  N_C0_108  -7.716611e+02uH
R_V761  N_C0_100  nV_761  -1.208822e+02m  TC=0,0
L_V761  nV_761  N_C0_108  -1.958901e+02uH
R_V762  N_C0_100  nV_762  1.214558e+02m  TC=0,0
L_V762  nV_762  N_C0_108  6.823761e+02uH
* *  Node  N_C0_100  to  Node  N_C0_109
R_R255  N_C0_100  N_C0_109  -1.119572e+08m  TC=0,0
R_V763  N_C0_100  nV_763  3.419737e+05m  TC=0,0
L_V763  nV_763  N_C0_109  2.568485e+04uH
R_V764  N_C0_100  nV_764  -1.739276e+03m  TC=0,0
L_V764  nV_764  N_C0_109  -2.818505e+03uH
R_V765  N_C0_100  nV_765  1.632061e+03m  TC=0,0
L_V765  nV_765  N_C0_109  9.169420e+03uH
* *  Node  N_C0_100  to  Node  N_C0_110
R_R256  N_C0_100  N_C0_110  2.798071e+07m  TC=0,0
R_V766  N_C0_100  nV_766  9.873404e+03m  TC=0,0
L_V766  nV_766  N_C0_110  7.415686e+02uH
R_V767  N_C0_100  nV_767  1.904608e+02m  TC=0,0
L_V767  nV_767  N_C0_110  3.086426e+02uH
R_V768  N_C0_100  nV_768  -1.803311e+02m  TC=0,0
L_V768  nV_768  N_C0_110  -1.013155e+03uH
* *  Node  N_C0_100  to  Node  NTMP0000000028
R_R257  N_C0_100  NTMP0000000028  -7.546774e+07m  TC=0,0
R_V769  N_C0_100  nV_769  -1.783903e+05m  TC=0,0
L_V769  nV_769  NTMP0000000028  -1.339848e+04uH
R_V770  N_C0_100  nV_770  -2.086865e+03m  TC=0,0
L_V770  nV_770  NTMP0000000028  -3.381774e+03uH
R_V771  N_C0_100  nV_771  1.982419e+03m  TC=0,0
L_V771  nV_771  NTMP0000000028  1.113784e+04uH
* *  Node  N_C0_100  to  Node  N_C0_111
R_R258  N_C0_100  N_C0_111  7.647435e+07m  TC=0,0
R_V772  N_C0_100  nV_772  -1.608053e+04m  TC=0,0
L_V772  nV_772  N_C0_111  -1.207771e+03uH
R_V773  N_C0_100  nV_773  -3.196478e+02m  TC=0,0
L_V773  nV_773  N_C0_111  -5.179906e+02uH
R_V774  N_C0_100  nV_774  3.036038e+02m  TC=0,0
L_V774  nV_774  N_C0_111  1.705740e+03uH
* *  Node  N_C0_100  to  Node  NTMP0000000030
R_R259  N_C0_100  NTMP0000000030  -9.423348e+07m  TC=0,0
R_V775  N_C0_100  nV_775  -8.456918e+04m  TC=0,0
L_V775  nV_775  NTMP0000000030  -6.351796e+03uH
R_V776  N_C0_100  nV_776  -1.446421e+03m  TC=0,0
L_V776  nV_776  NTMP0000000030  -2.343932e+03uH
R_V777  N_C0_100  nV_777  1.355129e+03m  TC=0,0
L_V777  nV_777  NTMP0000000030  7.613530e+03uH
* *  Node  N_C0_100  to  Node  N_C0_112
R_R260  N_C0_100  N_C0_112  1.306822e+08m  TC=0,0
R_V778  N_C0_100  nV_778  -6.412760e+04m  TC=0,0
L_V778  nV_778  N_C0_112  -4.816476e+03uH
R_V779  N_C0_100  nV_779  -6.190957e+03m  TC=0,0
L_V779  nV_779  N_C0_112  -1.003247e+04uH
R_V780  N_C0_100  nV_780  5.664858e+03m  TC=0,0
L_V780  nV_780  N_C0_112  3.182691e+04uH
* *  Node  N_C0_100  to  Node  N_BUS_2
R_R261  N_C0_100  N_BUS_2  2.850257e+07m  TC=0,0
R_V781  N_C0_100  nV_781  5.178316e+04m  TC=0,0
L_V781  nV_781  N_BUS_2  3.889313e+03uH
R_V782  N_C0_100  nV_782  5.766647e+02m  TC=0,0
L_V782  nV_782  N_BUS_2  9.344877e+02uH
R_V783  N_C0_100  nV_783  -5.479948e+02m  TC=0,0
L_V783  nV_783  N_BUS_2  -3.078803e+03uH
* *  Node  N_C0_100  to  Node  N_C0_114
R_R262  N_C0_100  N_C0_114  7.102185e+07m  TC=0,0
R_V784  N_C0_100  nV_784  6.570457e+03m  TC=0,0
L_V784  nV_784  N_C0_114  4.934918e+02uH
R_V785  N_C0_100  nV_785  -9.074163e+01m  TC=0,0
L_V785  nV_785  N_C0_114  -1.470472e+02uH
R_V786  N_C0_100  nV_786  1.635746e+02m  TC=0,0
L_V786  nV_786  N_C0_114  9.190124e+02uH
* *  Node  N_C0_100  to  Node  N_C0_115
R_R263  N_C0_100  N_C0_115  1.268676e+07m  TC=0,0
R_V787  N_C0_100  nV_787  4.860973e+03m  TC=0,0
L_V787  nV_787  N_C0_115  3.650964e+02uH
R_V788  N_C0_100  nV_788  -5.994255e+01m  TC=0,0
L_V788  nV_788  N_C0_115  -9.713717e+01uH
R_V789  N_C0_100  nV_789  9.840507e+01m  TC=0,0
L_V789  nV_789  N_C0_115  5.528699e+02uH
* *  Node  N_C0_100  to  Node  N_C0_116
R_R264  N_C0_100  N_C0_116  1.528496e+07m  TC=0,0
R_V790  N_C0_100  nV_790  5.155296e+03m  TC=0,0
L_V790  nV_790  N_C0_116  3.872024e+02uH
R_V791  N_C0_100  nV_791  -6.058522e+01m  TC=0,0
L_V791  nV_791  N_C0_116  -9.817861e+01uH
R_V792  N_C0_100  nV_792  1.002038e+02m  TC=0,0
L_V792  nV_792  N_C0_116  5.629756e+02uH
* *  Node  N_C0_100  to  Node  N_C0_117
R_R265  N_C0_100  N_C0_117  2.184172e+06m  TC=0,0
R_V793  N_C0_100  nV_793  1.834437e+03m  TC=0,0
L_V793  nV_793  N_C0_117  1.377803e+02uH
R_V794  N_C0_100  nV_794  -3.260814e+01m  TC=0,0
L_V794  nV_794  N_C0_117  -5.284164e+01uH
R_V795  N_C0_100  nV_795  1.285974e+00m  TC=0,0
L_V795  nV_795  N_C0_117  7.224996e+00uH
* *  Node  N_C0_100  to  Node  N_C0_118
R_R266  N_C0_100  N_C0_118  -6.835926e+07m  TC=0,0
R_V796  N_C0_100  nV_796  1.709807e+04m  TC=0,0
L_V796  nV_796  N_C0_118  1.284196e+03uH
R_V797  N_C0_100  nV_797  -1.984896e+02m  TC=0,0
L_V797  nV_797  N_C0_118  -3.216532e+02uH
R_V798  N_C0_100  nV_798  3.866273e+02m  TC=0,0
L_V798  nV_798  N_C0_118  2.172191e+03uH
* *  Node  N_C0_100  to  Node  N_C0_119
R_R267  N_C0_100  N_C0_119  1.305652e+08m  TC=0,0
R_V799  N_C0_100  nV_799  1.447450e+04m  TC=0,0
L_V799  nV_799  N_C0_119  1.087146e+03uH
R_V800  N_C0_100  nV_800  -1.563015e+02m  TC=0,0
L_V800  nV_800  N_C0_119  -2.532873e+02uH
R_V801  N_C0_100  nV_801  2.856597e+02m  TC=0,0
L_V801  nV_801  N_C0_119  1.604924e+03uH
* *  Node  N_C0_100  to  Node  N_C0_120
R_R268  N_C0_100  N_C0_120  -2.287471e+08m  TC=0,0
R_V802  N_C0_100  nV_802  2.712881e+04m  TC=0,0
L_V802  nV_802  N_C0_120  2.037582e+03uH
R_V803  N_C0_100  nV_803  -3.578307e+02m  TC=0,0
L_V803  nV_803  N_C0_120  -5.798662e+02uH
R_V804  N_C0_100  nV_804  7.094586e+02m  TC=0,0
L_V804  nV_804  N_C0_120  3.985957e+03uH
* *  Node  N_C0_100  to  Node  N_C0_121
R_R269  N_C0_100  N_C0_121  -7.301624e+10m  TC=0,0
R_V805  N_C0_100  nV_805  2.604828e+04m  TC=0,0
L_V805  nV_805  N_C0_121  1.956426e+03uH
R_V806  N_C0_100  nV_806  -3.344704e+02m  TC=0,0
L_V806  nV_806  N_C0_121  -5.420107e+02uH
R_V807  N_C0_100  nV_807  6.501290e+02m  TC=0,0
L_V807  nV_807  N_C0_121  3.652625e+03uH
* *  Node  N_C0_100  to  Node  N_BUS_GND
R_R270  N_C0_100  N_BUS_GND  -2.006688e+09m  TC=0,0
R_V808  N_C0_100  nV_808  1.436136e+04m  TC=0,0
L_V808  nV_808  N_BUS_GND  1.078648e+03uH
R_V809  N_C0_100  nV_809  2.190725e+02m  TC=0,0
L_V809  nV_809  N_BUS_GND  3.550080e+02uH
R_V810  N_C0_100  nV_810  -2.296953e+02m  TC=0,0
L_V810  nV_810  N_BUS_GND  -1.290499e+03uH
*  Node  N_C0_101  to other nodes
* *  Node  N_C0_101  to  Node  N_C0_102
R_R271  N_C0_101  N_C0_102  3.527210e+06m  TC=0,0
R_V811  N_C0_101  nV_811  -6.380108e+03m  TC=0,0
L_V811  nV_811  N_C0_102  -4.791952e+02uH
R_V812  N_C0_101  nV_812  3.412509e+02m  TC=0,0
L_V812  nV_812  N_C0_102  5.529985e+02uH
R_V813  N_C0_101  nV_813  1.909120e+03m  TC=0,0
L_V813  nV_813  N_C0_102  1.072602e+04uH
* *  Node  N_C0_101  to  Node  N_C0_103
R_R272  N_C0_101  N_C0_103  3.159990e+06m  TC=0,0
R_V814  N_C0_101  nV_814  5.238174e+03m  TC=0,0
L_V814  nV_814  N_C0_103  3.934271e+02uH
R_V815  N_C0_101  nV_815  1.402109e+02m  TC=0,0
L_V815  nV_815  N_C0_103  2.272124e+02uH
R_V816  N_C0_101  nV_816  -1.284534e+02m  TC=0,0
L_V816  nV_816  N_C0_103  -7.216909e+02uH
* *  Node  N_C0_101  to  Node  N_C0_104
R_R273  N_C0_101  N_C0_104  2.552575e+06m  TC=0,0
R_V817  N_C0_101  nV_817  7.129146e+02m  TC=0,0
L_V817  nV_817  N_C0_104  5.354537e+01uH
R_V818  N_C0_101  nV_818  7.057741e+00m  TC=0,0
L_V818  nV_818  N_C0_104  1.143710e+01uH
R_V819  N_C0_101  nV_819  3.021354e+01m  TC=0,0
L_V819  nV_819  N_C0_104  1.697490e+02uH
* *  Node  N_C0_101  to  Node  NTMP0000000019
R_R274  N_C0_101  NTMP0000000019  7.295765e+06m  TC=0,0
R_V820  N_C0_101  nV_820  -7.333293e+04m  TC=0,0
L_V820  nV_820  NTMP0000000019  -5.507867e+03uH
R_V821  N_C0_101  nV_821  4.745527e+03m  TC=0,0
L_V821  nV_821  NTMP0000000019  7.690147e+03uH
R_V822  N_C0_101  nV_822  -4.528203e+03m  TC=0,0
L_V822  nV_822  NTMP0000000019  -2.544084e+04uH
* *  Node  N_C0_101  to  Node  N_C0_105
R_R275  N_C0_101  N_C0_105  6.021179e+06m  TC=0,0
R_V823  N_C0_101  nV_823  -1.969899e+04m  TC=0,0
L_V823  nV_823  N_C0_105  -1.479545e+03uH
R_V824  N_C0_101  nV_824  3.554853e+02m  TC=0,0
L_V824  nV_824  N_C0_105  5.760654e+02uH
R_V825  N_C0_101  nV_825  -9.000260e+02m  TC=0,0
L_V825  nV_825  N_C0_105  -5.056623e+03uH
* *  Node  N_C0_101  to  Node  NTMP0000000021
R_R276  N_C0_101  NTMP0000000021  5.607142e+06m  TC=0,0
R_V826  N_C0_101  nV_826  -8.663368e+03m  TC=0,0
L_V826  nV_826  NTMP0000000021  -6.506856e+02uH
R_V827  N_C0_101  nV_827  -2.905729e+02m  TC=0,0
L_V827  nV_827  NTMP0000000021  -4.708746e+02uH
R_V828  N_C0_101  nV_828  2.657209e+02m  TC=0,0
L_V828  nV_828  NTMP0000000021  1.492902e+03uH
* *  Node  N_C0_101  to  Node  N_C0_106
R_R277  N_C0_101  N_C0_106  -1.768950e+07m  TC=0,0
R_V829  N_C0_101  nV_829  -3.095026e+04m  TC=0,0
L_V829  nV_829  N_C0_106  -2.324602e+03uH
R_V830  N_C0_101  nV_830  2.421919e+02m  TC=0,0
L_V830  nV_830  N_C0_106  3.924730e+02uH
R_V831  N_C0_101  nV_831  -4.228919e+02m  TC=0,0
L_V831  nV_831  N_C0_106  -2.375937e+03uH
* *  Node  N_C0_101  to  Node  N_C0_107
R_R278  N_C0_101  N_C0_107  -7.756465e+06m  TC=0,0
R_V832  N_C0_101  nV_832  5.608108e+05m  TC=0,0
L_V832  nV_832  N_C0_107  4.212121e+04uH
R_V833  N_C0_101  nV_833  -1.737077e+05m  TC=0,0
L_V833  nV_833  N_C0_107  -2.814940e+05uH
R_V834  N_C0_101  nV_834  9.596580e+05m  TC=0,0
L_V834  nV_834  N_C0_107  5.391654e+06uH
* *  Node  N_C0_101  to  Node  N_C0_108
R_R279  N_C0_101  N_C0_108  -4.937618e+06m  TC=0,0
R_V835  N_C0_101  nV_835  -1.174604e+04m  TC=0,0
L_V835  nV_835  N_C0_108  -8.822177e+02uH
R_V836  N_C0_101  nV_836  -1.383997e+02m  TC=0,0
L_V836  nV_836  N_C0_108  -2.242772e+02uH
R_V837  N_C0_101  nV_837  1.438660e+02m  TC=0,0
L_V837  nV_837  N_C0_108  8.082837e+02uH
* *  Node  N_C0_101  to  Node  N_C0_109
R_R280  N_C0_101  N_C0_109  -4.335380e+06m  TC=0,0
R_V838  N_C0_101  nV_838  -3.190554e+04m  TC=0,0
L_V838  nV_838  N_C0_109  -2.396351e+03uH
R_V839  N_C0_101  nV_839  -4.579652e+02m  TC=0,0
L_V839  nV_839  N_C0_109  -7.421346e+02uH
R_V840  N_C0_101  nV_840  4.282007e+02m  TC=0,0
L_V840  nV_840  N_C0_109  2.405763e+03uH
* *  Node  N_C0_101  to  Node  N_C0_110
R_R281  N_C0_101  N_C0_110  2.811878e+06m  TC=0,0
R_V841  N_C0_101  nV_841  1.636168e+04m  TC=0,0
L_V841  nV_841  N_C0_110  1.228888e+03uH
R_V842  N_C0_101  nV_842  3.757299e+02m  TC=0,0
L_V842  nV_842  N_C0_110  6.088719e+02uH
R_V843  N_C0_101  nV_843  -3.506484e+02m  TC=0,0
L_V843  nV_843  N_C0_110  -1.970051e+03uH
* *  Node  N_C0_101  to  Node  NTMP0000000028
R_R282  N_C0_101  NTMP0000000028  7.264238e+06m  TC=0,0
R_V844  N_C0_101  nV_844  8.097978e+04m  TC=0,0
L_V844  nV_844  NTMP0000000028  6.082204e+03uH
R_V845  N_C0_101  nV_845  1.186549e+04m  TC=0,0
L_V845  nV_845  NTMP0000000028  1.922807e+04uH
R_V846  N_C0_101  nV_846  -9.688848e+03m  TC=0,0
L_V846  nV_846  NTMP0000000028  -5.443493e+04uH
* *  Node  N_C0_101  to  Node  N_C0_111
R_R283  N_C0_101  N_C0_111  8.693442e+06m  TC=0,0
R_V847  N_C0_101  nV_847  -2.625773e+05m  TC=0,0
L_V847  nV_847  N_C0_111  -1.972158e+04uH
R_V848  N_C0_101  nV_848  -1.267550e+03m  TC=0,0
L_V848  nV_848  N_C0_111  -2.054070e+03uH
R_V849  N_C0_101  nV_849  1.212522e+03m  TC=0,0
L_V849  nV_849  N_C0_111  6.812319e+03uH
* *  Node  N_C0_101  to  Node  NTMP0000000030
R_R284  N_C0_101  NTMP0000000030  6.857919e+06m  TC=0,0
R_V850  N_C0_101  nV_850  -3.602851e+04m  TC=0,0
L_V850  nV_850  NTMP0000000030  -2.706018e+03uH
R_V851  N_C0_101  nV_851  -6.686750e+02m  TC=0,0
L_V851  nV_851  NTMP0000000030  -1.083591e+03uH
R_V852  N_C0_101  nV_852  6.207257e+02m  TC=0,0
L_V852  nV_852  NTMP0000000030  3.487428e+03uH
* *  Node  N_C0_101  to  Node  N_C0_112
R_R285  N_C0_101  N_C0_112  -5.994472e+06m  TC=0,0
R_V853  N_C0_101  nV_853  4.691705e+04m  TC=0,0
L_V853  nV_853  N_C0_112  3.523831e+03uH
R_V854  N_C0_101  nV_854  3.289167e+03m  TC=0,0
L_V854  nV_854  N_C0_112  5.330109e+03uH
R_V855  N_C0_101  nV_855  -2.958543e+03m  TC=0,0
L_V855  nV_855  N_C0_112  -1.662200e+04uH
* *  Node  N_C0_101  to  Node  N_BUS_2
R_R286  N_C0_101  N_BUS_2  -8.715081e+06m  TC=0,0
R_V856  N_C0_101  nV_856  1.339941e+05m  TC=0,0
L_V856  nV_856  N_BUS_2  1.006399e+04uH
R_V857  N_C0_101  nV_857  5.316160e+03m  TC=0,0
L_V857  nV_857  N_BUS_2  8.614860e+03uH
R_V858  N_C0_101  nV_858  -5.032271e+03m  TC=0,0
L_V858  nV_858  N_BUS_2  -2.827285e+04uH
* *  Node  N_C0_101  to  Node  N_C0_114
R_R287  N_C0_101  N_C0_114  3.444412e+06m  TC=0,0
R_V859  N_C0_101  nV_859  5.742034e+03m  TC=0,0
L_V859  nV_859  N_C0_114  4.312709e+02uH
R_V860  N_C0_101  nV_860  -6.142166e+01m  TC=0,0
L_V860  nV_860  N_C0_114  -9.953406e+01uH
R_V861  N_C0_101  nV_861  1.025613e+02m  TC=0,0
L_V861  nV_861  N_C0_114  5.762209e+02uH
* *  Node  N_C0_101  to  Node  N_C0_115
R_R288  N_C0_101  N_C0_115  4.530674e+06m  TC=0,0
R_V862  N_C0_101  nV_862  7.302953e+03m  TC=0,0
L_V862  nV_862  N_C0_115  5.485079e+02uH
R_V863  N_C0_101  nV_863  -9.082448e+01m  TC=0,0
L_V863  nV_863  N_C0_115  -1.471815e+02uH
R_V864  N_C0_101  nV_864  1.636792e+02m  TC=0,0
L_V864  nV_864  N_C0_115  9.196001e+02uH
* *  Node  N_C0_101  to  Node  N_C0_116
R_R289  N_C0_101  N_C0_116  1.279869e+06m  TC=0,0
R_V865  N_C0_101  nV_865  1.955138e+03m  TC=0,0
L_V865  nV_865  N_C0_116  1.468459e+02uH
R_V866  N_C0_101  nV_866  -3.309389e+01m  TC=0,0
L_V866  nV_866  N_C0_116  -5.362879e+01uH
R_V867  N_C0_101  nV_867  1.286739e+00m  TC=0,0
L_V867  nV_867  N_C0_116  7.229293e+00uH
* *  Node  N_C0_101  to  Node  N_C0_117
R_R290  N_C0_101  N_C0_117  3.001357e+06m  TC=0,0
R_V868  N_C0_101  nV_868  5.628638e+03m  TC=0,0
L_V868  nV_868  N_C0_117  4.227540e+02uH
R_V869  N_C0_101  nV_869  -6.062815e+01m  TC=0,0
L_V869  nV_869  N_C0_117  -9.824817e+01uH
R_V870  N_C0_101  nV_870  1.002538e+02m  TC=0,0
L_V870  nV_870  N_C0_117  5.632567e+02uH
* *  Node  N_C0_101  to  Node  N_C0_118
R_R291  N_C0_101  N_C0_118  6.097149e+06m  TC=0,0
R_V871  N_C0_101  nV_871  1.272828e+04m  TC=0,0
L_V871  nV_871  N_C0_118  9.559920e+02uH
R_V872  N_C0_101  nV_872  -1.435177e+02m  TC=0,0
L_V872  nV_872  N_C0_118  -2.325710e+02uH
R_V873  N_C0_101  nV_873  2.629433e+02m  TC=0,0
L_V873  nV_873  N_C0_118  1.477296e+03uH
* *  Node  N_C0_101  to  Node  N_C0_119
R_R292  N_C0_101  N_C0_119  3.004214e+06m  TC=0,0
R_V874  N_C0_101  nV_874  9.356313e+03m  TC=0,0
L_V874  nV_874  N_C0_119  7.027310e+02uH
R_V875  N_C0_101  nV_875  -9.170703e+01m  TC=0,0
L_V875  nV_875  N_C0_119  -1.486116e+02uH
R_V876  N_C0_101  nV_876  1.534686e+02m  TC=0,0
L_V876  nV_876  N_C0_119  8.622336e+02uH
* *  Node  N_C0_101  to  Node  N_C0_120
R_R293  N_C0_101  N_C0_120  1.417244e+07m  TC=0,0
R_V877  N_C0_101  nV_877  2.276715e+04m  TC=0,0
L_V877  nV_877  N_C0_120  1.709988e+03uH
R_V878  N_C0_101  nV_878  -2.876212e+02m  TC=0,0
L_V878  nV_878  N_C0_120  -4.660914e+02uH
R_V879  N_C0_101  nV_879  5.547218e+02m  TC=0,0
L_V879  nV_879  N_C0_120  3.116598e+03uH
* *  Node  N_C0_101  to  Node  N_C0_121
R_R294  N_C0_101  N_C0_121  8.347495e+06m  TC=0,0
R_V880  N_C0_101  nV_880  2.170561e+04m  TC=0,0
L_V880  nV_880  N_C0_121  1.630258e+03uH
R_V881  N_C0_101  nV_881  -2.611189e+02m  TC=0,0
L_V881  nV_881  N_C0_121  -4.231443e+02uH
R_V882  N_C0_101  nV_882  4.915716e+02m  TC=0,0
L_V882  nV_882  N_C0_121  2.761801e+03uH
* *  Node  N_C0_101  to  Node  N_BUS_GND
R_R295  N_C0_101  N_BUS_GND  1.232050e+07m  TC=0,0
R_V883  N_C0_101  nV_883  1.270664e+04m  TC=0,0
L_V883  nV_883  N_BUS_GND  9.543665e+02uH
R_V884  N_C0_101  nV_884  1.341946e+02m  TC=0,0
L_V884  nV_884  N_BUS_GND  2.174630e+02uH
R_V885  N_C0_101  nV_885  -1.395803e+02m  TC=0,0
L_V885  nV_885  N_BUS_GND  -7.842052e+02uH
*  Node  N_C0_102  to other nodes
* *  Node  N_C0_102  to  Node  N_C0_103
R_R296  N_C0_102  N_C0_103  1.272902e+06m  TC=0,0
R_V886  N_C0_102  nV_886  7.433032e+02m  TC=0,0
L_V886  nV_886  N_C0_103  5.582779e+01uH
R_V887  N_C0_102  nV_887  7.119167e+00m  TC=0,0
L_V887  nV_887  N_C0_103  1.153664e+01uH
R_V888  N_C0_102  nV_888  1.619122e+01m  TC=0,0
L_V888  nV_888  N_C0_103  9.096724e+01uH
* *  Node  N_C0_102  to  Node  N_C0_104
R_R297  N_C0_102  N_C0_104  8.113788e+06m  TC=0,0
R_V889  N_C0_102  nV_889  -2.817115e+03m  TC=0,0
L_V889  nV_889  N_C0_104  -2.115870e+02uH
R_V890  N_C0_102  nV_890  -1.650660e+02m  TC=0,0
L_V890  nV_890  N_C0_104  -2.674902e+02uH
R_V891  N_C0_102  nV_891  1.053304e+02m  TC=0,0
L_V891  nV_891  N_C0_104  5.917785e+02uH
* *  Node  N_C0_102  to  Node  NTMP0000000019
R_R298  N_C0_102  NTMP0000000019  1.188895e+06m  TC=0,0
R_V892  N_C0_102  nV_892  7.064114e+02m  TC=0,0
L_V892  nV_892  NTMP0000000019  5.305692e+01uH
R_V893  N_C0_102  nV_893  6.826699e+00m  TC=0,0
L_V893  nV_893  NTMP0000000019  1.106269e+01uH
R_V894  N_C0_102  nV_894  1.809292e+01m  TC=0,0
L_V894  nV_894  NTMP0000000019  1.016516e+02uH
* *  Node  N_C0_102  to  Node  N_C0_105
R_R299  N_C0_102  N_C0_105  2.007494e+07m  TC=0,0
R_V895  N_C0_102  nV_895  -5.342318e+03m  TC=0,0
L_V895  nV_895  N_C0_105  -4.012491e+02uH
R_V896  N_C0_102  nV_896  2.265713e+02m  TC=0,0
L_V896  nV_896  N_C0_105  3.671598e+02uH
R_V897  N_C0_102  nV_897  -7.027229e+02m  TC=0,0
L_V897  nV_897  N_C0_105  -3.948113e+03uH
* *  Node  N_C0_102  to  Node  NTMP0000000021
R_R300  N_C0_102  NTMP0000000021  1.374148e+07m  TC=0,0
R_V898  N_C0_102  nV_898  -9.211273e+03m  TC=0,0
L_V898  nV_898  NTMP0000000021  -6.918374e+02uH
R_V899  N_C0_102  nV_899  2.187943e+03m  TC=0,0
L_V899  nV_899  NTMP0000000021  3.545571e+03uH
R_V900  N_C0_102  nV_900  -2.329169e+03m  TC=0,0
L_V900  nV_900  NTMP0000000021  -1.308599e+04uH
* *  Node  N_C0_102  to  Node  N_C0_106
R_R301  N_C0_102  N_C0_106  1.162281e+07m  TC=0,0
R_V901  N_C0_102  nV_901  -7.407124e+03m  TC=0,0
L_V901  nV_901  N_C0_106  -5.563320e+02uH
R_V902  N_C0_102  nV_902  1.264546e+03m  TC=0,0
L_V902  nV_902  N_C0_106  2.049201e+03uH
R_V903  N_C0_102  nV_903  7.637418e+02m  TC=0,0
L_V903  nV_903  N_C0_106  4.290936e+03uH
* *  Node  N_C0_102  to  Node  N_C0_107
R_R302  N_C0_102  N_C0_107  -6.244156e+07m  TC=0,0
R_V904  N_C0_102  nV_904  -8.145510e+04m  TC=0,0
L_V904  nV_904  N_C0_107  -6.117904e+03uH
R_V905  N_C0_102  nV_905  -4.636456e+02m  TC=0,0
L_V905  nV_905  N_C0_107  -7.513396e+02uH
R_V906  N_C0_102  nV_906  4.381260e+02m  TC=0,0
L_V906  nV_906  N_C0_107  2.461527e+03uH
* *  Node  N_C0_102  to  Node  N_C0_108
R_R303  N_C0_102  N_C0_108  3.190391e+07m  TC=0,0
R_V907  N_C0_102  nV_907  -2.102040e+03m  TC=0,0
L_V907  nV_907  N_C0_108  -1.578794e+02uH
R_V908  N_C0_102  nV_908  -4.516451e+01m  TC=0,0
L_V908  nV_908  N_C0_108  -7.318928e+01uH
R_V909  N_C0_102  nV_909  4.336518e+01m  TC=0,0
L_V909  nV_909  N_C0_108  2.436389e+02uH
* *  Node  N_C0_102  to  Node  N_C0_109
R_R304  N_C0_102  N_C0_109  8.443497e+05m  TC=0,0
R_V910  N_C0_102  nV_910  1.264846e+03m  TC=0,0
L_V910  nV_910  N_C0_109  9.499962e+01uH
R_V911  N_C0_102  nV_911  2.901258e+01m  TC=0,0
L_V911  nV_911  N_C0_109  4.701501e+01uH
R_V912  N_C0_102  nV_912  -2.693255e+01m  TC=0,0
L_V912  nV_912  N_C0_109  -1.513154e+02uH
* *  Node  N_C0_102  to  Node  N_C0_110
R_R305  N_C0_102  N_C0_110  -1.765496e+07m  TC=0,0
R_V913  N_C0_102  nV_913  -7.522572e+03m  TC=0,0
L_V913  nV_913  N_C0_110  -5.650030e+02uH
R_V914  N_C0_102  nV_914  -1.122133e+02m  TC=0,0
L_V914  nV_914  N_C0_110  -1.818422e+02uH
R_V915  N_C0_102  nV_915  1.064058e+02m  TC=0,0
L_V915  nV_915  N_C0_110  5.978207e+02uH
* *  Node  N_C0_102  to  Node  NTMP0000000028
R_R306  N_C0_102  NTMP0000000028  4.740318e+06m  TC=0,0
R_V916  N_C0_102  nV_916  -5.034550e+03m  TC=0,0
L_V916  nV_916  NTMP0000000028  -3.781334e+02uH
R_V917  N_C0_102  nV_917  -1.258559e+02m  TC=0,0
L_V917  nV_917  NTMP0000000028  -2.039500e+02uH
R_V918  N_C0_102  nV_918  1.151434e+02m  TC=0,0
L_V918  nV_918  NTMP0000000028  6.469112e+02uH
* *  Node  N_C0_102  to  Node  N_C0_111
R_R307  N_C0_102  N_C0_111  -2.699096e+07m  TC=0,0
R_V919  N_C0_102  nV_919  3.800561e+04m  TC=0,0
L_V919  nV_919  N_C0_111  2.854514e+03uH
R_V920  N_C0_102  nV_920  -9.618488e+02m  TC=0,0
L_V920  nV_920  N_C0_111  -1.558680e+03uH
R_V921  N_C0_102  nV_921  8.864071e+02m  TC=0,0
L_V921  nV_921  N_C0_111  4.980108e+03uH
* *  Node  N_C0_102  to  Node  NTMP0000000030
R_R308  N_C0_102  NTMP0000000030  1.321743e+07m  TC=0,0
R_V922  N_C0_102  nV_922  2.159996e+04m  TC=0,0
L_V922  nV_922  NTMP0000000030  1.622323e+03uH
R_V923  N_C0_102  nV_923  3.796074e+03m  TC=0,0
L_V923  nV_923  NTMP0000000030  6.151555e+03uH
R_V924  N_C0_102  nV_924  -3.181477e+03m  TC=0,0
L_V924  nV_924  NTMP0000000030  -1.787451e+04uH
* *  Node  N_C0_102  to  Node  N_C0_112
R_R309  N_C0_102  N_C0_112  2.029817e+07m  TC=0,0
R_V925  N_C0_102  nV_925  4.638546e+05m  TC=0,0
L_V925  nV_925  N_C0_112  3.483905e+04uH
R_V926  N_C0_102  nV_926  -2.182957e+02m  TC=0,0
L_V926  nV_926  N_C0_112  -3.537491e+02uH
R_V927  N_C0_102  nV_927  2.124220e+02m  TC=0,0
L_V927  nV_927  N_C0_112  1.193452e+03uH
* *  Node  N_C0_102  to  Node  N_BUS_2
R_R310  N_C0_102  N_BUS_2  -2.679265e+08m  TC=0,0
R_V928  N_C0_102  nV_928  1.280192e+04m  TC=0,0
L_V928  nV_928  N_BUS_2  9.615225e+02uH
R_V929  N_C0_102  nV_929  9.062170e+02m  TC=0,0
L_V929  nV_929  N_BUS_2  1.468529e+03uH
R_V930  N_C0_102  nV_930  -8.006097e+02m  TC=0,0
L_V930  nV_930  N_BUS_2  -4.498071e+03uH
* *  Node  N_C0_102  to  Node  N_C0_114
R_R311  N_C0_102  N_C0_114  5.450865e+06m  TC=0,0
R_V931  N_C0_102  nV_931  9.687524e+03m  TC=0,0
L_V931  nV_931  N_C0_114  7.276076e+02uH
R_V932  N_C0_102  nV_932  -9.164960e+01m  TC=0,0
L_V932  nV_932  N_C0_114  -1.485186e+02uH
R_V933  N_C0_102  nV_933  1.534051e+02m  TC=0,0
L_V933  nV_933  N_C0_114  8.618769e+02uH
* *  Node  N_C0_102  to  Node  N_C0_115
R_R312  N_C0_102  N_C0_115  9.533217e+06m  TC=0,0
R_V934  N_C0_102  nV_934  1.956077e+04m  TC=0,0
L_V934  nV_934  N_C0_115  1.469165e+03uH
R_V935  N_C0_102  nV_935  -1.563351e+02m  TC=0,0
L_V935  nV_935  N_C0_115  -2.533417e+02uH
R_V936  N_C0_102  nV_936  2.857824e+02m  TC=0,0
L_V936  nV_936  N_C0_115  1.605613e+03uH
* *  Node  N_C0_102  to  Node  N_C0_116
R_R313  N_C0_102  N_C0_116  1.075741e+07m  TC=0,0
R_V937  N_C0_102  nV_937  1.355942e+04m  TC=0,0
L_V937  nV_937  N_C0_116  1.018417e+03uH
R_V938  N_C0_102  nV_938  -1.434141e+02m  TC=0,0
L_V938  nV_938  N_C0_116  -2.324032e+02uH
R_V939  N_C0_102  nV_939  2.628383e+02m  TC=0,0
L_V939  nV_939  N_C0_116  1.476706e+03uH
* *  Node  N_C0_102  to  Node  N_C0_117
R_R314  N_C0_102  N_C0_117  1.453717e+07m  TC=0,0
R_V940  N_C0_102  nV_940  2.450576e+04m  TC=0,0
L_V940  nV_940  N_C0_117  1.840571e+03uH
R_V941  N_C0_102  nV_941  -1.985261e+02m  TC=0,0
L_V941  nV_941  N_C0_117  -3.217124e+02uH
R_V942  N_C0_102  nV_942  3.868078e+02m  TC=0,0
L_V942  nV_942  N_C0_117  2.173205e+03uH
* *  Node  N_C0_102  to  Node  N_C0_118
R_R315  N_C0_102  N_C0_118  1.454845e+06m  TC=0,0
R_V943  N_C0_102  nV_943  1.910577e+03m  TC=0,0
L_V943  nV_943  N_C0_118  1.434990e+02uH
R_V944  N_C0_102  nV_944  -3.087566e+01m  TC=0,0
L_V944  nV_944  N_C0_118  -5.003414e+01uH
R_V945  N_C0_102  nV_945  1.282977e+00m  TC=0,0
L_V945  nV_945  N_C0_118  7.208162e+00uH
* *  Node  N_C0_102  to  Node  N_C0_119
R_R316  N_C0_102  N_C0_119  1.299098e+07m  TC=0,0
R_V946  N_C0_102  nV_946  1.070980e+04m  TC=0,0
L_V946  nV_946  N_C0_119  8.043880e+02uH
R_V947  N_C0_102  nV_947  -1.577758e+02m  TC=0,0
L_V947  nV_947  N_C0_119  -2.556763e+02uH
R_V948  N_C0_102  nV_948  2.760164e+02m  TC=0,0
L_V948  nV_948  N_C0_119  1.550745e+03uH
* *  Node  N_C0_102  to  Node  N_C0_120
R_R317  N_C0_102  N_C0_120  1.070728e+07m  TC=0,0
R_V949  N_C0_102  nV_949  1.146543e+04m  TC=0,0
L_V949  nV_949  N_C0_120  8.611423e+02uH
R_V950  N_C0_102  nV_950  -1.452677e+02m  TC=0,0
L_V950  nV_950  N_C0_120  -2.354069e+02uH
R_V951  N_C0_102  nV_951  2.370562e+02m  TC=0,0
L_V951  nV_951  N_C0_120  1.331855e+03uH
* *  Node  N_C0_102  to  Node  N_C0_121
R_R318  N_C0_102  N_C0_121  2.182582e+07m  TC=0,0
R_V952  N_C0_102  nV_952  1.435119e+04m  TC=0,0
L_V952  nV_952  N_C0_121  1.077884e+03uH
R_V953  N_C0_102  nV_953  -2.177563e+02m  TC=0,0
L_V953  nV_953  N_C0_121  -3.528750e+02uH
R_V954  N_C0_102  nV_954  3.745709e+02m  TC=0,0
L_V954  nV_954  N_C0_121  2.104455e+03uH
* *  Node  N_C0_102  to  Node  N_BUS_GND
R_R319  N_C0_102  N_BUS_GND  1.916526e+07m  TC=0,0
R_V955  N_C0_102  nV_955  1.287968e+04m  TC=0,0
L_V955  nV_955  N_BUS_GND  9.673626e+02uH
R_V956  N_C0_102  nV_956  1.003194e+02m  TC=0,0
L_V956  nV_956  N_BUS_GND  1.625680e+02uH
R_V957  N_C0_102  nV_957  -1.033266e+02m  TC=0,0
L_V957  nV_957  N_BUS_GND  -5.805206e+02uH
*  Node  N_C0_103  to other nodes
* *  Node  N_C0_103  to  Node  N_C0_104
R_R320  N_C0_103  N_C0_104  1.272902e+06m  TC=0,0
R_V958  N_C0_103  nV_958  7.433032e+02m  TC=0,0
L_V958  nV_958  N_C0_104  5.582779e+01uH
R_V959  N_C0_103  nV_959  7.119167e+00m  TC=0,0
L_V959  nV_959  N_C0_104  1.153664e+01uH
R_V960  N_C0_103  nV_960  1.619122e+01m  TC=0,0
L_V960  nV_960  N_C0_104  9.096724e+01uH
* *  Node  N_C0_103  to  Node  NTMP0000000019
R_R321  N_C0_103  NTMP0000000019  1.460498e+07m  TC=0,0
R_V961  N_C0_103  nV_961  -1.547505e+04m  TC=0,0
L_V961  nV_961  NTMP0000000019  -1.162295e+03uH
R_V962  N_C0_103  nV_962  -1.781347e+03m  TC=0,0
L_V962  nV_962  NTMP0000000019  -2.886681e+03uH
R_V963  N_C0_103  nV_963  1.550818e+03m  TC=0,0
L_V963  nV_963  NTMP0000000019  8.712971e+03uH
* *  Node  N_C0_103  to  Node  N_C0_105
R_R322  N_C0_103  N_C0_105  2.517160e+07m  TC=0,0
R_V964  N_C0_103  nV_964  -2.421304e+04m  TC=0,0
L_V964  nV_964  N_C0_105  -1.818586e+03uH
R_V965  N_C0_103  nV_965  -6.772813e+02m  TC=0,0
L_V965  nV_965  N_C0_105  -1.097537e+03uH
R_V966  N_C0_103  nV_966  6.214576e+02m  TC=0,0
L_V966  nV_966  N_C0_105  3.491540e+03uH
* *  Node  N_C0_103  to  Node  NTMP0000000021
R_R323  N_C0_103  NTMP0000000021  1.460498e+07m  TC=0,0
R_V967  N_C0_103  nV_967  -1.547505e+04m  TC=0,0
L_V967  nV_967  NTMP0000000021  -1.162295e+03uH
R_V968  N_C0_103  nV_968  -1.781347e+03m  TC=0,0
L_V968  nV_968  NTMP0000000021  -2.886681e+03uH
R_V969  N_C0_103  nV_969  1.550818e+03m  TC=0,0
L_V969  nV_969  NTMP0000000021  8.712971e+03uH
* *  Node  N_C0_103  to  Node  N_C0_106
R_R324  N_C0_103  N_C0_106  2.517160e+07m  TC=0,0
R_V970  N_C0_103  nV_970  -2.421304e+04m  TC=0,0
L_V970  nV_970  N_C0_106  -1.818586e+03uH
R_V971  N_C0_103  nV_971  -6.772813e+02m  TC=0,0
L_V971  nV_971  N_C0_106  -1.097537e+03uH
R_V972  N_C0_103  nV_972  6.214576e+02m  TC=0,0
L_V972  nV_972  N_C0_106  3.491540e+03uH
* *  Node  N_C0_103  to  Node  N_C0_107
R_R325  N_C0_103  N_C0_107  2.944399e+07m  TC=0,0
R_V973  N_C0_103  nV_973  -5.551341e+04m  TC=0,0
L_V973  nV_973  N_C0_107  -4.169483e+03uH
R_V974  N_C0_103  nV_974  -1.187374e+03m  TC=0,0
L_V974  nV_974  N_C0_107  -1.924145e+03uH
R_V975  N_C0_103  nV_975  1.058031e+03m  TC=0,0
L_V975  nV_975  N_C0_107  5.944344e+03uH
* *  Node  N_C0_103  to  Node  N_C0_108
R_R326  N_C0_103  N_C0_108  3.337697e+05m  TC=0,0
R_V976  N_C0_103  nV_976  8.977524e+01m  TC=0,0
L_V976  nV_976  N_C0_108  6.742811e+00uH
R_V977  N_C0_103  nV_977  1.341474e+00m  TC=0,0
L_V977  nV_977  N_C0_108  2.173864e+00uH
R_V978  N_C0_103  nV_978  2.237571e+01m  TC=0,0
L_V978  nV_978  N_C0_108  1.257136e+02uH
* *  Node  N_C0_103  to  Node  N_C0_109
R_R327  N_C0_103  N_C0_109  3.244195e+06m  TC=0,0
R_V979  N_C0_103  nV_979  -4.690319e+03m  TC=0,0
L_V979  nV_979  N_C0_109  -3.522791e+02uH
R_V980  N_C0_103  nV_980  -1.380090e+02m  TC=0,0
L_V980  nV_980  N_C0_109  -2.236442e+02uH
R_V981  N_C0_103  nV_981  1.268524e+02m  TC=0,0
L_V981  nV_981  N_C0_109  7.126960e+02uH
* *  Node  N_C0_103  to  Node  N_C0_110
R_R328  N_C0_103  N_C0_110  3.244195e+06m  TC=0,0
R_V982  N_C0_103  nV_982  -4.690319e+03m  TC=0,0
L_V982  nV_982  N_C0_110  -3.522791e+02uH
R_V983  N_C0_103  nV_983  -1.380090e+02m  TC=0,0
L_V983  nV_983  N_C0_110  -2.236442e+02uH
R_V984  N_C0_103  nV_984  1.268524e+02m  TC=0,0
L_V984  nV_984  N_C0_110  7.126960e+02uH
* *  Node  N_C0_103  to  Node  NTMP0000000028
R_R329  N_C0_103  NTMP0000000028  1.419857e+07m  TC=0,0
R_V985  N_C0_103  nV_985  -1.868143e+04m  TC=0,0
L_V985  nV_985  NTMP0000000028  -1.403119e+03uH
R_V986  N_C0_103  nV_986  -7.018740e+02m  TC=0,0
L_V986  nV_986  NTMP0000000028  -1.137390e+03uH
R_V987  N_C0_103  nV_987  6.257037e+02m  TC=0,0
L_V987  nV_987  NTMP0000000028  3.515396e+03uH
* *  Node  N_C0_103  to  Node  N_C0_111
R_R330  N_C0_103  N_C0_111  4.526643e+07m  TC=0,0
R_V988  N_C0_103  nV_988  -4.441312e+04m  TC=0,0
L_V988  nV_988  N_C0_111  -3.335767e+03uH
R_V989  N_C0_103  nV_989  -5.053746e+02m  TC=0,0
L_V989  nV_989  N_C0_111  -8.189618e+02uH
R_V990  N_C0_103  nV_990  4.707743e+02m  TC=0,0
L_V990  nV_990  N_C0_111  2.644955e+03uH
* *  Node  N_C0_103  to  Node  NTMP0000000030
R_R331  N_C0_103  NTMP0000000030  1.419857e+07m  TC=0,0
R_V991  N_C0_103  nV_991  -1.868143e+04m  TC=0,0
L_V991  nV_991  NTMP0000000030  -1.403119e+03uH
R_V992  N_C0_103  nV_992  -7.018740e+02m  TC=0,0
L_V992  nV_992  NTMP0000000030  -1.137390e+03uH
R_V993  N_C0_103  nV_993  6.257037e+02m  TC=0,0
L_V993  nV_993  NTMP0000000030  3.515396e+03uH
* *  Node  N_C0_103  to  Node  N_C0_112
R_R332  N_C0_103  N_C0_112  4.526643e+07m  TC=0,0
R_V994  N_C0_103  nV_994  -4.441312e+04m  TC=0,0
L_V994  nV_994  N_C0_112  -3.335767e+03uH
R_V995  N_C0_103  nV_995  -5.053746e+02m  TC=0,0
L_V995  nV_995  N_C0_112  -8.189618e+02uH
R_V996  N_C0_103  nV_996  4.707743e+02m  TC=0,0
L_V996  nV_996  N_C0_112  2.644955e+03uH
* *  Node  N_C0_103  to  Node  N_BUS_2
R_R333  N_C0_103  N_BUS_2  1.850793e+07m  TC=0,0
R_V997  N_C0_103  nV_997  9.185455e+03m  TC=0,0
L_V997  nV_997  N_BUS_2  6.898983e+02uH
R_V998  N_C0_103  nV_998  4.827174e+02m  TC=0,0
L_V998  nV_998  N_BUS_2  7.822456e+02uH
R_V999  N_C0_103  nV_999  -4.239482e+02m  TC=0,0
L_V999  nV_999  N_BUS_2  -2.381872e+03uH
* *  Node  N_C0_103  to  Node  N_C0_114
R_R334  N_C0_103  N_C0_114  1.026022e+07m  TC=0,0
R_V1000  N_C0_103  nV_1000  6.632503e+04m  TC=0,0
L_V1000  nV_1000  N_C0_114  4.981520e+03uH
R_V1001  N_C0_103  nV_1001  -1.109782e+05m  TC=0,0
L_V1001  nV_1001  N_C0_114  -1.798407e+05uH
R_V1002  N_C0_103  nV_1002  -1.315594e+05m  TC=0,0
L_V1002  nV_1002  N_C0_114  -7.391410e+05uH
* *  Node  N_C0_103  to  Node  N_C0_115
R_R335  N_C0_103  N_C0_115  2.773017e+07m  TC=0,0
R_V1003  N_C0_103  nV_1003  -2.841914e+05m  TC=0,0
L_V1003  nV_1003  N_C0_115  -2.134496e+04uH
R_V1004  N_C0_103  nV_1004  -6.851068e+04m  TC=0,0
L_V1004  nV_1004  N_C0_115  -1.110219e+05uH
R_V1005  N_C0_103  nV_1005  9.939367e+04m  TC=0,0
L_V1005  nV_1005  N_C0_115  5.584242e+05uH
* *  Node  N_C0_103  to  Node  N_C0_116
R_R336  N_C0_103  N_C0_116  1.026022e+07m  TC=0,0
R_V1006  N_C0_103  nV_1006  6.632503e+04m  TC=0,0
L_V1006  nV_1006  N_C0_116  4.981520e+03uH
R_V1007  N_C0_103  nV_1007  -1.109782e+05m  TC=0,0
L_V1007  nV_1007  N_C0_116  -1.798407e+05uH
R_V1008  N_C0_103  nV_1008  -1.315594e+05m  TC=0,0
L_V1008  nV_1008  N_C0_116  -7.391410e+05uH
* *  Node  N_C0_103  to  Node  N_C0_117
R_R337  N_C0_103  N_C0_117  2.773017e+07m  TC=0,0
R_V1009  N_C0_103  nV_1009  -2.841914e+05m  TC=0,0
L_V1009  nV_1009  N_C0_117  -2.134496e+04uH
R_V1010  N_C0_103  nV_1010  -6.851068e+04m  TC=0,0
L_V1010  nV_1010  N_C0_117  -1.110219e+05uH
R_V1011  N_C0_103  nV_1011  9.939367e+04m  TC=0,0
L_V1011  nV_1011  N_C0_117  5.584242e+05uH
* *  Node  N_C0_103  to  Node  N_C0_118
R_R338  N_C0_103  N_C0_118  9.314136e+06m  TC=0,0
R_V1012  N_C0_103  nV_1012  2.761851e+04m  TC=0,0
L_V1012  nV_1012  N_C0_118  2.074362e+03uH
R_V1013  N_C0_103  nV_1013  1.547541e+06m  TC=0,0
L_V1013  nV_1013  N_C0_118  2.507796e+06uH
R_V1014  N_C0_103  nV_1014  -4.033547e+04m  TC=0,0
L_V1014  nV_1014  N_C0_118  -2.266171e+05uH
* *  Node  N_C0_103  to  Node  N_C0_119
R_R339  N_C0_103  N_C0_119  9.314136e+06m  TC=0,0
R_V1015  N_C0_103  nV_1015  2.761851e+04m  TC=0,0
L_V1015  nV_1015  N_C0_119  2.074362e+03uH
R_V1016  N_C0_103  nV_1016  1.547541e+06m  TC=0,0
L_V1016  nV_1016  N_C0_119  2.507796e+06uH
R_V1017  N_C0_103  nV_1017  -4.033547e+04m  TC=0,0
L_V1017  nV_1017  N_C0_119  -2.266171e+05uH
* *  Node  N_C0_103  to  Node  N_C0_120
R_R340  N_C0_103  N_C0_120  3.652782e+07m  TC=0,0
R_V1018  N_C0_103  nV_1018  8.677139e+04m  TC=0,0
L_V1018  nV_1018  N_C0_120  6.517199e+03uH
R_V1019  N_C0_103  nV_1019  -6.573402e+04m  TC=0,0
L_V1019  nV_1019  N_C0_120  -1.065223e+05uH
R_V1020  N_C0_103  nV_1020  7.663181e+04m  TC=0,0
L_V1020  nV_1020  N_C0_120  4.305411e+05uH
* *  Node  N_C0_103  to  Node  N_C0_121
R_R341  N_C0_103  N_C0_121  3.652782e+07m  TC=0,0
R_V1021  N_C0_103  nV_1021  8.677139e+04m  TC=0,0
L_V1021  nV_1021  N_C0_121  6.517199e+03uH
R_V1022  N_C0_103  nV_1022  -6.573402e+04m  TC=0,0
L_V1022  nV_1022  N_C0_121  -1.065223e+05uH
R_V1023  N_C0_103  nV_1023  7.663181e+04m  TC=0,0
L_V1023  nV_1023  N_C0_121  4.305411e+05uH
* *  Node  N_C0_103  to  Node  N_BUS_GND
R_R342  N_C0_103  N_BUS_GND  8.114874e+06m  TC=0,0
R_V1024  N_C0_103  nV_1024  -1.434013e+04m  TC=0,0
L_V1024  nV_1024  N_BUS_GND  -1.077054e+03uH
R_V1025  N_C0_103  nV_1025  9.786636e+03m  TC=0,0
L_V1025  nV_1025  N_BUS_GND  1.585929e+04uH
R_V1026  N_C0_103  nV_1026  1.318877e+06m  TC=0,0
L_V1026  nV_1026  N_BUS_GND  7.409859e+06uH
*  Node  N_C0_104  to other nodes
* *  Node  N_C0_104  to  Node  NTMP0000000019
R_R343  N_C0_104  NTMP0000000019  1.374148e+07m  TC=0,0
R_V1027  N_C0_104  nV_1027  -9.211273e+03m  TC=0,0
L_V1027  nV_1027  NTMP0000000019  -6.918374e+02uH
R_V1028  N_C0_104  nV_1028  2.187943e+03m  TC=0,0
L_V1028  nV_1028  NTMP0000000019  3.545571e+03uH
R_V1029  N_C0_104  nV_1029  -2.329169e+03m  TC=0,0
L_V1029  nV_1029  NTMP0000000019  -1.308599e+04uH
* *  Node  N_C0_104  to  Node  N_C0_105
R_R344  N_C0_104  N_C0_105  1.162281e+07m  TC=0,0
R_V1030  N_C0_104  nV_1030  -7.407124e+03m  TC=0,0
L_V1030  nV_1030  N_C0_105  -5.563320e+02uH
R_V1031  N_C0_104  nV_1031  1.264546e+03m  TC=0,0
L_V1031  nV_1031  N_C0_105  2.049201e+03uH
R_V1032  N_C0_104  nV_1032  7.637418e+02m  TC=0,0
L_V1032  nV_1032  N_C0_105  4.290936e+03uH
* *  Node  N_C0_104  to  Node  NTMP0000000021
R_R345  N_C0_104  NTMP0000000021  1.188895e+06m  TC=0,0
R_V1033  N_C0_104  nV_1033  7.064114e+02m  TC=0,0
L_V1033  nV_1033  NTMP0000000021  5.305692e+01uH
R_V1034  N_C0_104  nV_1034  6.826699e+00m  TC=0,0
L_V1034  nV_1034  NTMP0000000021  1.106269e+01uH
R_V1035  N_C0_104  nV_1035  1.809292e+01m  TC=0,0
L_V1035  nV_1035  NTMP0000000021  1.016516e+02uH
* *  Node  N_C0_104  to  Node  N_C0_106
R_R346  N_C0_104  N_C0_106  2.007494e+07m  TC=0,0
R_V1036  N_C0_104  nV_1036  -5.342318e+03m  TC=0,0
L_V1036  nV_1036  N_C0_106  -4.012491e+02uH
R_V1037  N_C0_104  nV_1037  2.265713e+02m  TC=0,0
L_V1037  nV_1037  N_C0_106  3.671598e+02uH
R_V1038  N_C0_104  nV_1038  -7.027229e+02m  TC=0,0
L_V1038  nV_1038  N_C0_106  -3.948113e+03uH
* *  Node  N_C0_104  to  Node  N_C0_107
R_R347  N_C0_104  N_C0_107  -6.244156e+07m  TC=0,0
R_V1039  N_C0_104  nV_1039  -8.145510e+04m  TC=0,0
L_V1039  nV_1039  N_C0_107  -6.117904e+03uH
R_V1040  N_C0_104  nV_1040  -4.636456e+02m  TC=0,0
L_V1040  nV_1040  N_C0_107  -7.513396e+02uH
R_V1041  N_C0_104  nV_1041  4.381260e+02m  TC=0,0
L_V1041  nV_1041  N_C0_107  2.461527e+03uH
* *  Node  N_C0_104  to  Node  N_C0_108
R_R348  N_C0_104  N_C0_108  3.190391e+07m  TC=0,0
R_V1042  N_C0_104  nV_1042  -2.102040e+03m  TC=0,0
L_V1042  nV_1042  N_C0_108  -1.578794e+02uH
R_V1043  N_C0_104  nV_1043  -4.516451e+01m  TC=0,0
L_V1043  nV_1043  N_C0_108  -7.318928e+01uH
R_V1044  N_C0_104  nV_1044  4.336518e+01m  TC=0,0
L_V1044  nV_1044  N_C0_108  2.436389e+02uH
* *  Node  N_C0_104  to  Node  N_C0_109
R_R349  N_C0_104  N_C0_109  -1.765496e+07m  TC=0,0
R_V1045  N_C0_104  nV_1045  -7.522572e+03m  TC=0,0
L_V1045  nV_1045  N_C0_109  -5.650030e+02uH
R_V1046  N_C0_104  nV_1046  -1.122133e+02m  TC=0,0
L_V1046  nV_1046  N_C0_109  -1.818422e+02uH
R_V1047  N_C0_104  nV_1047  1.064058e+02m  TC=0,0
L_V1047  nV_1047  N_C0_109  5.978207e+02uH
* *  Node  N_C0_104  to  Node  N_C0_110
R_R350  N_C0_104  N_C0_110  8.443497e+05m  TC=0,0
R_V1048  N_C0_104  nV_1048  1.264846e+03m  TC=0,0
L_V1048  nV_1048  N_C0_110  9.499962e+01uH
R_V1049  N_C0_104  nV_1049  2.901258e+01m  TC=0,0
L_V1049  nV_1049  N_C0_110  4.701501e+01uH
R_V1050  N_C0_104  nV_1050  -2.693255e+01m  TC=0,0
L_V1050  nV_1050  N_C0_110  -1.513154e+02uH
* *  Node  N_C0_104  to  Node  NTMP0000000028
R_R351  N_C0_104  NTMP0000000028  1.321743e+07m  TC=0,0
R_V1051  N_C0_104  nV_1051  2.159996e+04m  TC=0,0
L_V1051  nV_1051  NTMP0000000028  1.622323e+03uH
R_V1052  N_C0_104  nV_1052  3.796074e+03m  TC=0,0
L_V1052  nV_1052  NTMP0000000028  6.151555e+03uH
R_V1053  N_C0_104  nV_1053  -3.181477e+03m  TC=0,0
L_V1053  nV_1053  NTMP0000000028  -1.787451e+04uH
* *  Node  N_C0_104  to  Node  N_C0_111
R_R352  N_C0_104  N_C0_111  2.029817e+07m  TC=0,0
R_V1054  N_C0_104  nV_1054  4.638546e+05m  TC=0,0
L_V1054  nV_1054  N_C0_111  3.483905e+04uH
R_V1055  N_C0_104  nV_1055  -2.182957e+02m  TC=0,0
L_V1055  nV_1055  N_C0_111  -3.537491e+02uH
R_V1056  N_C0_104  nV_1056  2.124220e+02m  TC=0,0
L_V1056  nV_1056  N_C0_111  1.193452e+03uH
* *  Node  N_C0_104  to  Node  NTMP0000000030
R_R353  N_C0_104  NTMP0000000030  4.740318e+06m  TC=0,0
R_V1057  N_C0_104  nV_1057  -5.034550e+03m  TC=0,0
L_V1057  nV_1057  NTMP0000000030  -3.781334e+02uH
R_V1058  N_C0_104  nV_1058  -1.258559e+02m  TC=0,0
L_V1058  nV_1058  NTMP0000000030  -2.039500e+02uH
R_V1059  N_C0_104  nV_1059  1.151434e+02m  TC=0,0
L_V1059  nV_1059  NTMP0000000030  6.469112e+02uH
* *  Node  N_C0_104  to  Node  N_C0_112
R_R354  N_C0_104  N_C0_112  -2.699096e+07m  TC=0,0
R_V1060  N_C0_104  nV_1060  3.800561e+04m  TC=0,0
L_V1060  nV_1060  N_C0_112  2.854514e+03uH
R_V1061  N_C0_104  nV_1061  -9.618488e+02m  TC=0,0
L_V1061  nV_1061  N_C0_112  -1.558680e+03uH
R_V1062  N_C0_104  nV_1062  8.864071e+02m  TC=0,0
L_V1062  nV_1062  N_C0_112  4.980108e+03uH
* *  Node  N_C0_104  to  Node  N_BUS_2
R_R355  N_C0_104  N_BUS_2  -2.679265e+08m  TC=0,0
R_V1063  N_C0_104  nV_1063  1.280192e+04m  TC=0,0
L_V1063  nV_1063  N_BUS_2  9.615225e+02uH
R_V1064  N_C0_104  nV_1064  9.062170e+02m  TC=0,0
L_V1064  nV_1064  N_BUS_2  1.468529e+03uH
R_V1065  N_C0_104  nV_1065  -8.006097e+02m  TC=0,0
L_V1065  nV_1065  N_BUS_2  -4.498071e+03uH
* *  Node  N_C0_104  to  Node  N_C0_114
R_R356  N_C0_104  N_C0_114  1.075741e+07m  TC=0,0
R_V1066  N_C0_104  nV_1066  1.355942e+04m  TC=0,0
L_V1066  nV_1066  N_C0_114  1.018417e+03uH
R_V1067  N_C0_104  nV_1067  -1.434141e+02m  TC=0,0
L_V1067  nV_1067  N_C0_114  -2.324032e+02uH
R_V1068  N_C0_104  nV_1068  2.628383e+02m  TC=0,0
L_V1068  nV_1068  N_C0_114  1.476706e+03uH
* *  Node  N_C0_104  to  Node  N_C0_115
R_R357  N_C0_104  N_C0_115  1.453717e+07m  TC=0,0
R_V1069  N_C0_104  nV_1069  2.450576e+04m  TC=0,0
L_V1069  nV_1069  N_C0_115  1.840571e+03uH
R_V1070  N_C0_104  nV_1070  -1.985261e+02m  TC=0,0
L_V1070  nV_1070  N_C0_115  -3.217124e+02uH
R_V1071  N_C0_104  nV_1071  3.868078e+02m  TC=0,0
L_V1071  nV_1071  N_C0_115  2.173205e+03uH
* *  Node  N_C0_104  to  Node  N_C0_116
R_R358  N_C0_104  N_C0_116  5.450865e+06m  TC=0,0
R_V1072  N_C0_104  nV_1072  9.687524e+03m  TC=0,0
L_V1072  nV_1072  N_C0_116  7.276076e+02uH
R_V1073  N_C0_104  nV_1073  -9.164960e+01m  TC=0,0
L_V1073  nV_1073  N_C0_116  -1.485186e+02uH
R_V1074  N_C0_104  nV_1074  1.534051e+02m  TC=0,0
L_V1074  nV_1074  N_C0_116  8.618769e+02uH
* *  Node  N_C0_104  to  Node  N_C0_117
R_R359  N_C0_104  N_C0_117  9.533217e+06m  TC=0,0
R_V1075  N_C0_104  nV_1075  1.956077e+04m  TC=0,0
L_V1075  nV_1075  N_C0_117  1.469165e+03uH
R_V1076  N_C0_104  nV_1076  -1.563351e+02m  TC=0,0
L_V1076  nV_1076  N_C0_117  -2.533417e+02uH
R_V1077  N_C0_104  nV_1077  2.857824e+02m  TC=0,0
L_V1077  nV_1077  N_C0_117  1.605613e+03uH
* *  Node  N_C0_104  to  Node  N_C0_118
R_R360  N_C0_104  N_C0_118  1.299098e+07m  TC=0,0
R_V1078  N_C0_104  nV_1078  1.070980e+04m  TC=0,0
L_V1078  nV_1078  N_C0_118  8.043880e+02uH
R_V1079  N_C0_104  nV_1079  -1.577758e+02m  TC=0,0
L_V1079  nV_1079  N_C0_118  -2.556763e+02uH
R_V1080  N_C0_104  nV_1080  2.760164e+02m  TC=0,0
L_V1080  nV_1080  N_C0_118  1.550745e+03uH
* *  Node  N_C0_104  to  Node  N_C0_119
R_R361  N_C0_104  N_C0_119  1.454845e+06m  TC=0,0
R_V1081  N_C0_104  nV_1081  1.910577e+03m  TC=0,0
L_V1081  nV_1081  N_C0_119  1.434990e+02uH
R_V1082  N_C0_104  nV_1082  -3.087566e+01m  TC=0,0
L_V1082  nV_1082  N_C0_119  -5.003414e+01uH
R_V1083  N_C0_104  nV_1083  1.282977e+00m  TC=0,0
L_V1083  nV_1083  N_C0_119  7.208162e+00uH
* *  Node  N_C0_104  to  Node  N_C0_120
R_R362  N_C0_104  N_C0_120  2.182582e+07m  TC=0,0
R_V1084  N_C0_104  nV_1084  1.435119e+04m  TC=0,0
L_V1084  nV_1084  N_C0_120  1.077884e+03uH
R_V1085  N_C0_104  nV_1085  -2.177563e+02m  TC=0,0
L_V1085  nV_1085  N_C0_120  -3.528750e+02uH
R_V1086  N_C0_104  nV_1086  3.745709e+02m  TC=0,0
L_V1086  nV_1086  N_C0_120  2.104455e+03uH
* *  Node  N_C0_104  to  Node  N_C0_121
R_R363  N_C0_104  N_C0_121  1.070728e+07m  TC=0,0
R_V1087  N_C0_104  nV_1087  1.146543e+04m  TC=0,0
L_V1087  nV_1087  N_C0_121  8.611423e+02uH
R_V1088  N_C0_104  nV_1088  -1.452677e+02m  TC=0,0
L_V1088  nV_1088  N_C0_121  -2.354069e+02uH
R_V1089  N_C0_104  nV_1089  2.370562e+02m  TC=0,0
L_V1089  nV_1089  N_C0_121  1.331855e+03uH
* *  Node  N_C0_104  to  Node  N_BUS_GND
R_R364  N_C0_104  N_BUS_GND  1.916526e+07m  TC=0,0
R_V1090  N_C0_104  nV_1090  1.287968e+04m  TC=0,0
L_V1090  nV_1090  N_BUS_GND  9.673626e+02uH
R_V1091  N_C0_104  nV_1091  1.003194e+02m  TC=0,0
L_V1091  nV_1091  N_BUS_GND  1.625680e+02uH
R_V1092  N_C0_104  nV_1092  -1.033266e+02m  TC=0,0
L_V1092  nV_1092  N_BUS_GND  -5.805206e+02uH
*  Node  NTMP0000000019  to other nodes
* *  Node  NTMP0000000019  to  Node  N_C0_105
R_R365  NTMP0000000019  N_C0_105  1.279289e+06m  TC=0,0
R_V1093  NTMP0000000019  nV_1093  7.599661e+02m  TC=0,0
L_V1093  nV_1093  N_C0_105  5.707930e+01uH
R_V1094  NTMP0000000019  nV_1094  7.048471e+00m  TC=0,0
L_V1094  nV_1094  N_C0_105  1.142208e+01uH
R_V1095  NTMP0000000019  nV_1095  1.659926e+01m  TC=0,0
L_V1095  nV_1095  N_C0_105  9.325975e+01uH
* *  Node  NTMP0000000019  to  Node  NTMP0000000021
R_R366  NTMP0000000019  NTMP0000000021  4.623875e+07m  TC=0,0
R_V1096  NTMP0000000019  nV_1096  -4.247623e+03m  TC=0,0
L_V1096  nV_1096  NTMP0000000021  -3.190291e+02uH
R_V1097  NTMP0000000019  nV_1097  1.418394e+03m  TC=0,0
L_V1097  nV_1097  NTMP0000000021  2.298513e+03uH
R_V1098  NTMP0000000019  nV_1098  -1.768856e+03m  TC=0,0
L_V1098  nV_1098  NTMP0000000021  -9.937977e+03uH
* *  Node  NTMP0000000019  to  Node  N_C0_106
R_R367  NTMP0000000019  N_C0_106  2.326917e+07m  TC=0,0
R_V1099  NTMP0000000019  nV_1099  -8.562506e+03m  TC=0,0
L_V1099  nV_1099  N_C0_106  -6.431100e+02uH
R_V1100  NTMP0000000019  nV_1100  -3.508420e+03m  TC=0,0
L_V1100  nV_1100  N_C0_106  -5.685410e+03uH
R_V1101  NTMP0000000019  nV_1101  2.715515e+03m  TC=0,0
L_V1101  nV_1101  N_C0_106  1.525660e+04uH
* *  Node  NTMP0000000019  to  Node  N_C0_107
R_R368  NTMP0000000019  N_C0_107  1.264569e+07m  TC=0,0
R_V1102  NTMP0000000019  nV_1102  -1.412056e+04m  TC=0,0
L_V1102  nV_1102  N_C0_107  -1.060562e+03uH
R_V1103  NTMP0000000019  nV_1103  -3.923993e+02m  TC=0,0
L_V1103  nV_1103  N_C0_107  -6.358848e+02uH
R_V1104  NTMP0000000019  nV_1104  3.606503e+02m  TC=0,0
L_V1104  nV_1104  N_C0_107  2.026244e+03uH
* *  Node  NTMP0000000019  to  Node  N_C0_108
R_R369  NTMP0000000019  N_C0_108  9.786885e+06m  TC=0,0
R_V1105  NTMP0000000019  nV_1105  2.370043e+04m  TC=0,0
L_V1105  nV_1105  N_C0_108  1.780084e+03uH
R_V1106  NTMP0000000019  nV_1106  4.474683e+02m  TC=0,0
L_V1106  nV_1106  N_C0_108  7.251243e+02uH
R_V1107  NTMP0000000019  nV_1107  -4.145316e+02m  TC=0,0
L_V1107  nV_1107  N_C0_108  -2.328966e+03uH
* *  Node  NTMP0000000019  to  Node  N_C0_109
R_R370  NTMP0000000019  N_C0_109  3.743991e+06m  TC=0,0
R_V1108  NTMP0000000019  nV_1108  -4.118347e+03m  TC=0,0
L_V1108  nV_1108  N_C0_109  -3.093196e+02uH
R_V1109  NTMP0000000019  nV_1109  -9.758691e+01m  TC=0,0
L_V1109  nV_1109  N_C0_109  -1.581400e+02uH
R_V1110  NTMP0000000019  nV_1110  8.951904e+01m  TC=0,0
L_V1110  nV_1110  N_C0_109  5.029455e+02uH
* *  Node  NTMP0000000019  to  Node  N_C0_110
R_R371  NTMP0000000019  N_C0_110  3.913246e+07m  TC=0,0
R_V1111  NTMP0000000019  nV_1111  2.209327e+04m  TC=0,0
L_V1111  nV_1111  N_C0_110  1.659375e+03uH
R_V1112  NTMP0000000019  nV_1112  -4.316144e+03m  TC=0,0
L_V1112  nV_1112  N_C0_110  -6.994331e+03uH
R_V1113  NTMP0000000019  nV_1113  4.476404e+03m  TC=0,0
L_V1113  nV_1113  N_C0_110  2.514982e+04uH
* *  Node  NTMP0000000019  to  Node  NTMP0000000028
R_R372  NTMP0000000019  NTMP0000000028  9.972177e+05m  TC=0,0
R_V1114  NTMP0000000019  nV_1114  1.593936e+03m  TC=0,0
L_V1114  nV_1114  NTMP0000000028  1.197168e+02uH
R_V1115  NTMP0000000019  nV_1115  4.866058e+01m  TC=0,0
L_V1115  nV_1115  NTMP0000000028  7.885467e+01uH
R_V1116  NTMP0000000019  nV_1116  -4.448945e+01m  TC=0,0
L_V1116  nV_1116  NTMP0000000028  -2.499554e+02uH
* *  Node  NTMP0000000019  to  Node  N_C0_111
R_R373  NTMP0000000019  N_C0_111  3.565450e+06m  TC=0,0
R_V1117  NTMP0000000019  nV_1117  -4.899846e+03m  TC=0,0
L_V1117  nV_1117  N_C0_111  -3.680161e+02uH
R_V1118  NTMP0000000019  nV_1118  -9.538496e+01m  TC=0,0
L_V1118  nV_1118  N_C0_111  -1.545717e+02uH
R_V1119  NTMP0000000019  nV_1119  8.774298e+01m  TC=0,0
L_V1119  nV_1119  N_C0_111  4.929671e+02uH
* *  Node  NTMP0000000019  to  Node  NTMP0000000030
R_R374  NTMP0000000019  NTMP0000000030  3.673011e+07m  TC=0,0
R_V1120  NTMP0000000019  nV_1120  1.079864e+04m  TC=0,0
L_V1120  nV_1120  NTMP0000000030  8.110611e+02uH
R_V1121  NTMP0000000019  nV_1121  1.629839e+03m  TC=0,0
L_V1121  nV_1121  NTMP0000000030  2.641160e+03uH
R_V1122  NTMP0000000019  nV_1122  -1.382067e+03m  TC=0,0
L_V1122  nV_1122  NTMP0000000030  -7.764877e+03uH
* *  Node  NTMP0000000019  to  Node  N_C0_112
R_R375  NTMP0000000019  N_C0_112  3.357291e+07m  TC=0,0
R_V1123  NTMP0000000019  nV_1123  1.190985e+04m  TC=0,0
L_V1123  nV_1123  N_C0_112  8.945212e+02uH
R_V1124  NTMP0000000019  nV_1124  -2.099274e+03m  TC=0,0
L_V1124  nV_1124  N_C0_112  -3.401882e+03uH
R_V1125  NTMP0000000019  nV_1125  2.179403e+03m  TC=0,0
L_V1125  nV_1125  N_C0_112  1.224456e+04uH
* *  Node  NTMP0000000019  to  Node  N_BUS_2
R_R376  NTMP0000000019  N_BUS_2  9.792390e+06m  TC=0,0
R_V1126  NTMP0000000019  nV_1126  8.161213e+03m  TC=0,0
L_V1126  nV_1126  N_BUS_2  6.129699e+02uH
R_V1127  NTMP0000000019  nV_1127  4.002101e+02m  TC=0,0
L_V1127  nV_1127  N_BUS_2  6.485422e+02uH
R_V1128  NTMP0000000019  nV_1128  -3.570817e+02m  TC=0,0
L_V1128  nV_1128  N_BUS_2  -2.006195e+03uH
* *  Node  NTMP0000000019  to  Node  N_C0_114
R_R377  NTMP0000000019  N_C0_114  9.875349e+07m  TC=0,0
R_V1129  NTMP0000000019  nV_1129  2.313653e+04m  TC=0,0
L_V1129  nV_1129  N_C0_114  1.737731e+03uH
R_V1130  NTMP0000000019  nV_1130  -1.811504e+05m  TC=0,0
L_V1130  nV_1130  N_C0_114  -2.935549e+05uH
R_V1131  NTMP0000000019  nV_1131  2.806054e+05m  TC=0,0
L_V1131  nV_1131  N_C0_114  1.576527e+06uH
* *  Node  NTMP0000000019  to  Node  N_C0_115
R_R378  NTMP0000000019  N_C0_115  1.623315e+08m  TC=0,0
R_V1132  NTMP0000000019  nV_1132  5.111715e+04m  TC=0,0
L_V1132  nV_1132  N_C0_115  3.839291e+03uH
R_V1133  NTMP0000000019  nV_1133  -1.223818e+05m  TC=0,0
L_V1133  nV_1133  N_C0_115  -1.983202e+05uH
R_V1134  NTMP0000000019  nV_1134  1.441201e+05m  TC=0,0
L_V1134  nV_1134  N_C0_115  8.097112e+05uH
* *  Node  NTMP0000000019  to  Node  N_C0_116
R_R379  NTMP0000000019  N_C0_116  9.786884e+08m  TC=0,0
R_V1135  NTMP0000000019  nV_1135  2.302146e+04m  TC=0,0
L_V1135  nV_1135  N_C0_116  1.729088e+03uH
R_V1136  NTMP0000000019  nV_1136  -1.705709e+05m  TC=0,0
L_V1136  nV_1136  N_C0_116  -2.764108e+05uH
R_V1137  NTMP0000000019  nV_1137  2.638248e+05m  TC=0,0
L_V1137  nV_1137  N_C0_116  1.482249e+06uH
* *  Node  NTMP0000000019  to  Node  N_C0_117
R_R380  NTMP0000000019  N_C0_117  6.884005e+08m  TC=0,0
R_V1138  NTMP0000000019  nV_1138  5.082767e+04m  TC=0,0
L_V1138  nV_1138  N_C0_117  3.817549e+03uH
R_V1139  NTMP0000000019  nV_1139  -1.197930e+05m  TC=0,0
L_V1139  nV_1139  N_C0_117  -1.941251e+05uH
R_V1140  NTMP0000000019  nV_1140  1.417322e+05m  TC=0,0
L_V1140  nV_1140  N_C0_117  7.962948e+05uH
* *  Node  NTMP0000000019  to  Node  N_C0_118
R_R381  NTMP0000000019  N_C0_118  1.082333e+07m  TC=0,0
R_V1141  NTMP0000000019  nV_1141  1.189307e+04m  TC=0,0
L_V1141  nV_1141  N_C0_118  8.932607e+02uH
R_V1142  NTMP0000000019  nV_1142  3.590865e+05m  TC=0,0
L_V1142  nV_1142  N_C0_118  5.819012e+05uH
R_V1143  NTMP0000000019  nV_1143  -2.632878e+04m  TC=0,0
L_V1143  nV_1143  N_C0_118  -1.479232e+05uH
* *  Node  NTMP0000000019  to  Node  N_C0_119
R_R382  NTMP0000000019  N_C0_119  1.007566e+08m  TC=0,0
R_V1144  NTMP0000000019  nV_1144  1.162904e+04m  TC=0,0
L_V1144  nV_1144  N_C0_119  8.734302e+02uH
R_V1145  NTMP0000000019  nV_1145  -4.205395e+06m  TC=0,0
L_V1145  nV_1145  N_C0_119  -6.814860e+06uH
R_V1146  NTMP0000000019  nV_1146  -2.779236e+04m  TC=0,0
L_V1146  nV_1146  N_C0_119  -1.561460e+05uH
* *  Node  NTMP0000000019  to  Node  N_C0_120
R_R383  NTMP0000000019  N_C0_120  9.297592e+06m  TC=0,0
R_V1147  NTMP0000000019  nV_1147  1.236925e+04m  TC=0,0
L_V1147  nV_1147  N_C0_120  9.290260e+02uH
R_V1148  NTMP0000000019  nV_1148  -2.218461e+05m  TC=0,0
L_V1148  nV_1148  N_C0_120  -3.595025e+05uH
R_V1149  NTMP0000000019  nV_1149  -3.458482e+04m  TC=0,0
L_V1149  nV_1149  N_C0_120  -1.943082e+05uH
* *  Node  NTMP0000000019  to  Node  N_C0_121
R_R384  NTMP0000000019  N_C0_121  4.203522e+07m  TC=0,0
R_V1150  NTMP0000000019  nV_1150  1.207995e+04m  TC=0,0
L_V1150  nV_1150  N_C0_121  9.072971e+02uH
R_V1151  NTMP0000000019  nV_1151  -1.320466e+05m  TC=0,0
L_V1151  nV_1151  N_C0_121  -2.139821e+05uH
R_V1152  NTMP0000000019  nV_1152  -3.719406e+04m  TC=0,0
L_V1152  nV_1152  N_C0_121  -2.089677e+05uH
* *  Node  NTMP0000000019  to  Node  N_BUS_GND
R_R385  NTMP0000000019  N_BUS_GND  1.072110e+09m  TC=0,0
R_V1153  NTMP0000000019  nV_1153  -4.834897e+04m  TC=0,0
L_V1153  nV_1153  N_BUS_GND  -3.631379e+03uH
R_V1154  NTMP0000000019  nV_1154  1.026112e+05m  TC=0,0
L_V1154  nV_1154  N_BUS_GND  1.662820e+05uH
R_V1155  NTMP0000000019  nV_1155  1.206182e+05m  TC=0,0
L_V1155  nV_1155  N_BUS_GND  6.776699e+05uH
*  Node  N_C0_105  to other nodes
* *  Node  N_C0_105  to  Node  NTMP0000000021
R_R386  N_C0_105  NTMP0000000021  2.326917e+07m  TC=0,0
R_V1156  N_C0_105  nV_1156  -8.562506e+03m  TC=0,0
L_V1156  nV_1156  NTMP0000000021  -6.431100e+02uH
R_V1157  N_C0_105  nV_1157  -3.508420e+03m  TC=0,0
L_V1157  nV_1157  NTMP0000000021  -5.685410e+03uH
R_V1158  N_C0_105  nV_1158  2.715515e+03m  TC=0,0
L_V1158  nV_1158  NTMP0000000021  1.525660e+04uH
* *  Node  N_C0_105  to  Node  N_C0_106
R_R387  N_C0_105  N_C0_106  8.589374e+06m  TC=0,0
R_V1159  N_C0_105  nV_1159  -3.554034e+03m  TC=0,0
L_V1159  nV_1159  N_C0_106  -2.669352e+02uH
R_V1160  N_C0_105  nV_1160  6.851960e+02m  TC=0,0
L_V1160  nV_1160  N_C0_106  1.110363e+03uH
R_V1161  N_C0_105  nV_1161  5.927768e+02m  TC=0,0
L_V1161  nV_1161  N_C0_106  3.330402e+03uH
* *  Node  N_C0_105  to  Node  N_C0_107
R_R388  N_C0_105  N_C0_107  1.236091e+06m  TC=0,0
R_V1162  N_C0_105  nV_1162  6.461370e+02m  TC=0,0
L_V1162  nV_1162  N_C0_107  4.852986e+01uH
R_V1163  N_C0_105  nV_1163  6.753561e+00m  TC=0,0
L_V1163  nV_1163  N_C0_107  1.094417e+01uH
R_V1164  N_C0_105  nV_1164  1.868000e+01m  TC=0,0
L_V1164  nV_1164  N_C0_107  1.049500e+02uH
* *  Node  N_C0_105  to  Node  N_C0_108
R_R389  N_C0_105  N_C0_108  2.443344e+07m  TC=0,0
R_V1165  N_C0_105  nV_1165  8.598242e+04m  TC=0,0
L_V1165  nV_1165  N_C0_108  6.457941e+03uH
R_V1166  N_C0_105  nV_1166  -4.221941e+02m  TC=0,0
L_V1166  nV_1166  N_C0_108  -6.841673e+02uH
R_V1167  N_C0_105  nV_1167  4.986751e+02m  TC=0,0
L_V1167  nV_1167  N_C0_108  2.801710e+03uH
* *  Node  N_C0_105  to  Node  N_C0_109
R_R390  N_C0_105  N_C0_109  2.569193e+07m  TC=0,0
R_V1168  N_C0_105  nV_1168  -3.319842e+04m  TC=0,0
L_V1168  nV_1168  N_C0_109  -2.493457e+03uH
R_V1169  N_C0_105  nV_1169  -2.235313e+02m  TC=0,0
L_V1169  nV_1169  N_C0_109  -3.622334e+02uH
R_V1170  N_C0_105  nV_1170  2.128130e+02m  TC=0,0
L_V1170  nV_1170  N_C0_109  1.195649e+03uH
* *  Node  N_C0_105  to  Node  N_C0_110
R_R391  N_C0_105  N_C0_110  1.678229e+09m  TC=0,0
R_V1171  N_C0_105  nV_1171  -5.350152e+04m  TC=0,0
L_V1171  nV_1171  N_C0_110  -4.018375e+03uH
R_V1172  N_C0_105  nV_1172  -1.907549e+02m  TC=0,0
L_V1172  nV_1172  N_C0_110  -3.091191e+02uH
R_V1173  N_C0_105  nV_1173  1.850948e+02m  TC=0,0
L_V1173  nV_1173  N_C0_110  1.039919e+03uH
* *  Node  N_C0_105  to  Node  NTMP0000000028
R_R392  N_C0_105  NTMP0000000028  6.059323e+06m  TC=0,0
R_V1174  N_C0_105  nV_1174  -4.043093e+03m  TC=0,0
L_V1174  nV_1174  NTMP0000000028  -3.036674e+02uH
R_V1175  N_C0_105  nV_1175  -9.597907e+01m  TC=0,0
L_V1175  nV_1175  NTMP0000000028  -1.555345e+02uH
R_V1176  N_C0_105  nV_1176  8.815756e+01m  TC=0,0
L_V1176  nV_1176  NTMP0000000028  4.952963e+02uH
* *  Node  N_C0_105  to  Node  N_C0_111
R_R393  N_C0_105  N_C0_111  9.280041e+05m  TC=0,0
R_V1177  N_C0_105  nV_1177  1.199183e+03m  TC=0,0
L_V1177  nV_1177  N_C0_111  9.006789e+01uH
R_V1178  N_C0_105  nV_1178  2.801600e+01m  TC=0,0
L_V1178  nV_1178  N_C0_111  4.540005e+01uH
R_V1179  N_C0_105  nV_1179  -2.599710e+01m  TC=0,0
L_V1179  nV_1179  N_C0_111  -1.460597e+02uH
* *  Node  N_C0_105  to  Node  NTMP0000000030
R_R394  N_C0_105  NTMP0000000030  2.407128e+07m  TC=0,0
R_V1180  N_C0_105  nV_1180  2.752326e+04m  TC=0,0
L_V1180  nV_1180  NTMP0000000030  2.067208e+03uH
R_V1181  N_C0_105  nV_1181  -2.293361e+03m  TC=0,0
L_V1181  nV_1181  NTMP0000000030  -3.716402e+03uH
R_V1182  N_C0_105  nV_1182  2.287977e+03m  TC=0,0
L_V1182  nV_1182  NTMP0000000030  1.285456e+04uH
* *  Node  N_C0_105  to  Node  N_C0_112
R_R395  N_C0_105  N_C0_112  1.848154e+07m  TC=0,0
R_V1183  N_C0_105  nV_1183  -1.440267e+04m  TC=0,0
L_V1183  nV_1183  N_C0_112  -1.081752e+03uH
R_V1184  N_C0_105  nV_1184  -2.153769e+02m  TC=0,0
L_V1184  nV_1184  N_C0_112  -3.490193e+02uH
R_V1185  N_C0_105  nV_1185  2.018383e+02m  TC=0,0
L_V1185  nV_1185  N_C0_112  1.133990e+03uH
* *  Node  N_C0_105  to  Node  N_BUS_2
R_R396  N_C0_105  N_BUS_2  6.261602e+06m  TC=0,0
R_V1186  N_C0_105  nV_1186  -2.207589e+03m  TC=0,0
L_V1186  nV_1186  N_BUS_2  -1.658069e+02uH
R_V1187  N_C0_105  nV_1187  -6.098353e+01m  TC=0,0
L_V1187  nV_1187  N_BUS_2  -9.882408e+01uH
R_V1188  N_C0_105  nV_1188  5.598985e+01m  TC=0,0
L_V1188  nV_1188  N_BUS_2  3.145682e+02uH
* *  Node  N_C0_105  to  Node  N_C0_114
R_R397  N_C0_105  N_C0_114  4.145059e+07m  TC=0,0
R_V1189  N_C0_105  nV_1189  1.703745e+04m  TC=0,0
L_V1189  nV_1189  N_C0_114  1.279644e+03uH
R_V1190  N_C0_105  nV_1190  -2.611573e+02m  TC=0,0
L_V1190  nV_1190  N_C0_114  -4.232065e+02uH
R_V1191  N_C0_105  nV_1191  4.911016e+02m  TC=0,0
L_V1191  nV_1191  N_C0_114  2.759160e+03uH
* *  Node  N_C0_105  to  Node  N_C0_115
R_R398  N_C0_105  N_C0_115  5.058026e+07m  TC=0,0
R_V1192  N_C0_105  nV_1192  1.995814e+04m  TC=0,0
L_V1192  nV_1192  N_C0_115  1.499010e+03uH
R_V1193  N_C0_105  nV_1193  -3.349366e+02m  TC=0,0
L_V1193  nV_1193  N_C0_115  -5.427663e+02uH
R_V1194  N_C0_105  nV_1194  6.502173e+02m  TC=0,0
L_V1194  nV_1194  N_C0_115  3.653121e+03uH
* *  Node  N_C0_105  to  Node  N_C0_116
R_R399  N_C0_105  N_C0_116  7.171683e+07m  TC=0,0
R_V1195  N_C0_105  nV_1195  1.786823e+04m  TC=0,0
L_V1195  nV_1195  N_C0_116  1.342041e+03uH
R_V1196  N_C0_105  nV_1196  -2.877423e+02m  TC=0,0
L_V1196  nV_1196  N_C0_116  -4.662876e+02uH
R_V1197  N_C0_105  nV_1197  5.543040e+02m  TC=0,0
L_V1197  nV_1197  N_C0_116  3.114250e+03uH
* *  Node  N_C0_105  to  Node  N_C0_117
R_R400  N_C0_105  N_C0_117  7.188178e+07m  TC=0,0
R_V1198  N_C0_105  nV_1198  2.057174e+04m  TC=0,0
L_V1198  nV_1198  N_C0_117  1.545096e+03uH
R_V1199  N_C0_105  nV_1199  -3.583574e+02m  TC=0,0
L_V1199  nV_1199  N_C0_117  -5.807198e+02uH
R_V1200  N_C0_105  nV_1200  7.095455e+02m  TC=0,0
L_V1200  nV_1200  N_C0_117  3.986445e+03uH
* *  Node  N_C0_105  to  Node  N_C0_118
R_R401  N_C0_105  N_C0_118  1.643255e+07m  TC=0,0
R_V1201  N_C0_105  nV_1201  1.060923e+04m  TC=0,0
L_V1201  nV_1201  N_C0_118  7.968346e+02uH
R_V1202  N_C0_105  nV_1202  -1.451916e+02m  TC=0,0
L_V1202  nV_1202  N_C0_118  -2.352835e+02uH
R_V1203  N_C0_105  nV_1203  2.369953e+02m  TC=0,0
L_V1203  nV_1203  N_C0_118  1.331513e+03uH
* *  Node  N_C0_105  to  Node  N_C0_119
R_R402  N_C0_105  N_C0_119  4.246825e+07m  TC=0,0
R_V1204  N_C0_105  nV_1204  1.306838e+04m  TC=0,0
L_V1204  nV_1204  N_C0_119  9.815358e+02uH
R_V1205  N_C0_105  nV_1205  -2.176000e+02m  TC=0,0
L_V1205  nV_1205  N_C0_119  -3.526218e+02uH
R_V1206  N_C0_105  nV_1206  3.744479e+02m  TC=0,0
L_V1206  nV_1206  N_C0_119  2.103764e+03uH
* *  Node  N_C0_105  to  Node  N_C0_120
R_R403  N_C0_105  N_C0_120  1.578833e+06m  TC=0,0
R_V1207  N_C0_105  nV_1207  1.865607e+03m  TC=0,0
L_V1207  nV_1207  N_C0_120  1.401215e+02uH
R_V1208  N_C0_105  nV_1208  -3.005914e+01m  TC=0,0
L_V1208  nV_1208  N_C0_120  -4.871096e+01uH
R_V1209  N_C0_105  nV_1209  1.281441e+00m  TC=0,0
L_V1209  nV_1209  N_C0_120  7.199531e+00uH
* *  Node  N_C0_105  to  Node  N_C0_121
R_R404  N_C0_105  N_C0_121  1.534454e+07m  TC=0,0
R_V1210  N_C0_105  nV_1210  9.534862e+03m  TC=0,0
L_V1210  nV_1210  N_C0_121  7.161414e+02uH
R_V1211  N_C0_105  nV_1211  -1.396468e+02m  TC=0,0
L_V1211  nV_1211  N_C0_121  -2.262983e+02uH
R_V1212  N_C0_105  nV_1212  2.223514e+02m  TC=0,0
L_V1212  nV_1212  N_C0_121  1.249239e+03uH
* *  Node  N_C0_105  to  Node  N_BUS_GND
R_R405  N_C0_105  N_BUS_GND  7.563719e+07m  TC=0,0
R_V1213  N_C0_105  nV_1213  1.345909e+04m  TC=0,0
L_V1213  nV_1213  N_BUS_GND  1.010881e+03uH
R_V1214  N_C0_105  nV_1214  1.858601e+02m  TC=0,0
L_V1214  nV_1214  N_BUS_GND  3.011870e+02uH
R_V1215  N_C0_105  nV_1215  -1.904610e+02m  TC=0,0
L_V1215  nV_1215  N_BUS_GND  -1.070069e+03uH
*  Node  NTMP0000000021  to other nodes
* *  Node  NTMP0000000021  to  Node  N_C0_106
R_R406  NTMP0000000021  N_C0_106  1.279289e+06m  TC=0,0
R_V1216  NTMP0000000021  nV_1216  7.599661e+02m  TC=0,0
L_V1216  nV_1216  N_C0_106  5.707930e+01uH
R_V1217  NTMP0000000021  nV_1217  7.048471e+00m  TC=0,0
L_V1217  nV_1217  N_C0_106  1.142208e+01uH
R_V1218  NTMP0000000021  nV_1218  1.659926e+01m  TC=0,0
L_V1218  nV_1218  N_C0_106  9.325975e+01uH
* *  Node  NTMP0000000021  to  Node  N_C0_107
R_R407  NTMP0000000021  N_C0_107  1.264569e+07m  TC=0,0
R_V1219  NTMP0000000021  nV_1219  -1.412056e+04m  TC=0,0
L_V1219  nV_1219  N_C0_107  -1.060562e+03uH
R_V1220  NTMP0000000021  nV_1220  -3.923993e+02m  TC=0,0
L_V1220  nV_1220  N_C0_107  -6.358848e+02uH
R_V1221  NTMP0000000021  nV_1221  3.606503e+02m  TC=0,0
L_V1221  nV_1221  N_C0_107  2.026244e+03uH
* *  Node  NTMP0000000021  to  Node  N_C0_108
R_R408  NTMP0000000021  N_C0_108  9.786885e+06m  TC=0,0
R_V1222  NTMP0000000021  nV_1222  2.370043e+04m  TC=0,0
L_V1222  nV_1222  N_C0_108  1.780084e+03uH
R_V1223  NTMP0000000021  nV_1223  4.474683e+02m  TC=0,0
L_V1223  nV_1223  N_C0_108  7.251243e+02uH
R_V1224  NTMP0000000021  nV_1224  -4.145316e+02m  TC=0,0
L_V1224  nV_1224  N_C0_108  -2.328966e+03uH
* *  Node  NTMP0000000021  to  Node  N_C0_109
R_R409  NTMP0000000021  N_C0_109  3.913246e+07m  TC=0,0
R_V1225  NTMP0000000021  nV_1225  2.209327e+04m  TC=0,0
L_V1225  nV_1225  N_C0_109  1.659375e+03uH
R_V1226  NTMP0000000021  nV_1226  -4.316144e+03m  TC=0,0
L_V1226  nV_1226  N_C0_109  -6.994331e+03uH
R_V1227  NTMP0000000021  nV_1227  4.476404e+03m  TC=0,0
L_V1227  nV_1227  N_C0_109  2.514982e+04uH
* *  Node  NTMP0000000021  to  Node  N_C0_110
R_R410  NTMP0000000021  N_C0_110  3.743991e+06m  TC=0,0
R_V1228  NTMP0000000021  nV_1228  -4.118347e+03m  TC=0,0
L_V1228  nV_1228  N_C0_110  -3.093196e+02uH
R_V1229  NTMP0000000021  nV_1229  -9.758691e+01m  TC=0,0
L_V1229  nV_1229  N_C0_110  -1.581400e+02uH
R_V1230  NTMP0000000021  nV_1230  8.951904e+01m  TC=0,0
L_V1230  nV_1230  N_C0_110  5.029455e+02uH
* *  Node  NTMP0000000021  to  Node  NTMP0000000028
R_R411  NTMP0000000021  NTMP0000000028  3.673011e+07m  TC=0,0
R_V1231  NTMP0000000021  nV_1231  1.079864e+04m  TC=0,0
L_V1231  nV_1231  NTMP0000000028  8.110611e+02uH
R_V1232  NTMP0000000021  nV_1232  1.629839e+03m  TC=0,0
L_V1232  nV_1232  NTMP0000000028  2.641160e+03uH
R_V1233  NTMP0000000021  nV_1233  -1.382067e+03m  TC=0,0
L_V1233  nV_1233  NTMP0000000028  -7.764877e+03uH
* *  Node  NTMP0000000021  to  Node  N_C0_111
R_R412  NTMP0000000021  N_C0_111  3.357291e+07m  TC=0,0
R_V1234  NTMP0000000021  nV_1234  1.190985e+04m  TC=0,0
L_V1234  nV_1234  N_C0_111  8.945212e+02uH
R_V1235  NTMP0000000021  nV_1235  -2.099274e+03m  TC=0,0
L_V1235  nV_1235  N_C0_111  -3.401882e+03uH
R_V1236  NTMP0000000021  nV_1236  2.179403e+03m  TC=0,0
L_V1236  nV_1236  N_C0_111  1.224456e+04uH
* *  Node  NTMP0000000021  to  Node  NTMP0000000030
R_R413  NTMP0000000021  NTMP0000000030  9.972177e+05m  TC=0,0
R_V1237  NTMP0000000021  nV_1237  1.593936e+03m  TC=0,0
L_V1237  nV_1237  NTMP0000000030  1.197168e+02uH
R_V1238  NTMP0000000021  nV_1238  4.866058e+01m  TC=0,0
L_V1238  nV_1238  NTMP0000000030  7.885467e+01uH
R_V1239  NTMP0000000021  nV_1239  -4.448945e+01m  TC=0,0
L_V1239  nV_1239  NTMP0000000030  -2.499554e+02uH
* *  Node  NTMP0000000021  to  Node  N_C0_112
R_R414  NTMP0000000021  N_C0_112  3.565450e+06m  TC=0,0
R_V1240  NTMP0000000021  nV_1240  -4.899846e+03m  TC=0,0
L_V1240  nV_1240  N_C0_112  -3.680161e+02uH
R_V1241  NTMP0000000021  nV_1241  -9.538496e+01m  TC=0,0
L_V1241  nV_1241  N_C0_112  -1.545717e+02uH
R_V1242  NTMP0000000021  nV_1242  8.774298e+01m  TC=0,0
L_V1242  nV_1242  N_C0_112  4.929671e+02uH
* *  Node  NTMP0000000021  to  Node  N_BUS_2
R_R415  NTMP0000000021  N_BUS_2  9.792390e+06m  TC=0,0
R_V1243  NTMP0000000021  nV_1243  8.161213e+03m  TC=0,0
L_V1243  nV_1243  N_BUS_2  6.129699e+02uH
R_V1244  NTMP0000000021  nV_1244  4.002101e+02m  TC=0,0
L_V1244  nV_1244  N_BUS_2  6.485422e+02uH
R_V1245  NTMP0000000021  nV_1245  -3.570817e+02m  TC=0,0
L_V1245  nV_1245  N_BUS_2  -2.006195e+03uH
* *  Node  NTMP0000000021  to  Node  N_C0_114
R_R416  NTMP0000000021  N_C0_114  9.786884e+08m  TC=0,0
R_V1246  NTMP0000000021  nV_1246  2.302146e+04m  TC=0,0
L_V1246  nV_1246  N_C0_114  1.729088e+03uH
R_V1247  NTMP0000000021  nV_1247  -1.705709e+05m  TC=0,0
L_V1247  nV_1247  N_C0_114  -2.764108e+05uH
R_V1248  NTMP0000000021  nV_1248  2.638248e+05m  TC=0,0
L_V1248  nV_1248  N_C0_114  1.482249e+06uH
* *  Node  NTMP0000000021  to  Node  N_C0_115
R_R417  NTMP0000000021  N_C0_115  6.884005e+08m  TC=0,0
R_V1249  NTMP0000000021  nV_1249  5.082767e+04m  TC=0,0
L_V1249  nV_1249  N_C0_115  3.817549e+03uH
R_V1250  NTMP0000000021  nV_1250  -1.197930e+05m  TC=0,0
L_V1250  nV_1250  N_C0_115  -1.941251e+05uH
R_V1251  NTMP0000000021  nV_1251  1.417322e+05m  TC=0,0
L_V1251  nV_1251  N_C0_115  7.962948e+05uH
* *  Node  NTMP0000000021  to  Node  N_C0_116
R_R418  NTMP0000000021  N_C0_116  9.875349e+07m  TC=0,0
R_V1252  NTMP0000000021  nV_1252  2.313653e+04m  TC=0,0
L_V1252  nV_1252  N_C0_116  1.737731e+03uH
R_V1253  NTMP0000000021  nV_1253  -1.811504e+05m  TC=0,0
L_V1253  nV_1253  N_C0_116  -2.935549e+05uH
R_V1254  NTMP0000000021  nV_1254  2.806054e+05m  TC=0,0
L_V1254  nV_1254  N_C0_116  1.576527e+06uH
* *  Node  NTMP0000000021  to  Node  N_C0_117
R_R419  NTMP0000000021  N_C0_117  1.623315e+08m  TC=0,0
R_V1255  NTMP0000000021  nV_1255  5.111715e+04m  TC=0,0
L_V1255  nV_1255  N_C0_117  3.839291e+03uH
R_V1256  NTMP0000000021  nV_1256  -1.223818e+05m  TC=0,0
L_V1256  nV_1256  N_C0_117  -1.983202e+05uH
R_V1257  NTMP0000000021  nV_1257  1.441201e+05m  TC=0,0
L_V1257  nV_1257  N_C0_117  8.097112e+05uH
* *  Node  NTMP0000000021  to  Node  N_C0_118
R_R420  NTMP0000000021  N_C0_118  1.007566e+08m  TC=0,0
R_V1258  NTMP0000000021  nV_1258  1.162904e+04m  TC=0,0
L_V1258  nV_1258  N_C0_118  8.734302e+02uH
R_V1259  NTMP0000000021  nV_1259  -4.205395e+06m  TC=0,0
L_V1259  nV_1259  N_C0_118  -6.814860e+06uH
R_V1260  NTMP0000000021  nV_1260  -2.779236e+04m  TC=0,0
L_V1260  nV_1260  N_C0_118  -1.561460e+05uH
* *  Node  NTMP0000000021  to  Node  N_C0_119
R_R421  NTMP0000000021  N_C0_119  1.082333e+07m  TC=0,0
R_V1261  NTMP0000000021  nV_1261  1.189307e+04m  TC=0,0
L_V1261  nV_1261  N_C0_119  8.932607e+02uH
R_V1262  NTMP0000000021  nV_1262  3.590865e+05m  TC=0,0
L_V1262  nV_1262  N_C0_119  5.819012e+05uH
R_V1263  NTMP0000000021  nV_1263  -2.632878e+04m  TC=0,0
L_V1263  nV_1263  N_C0_119  -1.479232e+05uH
* *  Node  NTMP0000000021  to  Node  N_C0_120
R_R422  NTMP0000000021  N_C0_120  4.203522e+07m  TC=0,0
R_V1264  NTMP0000000021  nV_1264  1.207995e+04m  TC=0,0
L_V1264  nV_1264  N_C0_120  9.072971e+02uH
R_V1265  NTMP0000000021  nV_1265  -1.320466e+05m  TC=0,0
L_V1265  nV_1265  N_C0_120  -2.139821e+05uH
R_V1266  NTMP0000000021  nV_1266  -3.719406e+04m  TC=0,0
L_V1266  nV_1266  N_C0_120  -2.089677e+05uH
* *  Node  NTMP0000000021  to  Node  N_C0_121
R_R423  NTMP0000000021  N_C0_121  9.297592e+06m  TC=0,0
R_V1267  NTMP0000000021  nV_1267  1.236925e+04m  TC=0,0
L_V1267  nV_1267  N_C0_121  9.290260e+02uH
R_V1268  NTMP0000000021  nV_1268  -2.218461e+05m  TC=0,0
L_V1268  nV_1268  N_C0_121  -3.595025e+05uH
R_V1269  NTMP0000000021  nV_1269  -3.458482e+04m  TC=0,0
L_V1269  nV_1269  N_C0_121  -1.943082e+05uH
* *  Node  NTMP0000000021  to  Node  N_BUS_GND
R_R424  NTMP0000000021  N_BUS_GND  1.072110e+09m  TC=0,0
R_V1270  NTMP0000000021  nV_1270  -4.834897e+04m  TC=0,0
L_V1270  nV_1270  N_BUS_GND  -3.631379e+03uH
R_V1271  NTMP0000000021  nV_1271  1.026112e+05m  TC=0,0
L_V1271  nV_1271  N_BUS_GND  1.662820e+05uH
R_V1272  NTMP0000000021  nV_1272  1.206182e+05m  TC=0,0
L_V1272  nV_1272  N_BUS_GND  6.776699e+05uH
*  Node  N_C0_106  to other nodes
* *  Node  N_C0_106  to  Node  N_C0_107
R_R425  N_C0_106  N_C0_107  1.236091e+06m  TC=0,0
R_V1273  N_C0_106  nV_1273  6.461370e+02m  TC=0,0
L_V1273  nV_1273  N_C0_107  4.852986e+01uH
R_V1274  N_C0_106  nV_1274  6.753561e+00m  TC=0,0
L_V1274  nV_1274  N_C0_107  1.094417e+01uH
R_V1275  N_C0_106  nV_1275  1.868000e+01m  TC=0,0
L_V1275  nV_1275  N_C0_107  1.049500e+02uH
* *  Node  N_C0_106  to  Node  N_C0_108
R_R426  N_C0_106  N_C0_108  2.443344e+07m  TC=0,0
R_V1276  N_C0_106  nV_1276  8.598242e+04m  TC=0,0
L_V1276  nV_1276  N_C0_108  6.457941e+03uH
R_V1277  N_C0_106  nV_1277  -4.221941e+02m  TC=0,0
L_V1277  nV_1277  N_C0_108  -6.841673e+02uH
R_V1278  N_C0_106  nV_1278  4.986751e+02m  TC=0,0
L_V1278  nV_1278  N_C0_108  2.801710e+03uH
* *  Node  N_C0_106  to  Node  N_C0_109
R_R427  N_C0_106  N_C0_109  1.678229e+09m  TC=0,0
R_V1279  N_C0_106  nV_1279  -5.350152e+04m  TC=0,0
L_V1279  nV_1279  N_C0_109  -4.018375e+03uH
R_V1280  N_C0_106  nV_1280  -1.907549e+02m  TC=0,0
L_V1280  nV_1280  N_C0_109  -3.091191e+02uH
R_V1281  N_C0_106  nV_1281  1.850948e+02m  TC=0,0
L_V1281  nV_1281  N_C0_109  1.039919e+03uH
* *  Node  N_C0_106  to  Node  N_C0_110
R_R428  N_C0_106  N_C0_110  2.569193e+07m  TC=0,0
R_V1282  N_C0_106  nV_1282  -3.319842e+04m  TC=0,0
L_V1282  nV_1282  N_C0_110  -2.493457e+03uH
R_V1283  N_C0_106  nV_1283  -2.235313e+02m  TC=0,0
L_V1283  nV_1283  N_C0_110  -3.622334e+02uH
R_V1284  N_C0_106  nV_1284  2.128130e+02m  TC=0,0
L_V1284  nV_1284  N_C0_110  1.195649e+03uH
* *  Node  N_C0_106  to  Node  NTMP0000000028
R_R429  N_C0_106  NTMP0000000028  2.407128e+07m  TC=0,0
R_V1285  N_C0_106  nV_1285  2.752326e+04m  TC=0,0
L_V1285  nV_1285  NTMP0000000028  2.067208e+03uH
R_V1286  N_C0_106  nV_1286  -2.293361e+03m  TC=0,0
L_V1286  nV_1286  NTMP0000000028  -3.716402e+03uH
R_V1287  N_C0_106  nV_1287  2.287977e+03m  TC=0,0
L_V1287  nV_1287  NTMP0000000028  1.285456e+04uH
* *  Node  N_C0_106  to  Node  N_C0_111
R_R430  N_C0_106  N_C0_111  1.848154e+07m  TC=0,0
R_V1288  N_C0_106  nV_1288  -1.440267e+04m  TC=0,0
L_V1288  nV_1288  N_C0_111  -1.081752e+03uH
R_V1289  N_C0_106  nV_1289  -2.153769e+02m  TC=0,0
L_V1289  nV_1289  N_C0_111  -3.490193e+02uH
R_V1290  N_C0_106  nV_1290  2.018383e+02m  TC=0,0
L_V1290  nV_1290  N_C0_111  1.133990e+03uH
* *  Node  N_C0_106  to  Node  NTMP0000000030
R_R431  N_C0_106  NTMP0000000030  6.059323e+06m  TC=0,0
R_V1291  N_C0_106  nV_1291  -4.043093e+03m  TC=0,0
L_V1291  nV_1291  NTMP0000000030  -3.036674e+02uH
R_V1292  N_C0_106  nV_1292  -9.597907e+01m  TC=0,0
L_V1292  nV_1292  NTMP0000000030  -1.555345e+02uH
R_V1293  N_C0_106  nV_1293  8.815756e+01m  TC=0,0
L_V1293  nV_1293  NTMP0000000030  4.952963e+02uH
* *  Node  N_C0_106  to  Node  N_C0_112
R_R432  N_C0_106  N_C0_112  9.280041e+05m  TC=0,0
R_V1294  N_C0_106  nV_1294  1.199183e+03m  TC=0,0
L_V1294  nV_1294  N_C0_112  9.006789e+01uH
R_V1295  N_C0_106  nV_1295  2.801600e+01m  TC=0,0
L_V1295  nV_1295  N_C0_112  4.540005e+01uH
R_V1296  N_C0_106  nV_1296  -2.599710e+01m  TC=0,0
L_V1296  nV_1296  N_C0_112  -1.460597e+02uH
* *  Node  N_C0_106  to  Node  N_BUS_2
R_R433  N_C0_106  N_BUS_2  6.261602e+06m  TC=0,0
R_V1297  N_C0_106  nV_1297  -2.207589e+03m  TC=0,0
L_V1297  nV_1297  N_BUS_2  -1.658069e+02uH
R_V1298  N_C0_106  nV_1298  -6.098353e+01m  TC=0,0
L_V1298  nV_1298  N_BUS_2  -9.882408e+01uH
R_V1299  N_C0_106  nV_1299  5.598985e+01m  TC=0,0
L_V1299  nV_1299  N_BUS_2  3.145682e+02uH
* *  Node  N_C0_106  to  Node  N_C0_114
R_R434  N_C0_106  N_C0_114  7.171683e+07m  TC=0,0
R_V1300  N_C0_106  nV_1300  1.786823e+04m  TC=0,0
L_V1300  nV_1300  N_C0_114  1.342041e+03uH
R_V1301  N_C0_106  nV_1301  -2.877423e+02m  TC=0,0
L_V1301  nV_1301  N_C0_114  -4.662876e+02uH
R_V1302  N_C0_106  nV_1302  5.543040e+02m  TC=0,0
L_V1302  nV_1302  N_C0_114  3.114250e+03uH
* *  Node  N_C0_106  to  Node  N_C0_115
R_R435  N_C0_106  N_C0_115  7.188178e+07m  TC=0,0
R_V1303  N_C0_106  nV_1303  2.057174e+04m  TC=0,0
L_V1303  nV_1303  N_C0_115  1.545096e+03uH
R_V1304  N_C0_106  nV_1304  -3.583574e+02m  TC=0,0
L_V1304  nV_1304  N_C0_115  -5.807198e+02uH
R_V1305  N_C0_106  nV_1305  7.095455e+02m  TC=0,0
L_V1305  nV_1305  N_C0_115  3.986445e+03uH
* *  Node  N_C0_106  to  Node  N_C0_116
R_R436  N_C0_106  N_C0_116  4.145059e+07m  TC=0,0
R_V1306  N_C0_106  nV_1306  1.703745e+04m  TC=0,0
L_V1306  nV_1306  N_C0_116  1.279644e+03uH
R_V1307  N_C0_106  nV_1307  -2.611573e+02m  TC=0,0
L_V1307  nV_1307  N_C0_116  -4.232065e+02uH
R_V1308  N_C0_106  nV_1308  4.911016e+02m  TC=0,0
L_V1308  nV_1308  N_C0_116  2.759160e+03uH
* *  Node  N_C0_106  to  Node  N_C0_117
R_R437  N_C0_106  N_C0_117  5.058026e+07m  TC=0,0
R_V1309  N_C0_106  nV_1309  1.995814e+04m  TC=0,0
L_V1309  nV_1309  N_C0_117  1.499010e+03uH
R_V1310  N_C0_106  nV_1310  -3.349366e+02m  TC=0,0
L_V1310  nV_1310  N_C0_117  -5.427663e+02uH
R_V1311  N_C0_106  nV_1311  6.502173e+02m  TC=0,0
L_V1311  nV_1311  N_C0_117  3.653121e+03uH
* *  Node  N_C0_106  to  Node  N_C0_118
R_R438  N_C0_106  N_C0_118  4.246825e+07m  TC=0,0
R_V1312  N_C0_106  nV_1312  1.306838e+04m  TC=0,0
L_V1312  nV_1312  N_C0_118  9.815358e+02uH
R_V1313  N_C0_106  nV_1313  -2.176000e+02m  TC=0,0
L_V1313  nV_1313  N_C0_118  -3.526218e+02uH
R_V1314  N_C0_106  nV_1314  3.744479e+02m  TC=0,0
L_V1314  nV_1314  N_C0_118  2.103764e+03uH
* *  Node  N_C0_106  to  Node  N_C0_119
R_R439  N_C0_106  N_C0_119  1.643255e+07m  TC=0,0
R_V1315  N_C0_106  nV_1315  1.060923e+04m  TC=0,0
L_V1315  nV_1315  N_C0_119  7.968346e+02uH
R_V1316  N_C0_106  nV_1316  -1.451916e+02m  TC=0,0
L_V1316  nV_1316  N_C0_119  -2.352835e+02uH
R_V1317  N_C0_106  nV_1317  2.369953e+02m  TC=0,0
L_V1317  nV_1317  N_C0_119  1.331513e+03uH
* *  Node  N_C0_106  to  Node  N_C0_120
R_R440  N_C0_106  N_C0_120  1.534454e+07m  TC=0,0
R_V1318  N_C0_106  nV_1318  9.534862e+03m  TC=0,0
L_V1318  nV_1318  N_C0_120  7.161414e+02uH
R_V1319  N_C0_106  nV_1319  -1.396468e+02m  TC=0,0
L_V1319  nV_1319  N_C0_120  -2.262983e+02uH
R_V1320  N_C0_106  nV_1320  2.223514e+02m  TC=0,0
L_V1320  nV_1320  N_C0_120  1.249239e+03uH
* *  Node  N_C0_106  to  Node  N_C0_121
R_R441  N_C0_106  N_C0_121  1.578833e+06m  TC=0,0
R_V1321  N_C0_106  nV_1321  1.865607e+03m  TC=0,0
L_V1321  nV_1321  N_C0_121  1.401215e+02uH
R_V1322  N_C0_106  nV_1322  -3.005914e+01m  TC=0,0
L_V1322  nV_1322  N_C0_121  -4.871096e+01uH
R_V1323  N_C0_106  nV_1323  1.281441e+00m  TC=0,0
L_V1323  nV_1323  N_C0_121  7.199531e+00uH
* *  Node  N_C0_106  to  Node  N_BUS_GND
R_R442  N_C0_106  N_BUS_GND  7.563719e+07m  TC=0,0
R_V1324  N_C0_106  nV_1324  1.345909e+04m  TC=0,0
L_V1324  nV_1324  N_BUS_GND  1.010881e+03uH
R_V1325  N_C0_106  nV_1325  1.858601e+02m  TC=0,0
L_V1325  nV_1325  N_BUS_GND  3.011870e+02uH
R_V1326  N_C0_106  nV_1326  -1.904610e+02m  TC=0,0
L_V1326  nV_1326  N_BUS_GND  -1.070069e+03uH
*  Node  N_C0_107  to other nodes
* *  Node  N_C0_107  to  Node  N_C0_108
R_R443  N_C0_107  N_C0_108  3.329444e+07m  TC=0,0
R_V1327  N_C0_107  nV_1327  6.327866e+03m  TC=0,0
L_V1327  nV_1327  N_C0_108  4.752714e+02uH
R_V1328  N_C0_107  nV_1328  2.156040e+02m  TC=0,0
L_V1328  nV_1328  N_C0_108  3.493872e+02uH
R_V1329  N_C0_107  nV_1329  -1.964603e+02m  TC=0,0
L_V1329  nV_1329  N_C0_108  -1.103775e+03uH
* *  Node  N_C0_107  to  Node  N_C0_109
R_R444  N_C0_107  N_C0_109  5.965711e+07m  TC=0,0
R_V1330  N_C0_107  nV_1330  -1.253060e+04m  TC=0,0
L_V1330  nV_1330  N_C0_109  -9.411441e+02uH
R_V1331  N_C0_107  nV_1331  -2.095619e+02m  TC=0,0
L_V1331  nV_1331  N_C0_109  -3.395959e+02uH
R_V1332  N_C0_107  nV_1332  1.968159e+02m  TC=0,0
L_V1332  nV_1332  N_C0_109  1.105772e+03uH
* *  Node  N_C0_107  to  Node  N_C0_110
R_R445  N_C0_107  N_C0_110  5.965711e+07m  TC=0,0
R_V1333  N_C0_107  nV_1333  -1.253060e+04m  TC=0,0
L_V1333  nV_1333  N_C0_110  -9.411441e+02uH
R_V1334  N_C0_107  nV_1334  -2.095619e+02m  TC=0,0
L_V1334  nV_1334  N_C0_110  -3.395959e+02uH
R_V1335  N_C0_107  nV_1335  1.968159e+02m  TC=0,0
L_V1335  nV_1335  N_C0_110  1.105772e+03uH
* *  Node  N_C0_107  to  Node  NTMP0000000028
R_R446  N_C0_107  NTMP0000000028  1.284541e+07m  TC=0,0
R_V1336  N_C0_107  nV_1336  -8.036236e+03m  TC=0,0
L_V1336  nV_1336  NTMP0000000028  -6.035831e+02uH
R_V1337  N_C0_107  nV_1337  -3.001866e+02m  TC=0,0
L_V1337  nV_1337  NTMP0000000028  -4.864536e+02uH
R_V1338  N_C0_107  nV_1338  2.710957e+02m  TC=0,0
L_V1338  nV_1338  NTMP0000000028  1.523099e+03uH
* *  Node  N_C0_107  to  Node  N_C0_111
R_R447  N_C0_107  N_C0_111  3.276682e+06m  TC=0,0
R_V1339  N_C0_107  nV_1339  -7.370151e+03m  TC=0,0
L_V1339  nV_1339  N_C0_111  -5.535550e+02uH
R_V1340  N_C0_107  nV_1340  -3.924597e+02m  TC=0,0
L_V1340  nV_1340  N_C0_111  -6.359826e+02uH
R_V1341  N_C0_107  nV_1341  3.461289e+02m  TC=0,0
L_V1341  nV_1341  N_C0_111  1.944659e+03uH
* *  Node  N_C0_107  to  Node  NTMP0000000030
R_R448  N_C0_107  NTMP0000000030  1.284541e+07m  TC=0,0
R_V1342  N_C0_107  nV_1342  -8.036236e+03m  TC=0,0
L_V1342  nV_1342  NTMP0000000030  -6.035831e+02uH
R_V1343  N_C0_107  nV_1343  -3.001866e+02m  TC=0,0
L_V1343  nV_1343  NTMP0000000030  -4.864536e+02uH
R_V1344  N_C0_107  nV_1344  2.710957e+02m  TC=0,0
L_V1344  nV_1344  NTMP0000000030  1.523099e+03uH
* *  Node  N_C0_107  to  Node  N_C0_112
R_R449  N_C0_107  N_C0_112  3.276682e+06m  TC=0,0
R_V1345  N_C0_107  nV_1345  -7.370151e+03m  TC=0,0
L_V1345  nV_1345  N_C0_112  -5.535550e+02uH
R_V1346  N_C0_107  nV_1346  -3.924597e+02m  TC=0,0
L_V1346  nV_1346  N_C0_112  -6.359826e+02uH
R_V1347  N_C0_107  nV_1347  3.461289e+02m  TC=0,0
L_V1347  nV_1347  N_C0_112  1.944659e+03uH
* *  Node  N_C0_107  to  Node  N_BUS_2
R_R450  N_C0_107  N_BUS_2  3.525571e+05m  TC=0,0
R_V1348  N_C0_107  nV_1348  9.573730e+01m  TC=0,0
L_V1348  nV_1348  N_BUS_2  7.190607e+00uH
R_V1349  N_C0_107  nV_1349  1.378079e+00m  TC=0,0
L_V1349  nV_1349  N_BUS_2  2.233182e+00uH
R_V1350  N_C0_107  nV_1350  1.502082e+01m  TC=0,0
L_V1350  nV_1350  N_BUS_2  8.439159e+01uH
* *  Node  N_C0_107  to  Node  N_C0_114
R_R451  N_C0_107  N_C0_114  2.736845e+07m  TC=0,0
R_V1351  N_C0_107  nV_1351  6.046071e+04m  TC=0,0
L_V1351  nV_1351  N_C0_114  4.541064e+03uH
R_V1352  N_C0_107  nV_1352  -2.389659e+05m  TC=0,0
L_V1352  nV_1352  N_C0_114  -3.872453e+05uH
R_V1353  N_C0_107  nV_1353  1.310891e+05m  TC=0,0
L_V1353  nV_1353  N_C0_114  7.364987e+05uH
* *  Node  N_C0_107  to  Node  N_C0_115
R_R452  N_C0_107  N_C0_115  3.526634e+07m  TC=0,0
R_V1354  N_C0_107  nV_1354  4.071809e+04m  TC=0,0
L_V1354  nV_1354  N_C0_115  3.058242e+03uH
R_V1355  N_C0_107  nV_1355  3.460212e+05m  TC=0,0
L_V1355  nV_1355  N_C0_115  5.607289e+05uH
R_V1356  N_C0_107  nV_1356  4.181136e+05m  TC=0,0
L_V1356  nV_1356  N_C0_115  2.349091e+06uH
* *  Node  N_C0_107  to  Node  N_C0_116
R_R453  N_C0_107  N_C0_116  2.736845e+07m  TC=0,0
R_V1357  N_C0_107  nV_1357  6.046071e+04m  TC=0,0
L_V1357  nV_1357  N_C0_116  4.541064e+03uH
R_V1358  N_C0_107  nV_1358  -2.389659e+05m  TC=0,0
L_V1358  nV_1358  N_C0_116  -3.872453e+05uH
R_V1359  N_C0_107  nV_1359  1.310891e+05m  TC=0,0
L_V1359  nV_1359  N_C0_116  7.364987e+05uH
* *  Node  N_C0_107  to  Node  N_C0_117
R_R454  N_C0_107  N_C0_117  3.526634e+07m  TC=0,0
R_V1360  N_C0_107  nV_1360  4.071809e+04m  TC=0,0
L_V1360  nV_1360  N_C0_117  3.058242e+03uH
R_V1361  N_C0_107  nV_1361  3.460212e+05m  TC=0,0
L_V1361  nV_1361  N_C0_117  5.607289e+05uH
R_V1362  N_C0_107  nV_1362  4.181136e+05m  TC=0,0
L_V1362  nV_1362  N_C0_117  2.349091e+06uH
* *  Node  N_C0_107  to  Node  N_C0_118
R_R455  N_C0_107  N_C0_118  2.133959e+07m  TC=0,0
R_V1363  N_C0_107  nV_1363  2.051408e+05m  TC=0,0
L_V1363  nV_1363  N_C0_118  1.540765e+04uH
R_V1364  N_C0_107  nV_1364  -4.692716e+04m  TC=0,0
L_V1364  nV_1364  N_C0_118  -7.604566e+04uH
R_V1365  N_C0_107  nV_1365  7.730395e+04m  TC=0,0
L_V1365  nV_1365  N_C0_118  4.343174e+05uH
* *  Node  N_C0_107  to  Node  N_C0_119
R_R456  N_C0_107  N_C0_119  2.133959e+07m  TC=0,0
R_V1366  N_C0_107  nV_1366  2.051408e+05m  TC=0,0
L_V1366  nV_1366  N_C0_119  1.540765e+04uH
R_V1367  N_C0_107  nV_1367  -4.692716e+04m  TC=0,0
L_V1367  nV_1367  N_C0_119  -7.604566e+04uH
R_V1368  N_C0_107  nV_1368  7.730395e+04m  TC=0,0
L_V1368  nV_1368  N_C0_119  4.343174e+05uH
* *  Node  N_C0_107  to  Node  N_C0_120
R_R457  N_C0_107  N_C0_120  7.948615e+06m  TC=0,0
R_V1369  N_C0_107  nV_1369  2.723352e+04m  TC=0,0
L_V1369  nV_1369  N_C0_120  2.045447e+03uH
R_V1370  N_C0_107  nV_1370  -6.631606e+04m  TC=0,0
L_V1370  nV_1370  N_C0_120  -1.074655e+05uH
R_V1371  N_C0_107  nV_1371  -4.115892e+04m  TC=0,0
L_V1371  nV_1371  N_C0_120  -2.312435e+05uH
* *  Node  N_C0_107  to  Node  N_C0_121
R_R458  N_C0_107  N_C0_121  7.948615e+06m  TC=0,0
R_V1372  N_C0_107  nV_1372  2.723352e+04m  TC=0,0
L_V1372  nV_1372  N_C0_121  2.045447e+03uH
R_V1373  N_C0_107  nV_1373  -6.631606e+04m  TC=0,0
L_V1373  nV_1373  N_C0_121  -1.074655e+05uH
R_V1374  N_C0_107  nV_1374  -4.115892e+04m  TC=0,0
L_V1374  nV_1374  N_C0_121  -2.312435e+05uH
* *  Node  N_C0_107  to  Node  N_BUS_GND
R_R459  N_C0_107  N_BUS_GND  1.119438e+08m  TC=0,0
R_V1375  N_C0_107  nV_1375  3.405108e+04m  TC=0,0
L_V1375  nV_1375  N_BUS_GND  2.557498e+03uH
R_V1376  N_C0_107  nV_1376  -1.792751e+04m  TC=0,0
L_V1376  nV_1376  N_BUS_GND  -2.905161e+04uH
R_V1377  N_C0_107  nV_1377  2.904669e+05m  TC=0,0
L_V1377  nV_1377  N_BUS_GND  1.631933e+06uH
*  Node  N_C0_108  to other nodes
* *  Node  N_C0_108  to  Node  N_C0_109
R_R460  N_C0_108  N_C0_109  1.337180e+06m  TC=0,0
R_V1378  N_C0_108  nV_1378  5.018496e+02m  TC=0,0
L_V1378  nV_1378  N_C0_109  3.769276e+01uH
R_V1379  N_C0_108  nV_1379  5.169883e+00m  TC=0,0
L_V1379  nV_1379  N_C0_109  8.377818e+00uH
R_V1380  N_C0_108  nV_1380  1.323446e+01m  TC=0,0
L_V1380  nV_1380  N_C0_109  7.435528e+01uH
* *  Node  N_C0_108  to  Node  N_C0_110
R_R461  N_C0_108  N_C0_110  1.337180e+06m  TC=0,0
R_V1381  N_C0_108  nV_1381  5.018496e+02m  TC=0,0
L_V1381  nV_1381  N_C0_110  3.769276e+01uH
R_V1382  N_C0_108  nV_1382  5.169883e+00m  TC=0,0
L_V1382  nV_1382  N_C0_110  8.377818e+00uH
R_V1383  N_C0_108  nV_1383  1.323446e+01m  TC=0,0
L_V1383  nV_1383  N_C0_110  7.435528e+01uH
* *  Node  N_C0_108  to  Node  NTMP0000000028
R_R462  N_C0_108  NTMP0000000028  7.292696e+06m  TC=0,0
R_V1384  N_C0_108  nV_1384  1.196287e+04m  TC=0,0
L_V1384  nV_1384  NTMP0000000028  8.985034e+02uH
R_V1385  N_C0_108  nV_1385  3.225756e+02m  TC=0,0
L_V1385  nV_1385  NTMP0000000028  5.227352e+02uH
R_V1386  N_C0_108  nV_1386  -2.936679e+02m  TC=0,0
L_V1386  nV_1386  NTMP0000000028  -1.649917e+03uH
* *  Node  N_C0_108  to  Node  N_C0_111
R_R463  N_C0_108  N_C0_111  2.814961e+07m  TC=0,0
R_V1387  N_C0_108  nV_1387  1.014021e+04m  TC=0,0
L_V1387  nV_1387  N_C0_111  7.616080e+02uH
R_V1388  N_C0_108  nV_1388  2.708786e+02m  TC=0,0
L_V1388  nV_1388  N_C0_111  4.389600e+02uH
R_V1389  N_C0_108  nV_1389  -2.520714e+02m  TC=0,0
L_V1389  nV_1389  N_C0_111  -1.416215e+03uH
* *  Node  N_C0_108  to  Node  NTMP0000000030
R_R464  N_C0_108  NTMP0000000030  7.292696e+06m  TC=0,0
R_V1390  N_C0_108  nV_1390  1.196287e+04m  TC=0,0
L_V1390  nV_1390  NTMP0000000030  8.985034e+02uH
R_V1391  N_C0_108  nV_1391  3.225756e+02m  TC=0,0
L_V1391  nV_1391  NTMP0000000030  5.227352e+02uH
R_V1392  N_C0_108  nV_1392  -2.936679e+02m  TC=0,0
L_V1392  nV_1392  NTMP0000000030  -1.649917e+03uH
* *  Node  N_C0_108  to  Node  N_C0_112
R_R465  N_C0_108  N_C0_112  2.814961e+07m  TC=0,0
R_V1393  N_C0_108  nV_1393  1.014021e+04m  TC=0,0
L_V1393  nV_1393  N_C0_112  7.616080e+02uH
R_V1394  N_C0_108  nV_1394  2.708786e+02m  TC=0,0
L_V1394  nV_1394  N_C0_112  4.389600e+02uH
R_V1395  N_C0_108  nV_1395  -2.520714e+02m  TC=0,0
L_V1395  nV_1395  N_C0_112  -1.416215e+03uH
* *  Node  N_C0_108  to  Node  N_BUS_2
R_R466  N_C0_108  N_BUS_2  5.655665e+07m  TC=0,0
R_V1396  N_C0_108  nV_1396  -1.660317e+04m  TC=0,0
L_V1396  nV_1396  N_BUS_2  -1.247026e+03uH
R_V1397  N_C0_108  nV_1397  -3.191131e+02m  TC=0,0
L_V1397  nV_1397  N_BUS_2  -5.171242e+02uH
R_V1398  N_C0_108  nV_1398  2.963491e+02m  TC=0,0
L_V1398  nV_1398  N_BUS_2  1.664980e+03uH
* *  Node  N_C0_108  to  Node  N_C0_114
R_R467  N_C0_108  N_C0_114  1.187386e+07m  TC=0,0
R_V1399  N_C0_108  nV_1399  1.122315e+04m  TC=0,0
L_V1399  nV_1399  N_C0_114  8.429450e+02uH
R_V1400  N_C0_108  nV_1400  1.343685e+02m  TC=0,0
L_V1400  nV_1400  N_C0_114  2.177447e+02uH
R_V1401  N_C0_108  nV_1401  -1.397164e+02m  TC=0,0
L_V1401  nV_1401  N_C0_114  -7.849695e+02uH
* *  Node  N_C0_108  to  Node  N_C0_115
R_R468  N_C0_108  N_C0_115  1.959361e+07m  TC=0,0
R_V1402  N_C0_108  nV_1402  2.896582e+04m  TC=0,0
L_V1402  nV_1402  N_C0_115  2.175556e+03uH
R_V1403  N_C0_108  nV_1403  2.179112e+02m  TC=0,0
L_V1403  nV_1403  N_C0_115  3.531260e+02uH
R_V1404  N_C0_108  nV_1404  -2.305494e+02m  TC=0,0
L_V1404  nV_1404  N_C0_115  -1.295297e+03uH
* *  Node  N_C0_108  to  Node  N_C0_116
R_R469  N_C0_108  N_C0_116  1.187386e+07m  TC=0,0
R_V1405  N_C0_108  nV_1405  1.122315e+04m  TC=0,0
L_V1405  nV_1405  N_C0_116  8.429450e+02uH
R_V1406  N_C0_108  nV_1406  1.343685e+02m  TC=0,0
L_V1406  nV_1406  N_C0_116  2.177447e+02uH
R_V1407  N_C0_108  nV_1407  -1.397164e+02m  TC=0,0
L_V1407  nV_1407  N_C0_116  -7.849695e+02uH
* *  Node  N_C0_108  to  Node  N_C0_117
R_R470  N_C0_108  N_C0_117  1.959361e+07m  TC=0,0
R_V1408  N_C0_108  nV_1408  2.896582e+04m  TC=0,0
L_V1408  nV_1408  N_C0_117  2.175556e+03uH
R_V1409  N_C0_108  nV_1409  2.179112e+02m  TC=0,0
L_V1409  nV_1409  N_C0_117  3.531260e+02uH
R_V1410  N_C0_108  nV_1410  -2.305494e+02m  TC=0,0
L_V1410  nV_1410  N_C0_117  -1.295297e+03uH
* *  Node  N_C0_108  to  Node  N_C0_118
R_R471  N_C0_108  N_C0_118  9.298273e+06m  TC=0,0
R_V1411  N_C0_108  nV_1411  6.882641e+03m  TC=0,0
L_V1411  nV_1411  N_C0_118  5.169393e+02uH
R_V1412  N_C0_108  nV_1412  1.008816e+02m  TC=0,0
L_V1412  nV_1412  N_C0_118  1.634791e+02uH
R_V1413  N_C0_108  nV_1413  -1.031808e+02m  TC=0,0
L_V1413  nV_1413  N_C0_118  -5.797017e+02uH
* *  Node  N_C0_108  to  Node  N_C0_119
R_R472  N_C0_108  N_C0_119  9.298273e+06m  TC=0,0
R_V1414  N_C0_108  nV_1414  6.882641e+03m  TC=0,0
L_V1414  nV_1414  N_C0_119  5.169393e+02uH
R_V1415  N_C0_108  nV_1415  1.008816e+02m  TC=0,0
L_V1415  nV_1415  N_C0_119  1.634791e+02uH
R_V1416  N_C0_108  nV_1416  -1.031808e+02m  TC=0,0
L_V1416  nV_1416  N_C0_119  -5.797017e+02uH
* *  Node  N_C0_108  to  Node  N_C0_120
R_R473  N_C0_108  N_C0_120  2.095502e+07m  TC=0,0
R_V1417  N_C0_108  nV_1417  1.548474e+04m  TC=0,0
L_V1417  nV_1417  N_C0_120  1.163023e+03uH
R_V1418  N_C0_108  nV_1418  1.852857e+02m  TC=0,0
L_V1418  nV_1418  N_C0_120  3.002562e+02uH
R_V1419  N_C0_108  nV_1419  -1.902888e+02m  TC=0,0
L_V1419  nV_1419  N_C0_120  -1.069101e+03uH
* *  Node  N_C0_108  to  Node  N_C0_121
R_R474  N_C0_108  N_C0_121  2.095502e+07m  TC=0,0
R_V1420  N_C0_108  nV_1420  1.548474e+04m  TC=0,0
L_V1420  nV_1420  N_C0_121  1.163023e+03uH
R_V1421  N_C0_108  nV_1421  1.852857e+02m  TC=0,0
L_V1421  nV_1421  N_C0_121  3.002562e+02uH
R_V1422  N_C0_108  nV_1422  -1.902888e+02m  TC=0,0
L_V1422  nV_1422  N_C0_121  -1.069101e+03uH
* *  Node  N_C0_108  to  Node  N_BUS_GND
R_R475  N_C0_108  N_BUS_GND  3.292962e+05m  TC=0,0
R_V1423  N_C0_108  nV_1423  5.785737e+01m  TC=0,0
L_V1423  nV_1423  N_BUS_GND  4.345533e+00uH
R_V1424  N_C0_108  nV_1424  9.206718e-01m  TC=0,0
L_V1424  nV_1424  N_BUS_GND  1.491953e+00uH
R_V1425  N_C0_108  nV_1425  2.603398e+01m  TC=0,0
L_V1425  nV_1425  N_BUS_GND  1.462669e+02uH
*  Node  N_C0_109  to other nodes
* *  Node  N_C0_109  to  Node  N_C0_110
R_R476  N_C0_109  N_C0_110  2.340178e+07m  TC=0,0
R_V1426  N_C0_109  nV_1426  -3.596231e+03m  TC=0,0
L_V1426  nV_1426  N_C0_110  -2.701046e+02uH
R_V1427  N_C0_109  nV_1427  -1.229229e+02m  TC=0,0
L_V1427  nV_1427  N_C0_110  -1.991971e+02uH
R_V1428  N_C0_109  nV_1428  1.124242e+02m  TC=0,0
L_V1428  nV_1428  N_C0_110  6.316338e+02uH
* *  Node  N_C0_109  to  Node  NTMP0000000028
R_R477  N_C0_109  NTMP0000000028  1.295710e+06m  TC=0,0
R_V1429  N_C0_109  nV_1429  4.592768e+02m  TC=0,0
L_V1429  nV_1429  NTMP0000000028  3.449522e+01uH
R_V1430  N_C0_109  nV_1430  4.980478e+00m  TC=0,0
L_V1430  nV_1430  NTMP0000000028  8.070886e+00uH
R_V1431  N_C0_109  nV_1431  1.479627e+01m  TC=0,0
L_V1431  nV_1431  NTMP0000000028  8.313002e+01uH
* *  Node  N_C0_109  to  Node  N_C0_111
R_R478  N_C0_109  N_C0_111  1.310271e+08m  TC=0,0
R_V1432  N_C0_109  nV_1432  -4.794119e+03m  TC=0,0
L_V1432  nV_1432  N_C0_111  -3.600752e+02uH
R_V1433  N_C0_109  nV_1433  -1.255089e+02m  TC=0,0
L_V1433  nV_1433  N_C0_111  -2.033877e+02uH
R_V1434  N_C0_109  nV_1434  1.161789e+02m  TC=0,0
L_V1434  nV_1434  N_C0_111  6.527289e+02uH
* *  Node  N_C0_109  to  Node  NTMP0000000030
R_R479  N_C0_109  NTMP0000000030  3.305565e+07m  TC=0,0
R_V1435  N_C0_109  nV_1435  -1.862992e+04m  TC=0,0
L_V1435  nV_1435  NTMP0000000030  -1.399250e+03uH
R_V1436  N_C0_109  nV_1436  -3.624584e+03m  TC=0,0
L_V1436  nV_1436  NTMP0000000030  -5.873653e+03uH
R_V1437  N_C0_109  nV_1437  3.028116e+03m  TC=0,0
L_V1437  nV_1437  NTMP0000000030  1.701289e+04uH
* *  Node  N_C0_109  to  Node  N_C0_112
R_R480  N_C0_109  N_C0_112  -8.337906e+07m  TC=0,0
R_V1438  N_C0_109  nV_1438  -8.890863e+03m  TC=0,0
L_V1438  nV_1438  N_C0_112  -6.677722e+02uH
R_V1439  N_C0_109  nV_1439  -1.587831e+02m  TC=0,0
L_V1439  nV_1439  N_C0_112  -2.573087e+02uH
R_V1440  N_C0_109  nV_1440  1.514357e+02m  TC=0,0
L_V1440  nV_1440  N_C0_112  8.508122e+02uH
* *  Node  N_C0_109  to  Node  N_BUS_2
R_R481  N_C0_109  N_BUS_2  2.100409e+07m  TC=0,0
R_V1441  N_C0_109  nV_1441  1.045430e+04m  TC=0,0
L_V1441  nV_1441  N_BUS_2  7.851982e+02uH
R_V1442  N_C0_109  nV_1442  2.564125e+02m  TC=0,0
L_V1442  nV_1442  N_BUS_2  4.155175e+02uH
R_V1443  N_C0_109  nV_1443  -2.384916e+02m  TC=0,0
L_V1443  nV_1443  N_BUS_2  -1.339919e+03uH
* *  Node  N_C0_109  to  Node  N_C0_114
R_R482  N_C0_109  N_C0_114  4.544996e+07m  TC=0,0
R_V1444  N_C0_109  nV_1444  -3.819415e+05m  TC=0,0
L_V1444  nV_1444  N_C0_114  -2.868675e+04uH
R_V1445  N_C0_109  nV_1445  -9.739882e+04m  TC=0,0
L_V1445  nV_1445  N_C0_114  -1.578352e+05uH
R_V1446  N_C0_109  nV_1446  1.916381e+05m  TC=0,0
L_V1446  nV_1446  N_C0_114  1.076682e+06uH
* *  Node  N_C0_109  to  Node  N_C0_115
R_R483  N_C0_109  N_C0_115  1.035798e+08m  TC=0,0
R_V1447  N_C0_109  nV_1447  -5.625937e+04m  TC=0,0
L_V1447  nV_1447  N_C0_115  -4.225511e+03uH
R_V1448  N_C0_109  nV_1448  -8.848530e+04m  TC=0,0
L_V1448  nV_1448  N_C0_115  -1.433908e+05uH
R_V1449  N_C0_109  nV_1449  2.494020e+05m  TC=0,0
L_V1449  nV_1449  N_C0_115  1.401217e+06uH
* *  Node  N_C0_109  to  Node  N_C0_116
R_R484  N_C0_109  N_C0_116  4.477816e+07m  TC=0,0
R_V1450  N_C0_109  nV_1450  -3.942533e+05m  TC=0,0
L_V1450  nV_1450  N_C0_116  -2.961145e+04uH
R_V1451  N_C0_109  nV_1451  -9.613720e+04m  TC=0,0
L_V1451  nV_1451  N_C0_116  -1.557907e+05uH
R_V1452  N_C0_109  nV_1452  1.883548e+05m  TC=0,0
L_V1452  nV_1452  N_C0_116  1.058235e+06uH
* *  Node  N_C0_109  to  Node  N_C0_117
R_R485  N_C0_109  N_C0_117  8.297734e+07m  TC=0,0
R_V1453  N_C0_109  nV_1453  -5.624026e+04m  TC=0,0
L_V1453  nV_1453  N_C0_117  -4.224076e+03uH
R_V1454  N_C0_109  nV_1454  -8.853720e+04m  TC=0,0
L_V1454  nV_1454  N_C0_117  -1.434749e+05uH
R_V1455  N_C0_109  nV_1455  2.496125e+05m  TC=0,0
L_V1455  nV_1455  N_C0_117  1.402400e+06uH
* *  Node  N_C0_109  to  Node  N_C0_118
R_R486  N_C0_109  N_C0_118  1.070086e+07m  TC=0,0
R_V1456  N_C0_109  nV_1456  9.896076e+04m  TC=0,0
L_V1456  nV_1456  N_C0_118  7.432714e+03uH
R_V1457  N_C0_109  nV_1457  -1.571004e+05m  TC=0,0
L_V1457  nV_1457  N_C0_118  -2.545819e+05uH
R_V1458  N_C0_109  nV_1458  -2.159993e+06m  TC=0,0
L_V1458  nV_1458  N_C0_118  -1.213551e+07uH
* *  Node  N_C0_109  to  Node  N_C0_119
R_R487  N_C0_109  N_C0_119  3.617886e+07m  TC=0,0
R_V1459  N_C0_109  nV_1459  8.516539e+04m  TC=0,0
L_V1459  nV_1459  N_C0_119  6.396576e+03uH
R_V1460  N_C0_109  nV_1460  -1.115726e+05m  TC=0,0
L_V1460  nV_1460  N_C0_119  -1.808039e+05uH
R_V1461  N_C0_109  nV_1461  7.950715e+05m  TC=0,0
L_V1461  nV_1461  N_C0_119  4.466956e+06uH
* *  Node  N_C0_109  to  Node  N_C0_120
R_R488  N_C0_109  N_C0_120  4.318943e+07m  TC=0,0
R_V1462  N_C0_109  nV_1462  -9.033469e+04m  TC=0,0
L_V1462  nV_1462  N_C0_120  -6.784829e+03uH
R_V1463  N_C0_109  nV_1463  -4.203352e+04m  TC=0,0
L_V1463  nV_1463  N_C0_120  -6.811550e+04uH
R_V1464  N_C0_109  nV_1464  -3.218096e+05m  TC=0,0
L_V1464  nV_1464  N_C0_120  -1.808025e+06uH
* *  Node  N_C0_109  to  Node  N_C0_121
R_R489  N_C0_109  N_C0_121  5.819834e+07m  TC=0,0
R_V1465  N_C0_109  nV_1465  -9.190531e+04m  TC=0,0
L_V1465  nV_1465  N_C0_121  -6.902795e+03uH
R_V1466  N_C0_109  nV_1466  -4.150617e+04m  TC=0,0
L_V1466  nV_1466  N_C0_121  -6.726093e+04uH
R_V1467  N_C0_109  nV_1467  -3.440587e+05m  TC=0,0
L_V1467  nV_1467  N_C0_121  -1.933028e+06uH
* *  Node  N_C0_109  to  Node  N_BUS_GND
R_R490  N_C0_109  N_BUS_GND  5.775298e+07m  TC=0,0
R_V1468  N_C0_109  nV_1468  -2.190578e+04m  TC=0,0
L_V1468  nV_1468  N_BUS_GND  -1.645293e+03uH
R_V1469  N_C0_109  nV_1469  1.285700e+04m  TC=0,0
L_V1469  nV_1469  N_BUS_GND  2.083483e+04uH
R_V1470  N_C0_109  nV_1470  1.105191e+06m  TC=0,0
L_V1470  nV_1470  N_BUS_GND  6.209301e+06uH
*  Node  N_C0_110  to other nodes
* *  Node  N_C0_110  to  Node  NTMP0000000028
R_R491  N_C0_110  NTMP0000000028  3.305565e+07m  TC=0,0
R_V1471  N_C0_110  nV_1471  -1.862992e+04m  TC=0,0
L_V1471  nV_1471  NTMP0000000028  -1.399250e+03uH
R_V1472  N_C0_110  nV_1472  -3.624584e+03m  TC=0,0
L_V1472  nV_1472  NTMP0000000028  -5.873653e+03uH
R_V1473  N_C0_110  nV_1473  3.028116e+03m  TC=0,0
L_V1473  nV_1473  NTMP0000000028  1.701289e+04uH
* *  Node  N_C0_110  to  Node  N_C0_111
R_R492  N_C0_110  N_C0_111  -8.337906e+07m  TC=0,0
R_V1474  N_C0_110  nV_1474  -8.890863e+03m  TC=0,0
L_V1474  nV_1474  N_C0_111  -6.677722e+02uH
R_V1475  N_C0_110  nV_1475  -1.587831e+02m  TC=0,0
L_V1475  nV_1475  N_C0_111  -2.573087e+02uH
R_V1476  N_C0_110  nV_1476  1.514357e+02m  TC=0,0
L_V1476  nV_1476  N_C0_111  8.508122e+02uH
* *  Node  N_C0_110  to  Node  NTMP0000000030
R_R493  N_C0_110  NTMP0000000030  1.295710e+06m  TC=0,0
R_V1477  N_C0_110  nV_1477  4.592768e+02m  TC=0,0
L_V1477  nV_1477  NTMP0000000030  3.449522e+01uH
R_V1478  N_C0_110  nV_1478  4.980478e+00m  TC=0,0
L_V1478  nV_1478  NTMP0000000030  8.070886e+00uH
R_V1479  N_C0_110  nV_1479  1.479627e+01m  TC=0,0
L_V1479  nV_1479  NTMP0000000030  8.313002e+01uH
* *  Node  N_C0_110  to  Node  N_C0_112
R_R494  N_C0_110  N_C0_112  1.310271e+08m  TC=0,0
R_V1480  N_C0_110  nV_1480  -4.794119e+03m  TC=0,0
L_V1480  nV_1480  N_C0_112  -3.600752e+02uH
R_V1481  N_C0_110  nV_1481  -1.255089e+02m  TC=0,0
L_V1481  nV_1481  N_C0_112  -2.033877e+02uH
R_V1482  N_C0_110  nV_1482  1.161789e+02m  TC=0,0
L_V1482  nV_1482  N_C0_112  6.527289e+02uH
* *  Node  N_C0_110  to  Node  N_BUS_2
R_R495  N_C0_110  N_BUS_2  2.100409e+07m  TC=0,0
R_V1483  N_C0_110  nV_1483  1.045430e+04m  TC=0,0
L_V1483  nV_1483  N_BUS_2  7.851982e+02uH
R_V1484  N_C0_110  nV_1484  2.564125e+02m  TC=0,0
L_V1484  nV_1484  N_BUS_2  4.155175e+02uH
R_V1485  N_C0_110  nV_1485  -2.384916e+02m  TC=0,0
L_V1485  nV_1485  N_BUS_2  -1.339919e+03uH
* *  Node  N_C0_110  to  Node  N_C0_114
R_R496  N_C0_110  N_C0_114  4.477816e+07m  TC=0,0
R_V1486  N_C0_110  nV_1486  -3.942533e+05m  TC=0,0
L_V1486  nV_1486  N_C0_114  -2.961145e+04uH
R_V1487  N_C0_110  nV_1487  -9.613720e+04m  TC=0,0
L_V1487  nV_1487  N_C0_114  -1.557907e+05uH
R_V1488  N_C0_110  nV_1488  1.883548e+05m  TC=0,0
L_V1488  nV_1488  N_C0_114  1.058235e+06uH
* *  Node  N_C0_110  to  Node  N_C0_115
R_R497  N_C0_110  N_C0_115  8.297734e+07m  TC=0,0
R_V1489  N_C0_110  nV_1489  -5.624026e+04m  TC=0,0
L_V1489  nV_1489  N_C0_115  -4.224076e+03uH
R_V1490  N_C0_110  nV_1490  -8.853720e+04m  TC=0,0
L_V1490  nV_1490  N_C0_115  -1.434749e+05uH
R_V1491  N_C0_110  nV_1491  2.496125e+05m  TC=0,0
L_V1491  nV_1491  N_C0_115  1.402400e+06uH
* *  Node  N_C0_110  to  Node  N_C0_116
R_R498  N_C0_110  N_C0_116  4.544996e+07m  TC=0,0
R_V1492  N_C0_110  nV_1492  -3.819415e+05m  TC=0,0
L_V1492  nV_1492  N_C0_116  -2.868675e+04uH
R_V1493  N_C0_110  nV_1493  -9.739882e+04m  TC=0,0
L_V1493  nV_1493  N_C0_116  -1.578352e+05uH
R_V1494  N_C0_110  nV_1494  1.916381e+05m  TC=0,0
L_V1494  nV_1494  N_C0_116  1.076682e+06uH
* *  Node  N_C0_110  to  Node  N_C0_117
R_R499  N_C0_110  N_C0_117  1.035798e+08m  TC=0,0
R_V1495  N_C0_110  nV_1495  -5.625937e+04m  TC=0,0
L_V1495  nV_1495  N_C0_117  -4.225511e+03uH
R_V1496  N_C0_110  nV_1496  -8.848530e+04m  TC=0,0
L_V1496  nV_1496  N_C0_117  -1.433908e+05uH
R_V1497  N_C0_110  nV_1497  2.494020e+05m  TC=0,0
L_V1497  nV_1497  N_C0_117  1.401217e+06uH
* *  Node  N_C0_110  to  Node  N_C0_118
R_R500  N_C0_110  N_C0_118  3.617886e+07m  TC=0,0
R_V1498  N_C0_110  nV_1498  8.516539e+04m  TC=0,0
L_V1498  nV_1498  N_C0_118  6.396576e+03uH
R_V1499  N_C0_110  nV_1499  -1.115726e+05m  TC=0,0
L_V1499  nV_1499  N_C0_118  -1.808039e+05uH
R_V1500  N_C0_110  nV_1500  7.950715e+05m  TC=0,0
L_V1500  nV_1500  N_C0_118  4.466956e+06uH
* *  Node  N_C0_110  to  Node  N_C0_119
R_R501  N_C0_110  N_C0_119  1.070086e+07m  TC=0,0
R_V1501  N_C0_110  nV_1501  9.896076e+04m  TC=0,0
L_V1501  nV_1501  N_C0_119  7.432714e+03uH
R_V1502  N_C0_110  nV_1502  -1.571004e+05m  TC=0,0
L_V1502  nV_1502  N_C0_119  -2.545819e+05uH
R_V1503  N_C0_110  nV_1503  -2.159993e+06m  TC=0,0
L_V1503  nV_1503  N_C0_119  -1.213551e+07uH
* *  Node  N_C0_110  to  Node  N_C0_120
R_R502  N_C0_110  N_C0_120  5.819834e+07m  TC=0,0
R_V1504  N_C0_110  nV_1504  -9.190531e+04m  TC=0,0
L_V1504  nV_1504  N_C0_120  -6.902795e+03uH
R_V1505  N_C0_110  nV_1505  -4.150617e+04m  TC=0,0
L_V1505  nV_1505  N_C0_120  -6.726093e+04uH
R_V1506  N_C0_110  nV_1506  -3.440587e+05m  TC=0,0
L_V1506  nV_1506  N_C0_120  -1.933028e+06uH
* *  Node  N_C0_110  to  Node  N_C0_121
R_R503  N_C0_110  N_C0_121  4.318943e+07m  TC=0,0
R_V1507  N_C0_110  nV_1507  -9.033469e+04m  TC=0,0
L_V1507  nV_1507  N_C0_121  -6.784829e+03uH
R_V1508  N_C0_110  nV_1508  -4.203352e+04m  TC=0,0
L_V1508  nV_1508  N_C0_121  -6.811550e+04uH
R_V1509  N_C0_110  nV_1509  -3.218096e+05m  TC=0,0
L_V1509  nV_1509  N_C0_121  -1.808025e+06uH
* *  Node  N_C0_110  to  Node  N_BUS_GND
R_R504  N_C0_110  N_BUS_GND  5.775298e+07m  TC=0,0
R_V1510  N_C0_110  nV_1510  -2.190578e+04m  TC=0,0
L_V1510  nV_1510  N_BUS_GND  -1.645293e+03uH
R_V1511  N_C0_110  nV_1511  1.285700e+04m  TC=0,0
L_V1511  nV_1511  N_BUS_GND  2.083483e+04uH
R_V1512  N_C0_110  nV_1512  1.105191e+06m  TC=0,0
L_V1512  nV_1512  N_BUS_GND  6.209301e+06uH
*  Node  NTMP0000000028  to other nodes
* *  Node  NTMP0000000028  to  Node  N_C0_111
R_R505  NTMP0000000028  N_C0_111  1.280698e+06m  TC=0,0
R_V1513  NTMP0000000028  nV_1513  4.629184e+02m  TC=0,0
L_V1513  nV_1513  N_C0_111  3.476873e+01uH
R_V1514  NTMP0000000028  nV_1514  4.983674e+00m  TC=0,0
L_V1514  nV_1514  N_C0_111  8.076065e+00uH
R_V1515  NTMP0000000028  nV_1515  1.475813e+01m  TC=0,0
L_V1515  nV_1515  N_C0_111  8.291571e+01uH
* *  Node  NTMP0000000028  to  Node  NTMP0000000030
R_R506  NTMP0000000028  NTMP0000000030  2.419227e+07m  TC=0,0
R_V1516  NTMP0000000028  nV_1516  -1.607337e+04m  TC=0,0
L_V1516  nV_1516  NTMP0000000030  -1.207234e+03uH
R_V1517  NTMP0000000028  nV_1517  1.080842e+03m  TC=0,0
L_V1517  nV_1517  NTMP0000000030  1.751509e+03uH
R_V1518  NTMP0000000028  nV_1518  -1.105902e+03m  TC=0,0
L_V1518  nV_1518  NTMP0000000030  -6.213299e+03uH
* *  Node  NTMP0000000028  to  Node  N_C0_112
R_R507  NTMP0000000028  N_C0_112  2.713860e+07m  TC=0,0
R_V1519  NTMP0000000028  nV_1519  -1.412016e+04m  TC=0,0
L_V1519  nV_1519  N_C0_112  -1.060533e+03uH
R_V1520  NTMP0000000028  nV_1520  -2.449614e+03m  TC=0,0
L_V1520  nV_1520  N_C0_112  -3.969610e+03uH
R_V1521  NTMP0000000028  nV_1521  1.964465e+03m  TC=0,0
L_V1521  nV_1521  N_C0_112  1.103697e+04uH
* *  Node  NTMP0000000028  to  Node  N_BUS_2
R_R508  NTMP0000000028  N_BUS_2  7.286320e+06m  TC=0,0
R_V1522  NTMP0000000028  nV_1522  1.225223e+04m  TC=0,0
L_V1522  nV_1522  N_BUS_2  9.202367e+02uH
R_V1523  NTMP0000000028  nV_1523  2.965436e+02m  TC=0,0
L_V1523  nV_1523  N_BUS_2  4.805502e+02uH
R_V1524  NTMP0000000028  nV_1524  -2.698018e+02m  TC=0,0
L_V1524  nV_1524  N_BUS_2  -1.515829e+03uH
* *  Node  NTMP0000000028  to  Node  N_C0_114
R_R509  NTMP0000000028  N_C0_114  4.819181e+08m  TC=0,0
R_V1525  NTMP0000000028  nV_1525  -2.742652e+05m  TC=0,0
L_V1525  nV_1525  N_C0_114  -2.059942e+04uH
R_V1526  NTMP0000000028  nV_1526  -1.039767e+05m  TC=0,0
L_V1526  nV_1526  N_C0_114  -1.684946e+05uH
R_V1527  NTMP0000000028  nV_1527  -2.746111e+05m  TC=0,0
L_V1527  nV_1527  N_C0_114  -1.542850e+06uH
* *  Node  NTMP0000000028  to  Node  N_C0_115
R_R510  NTMP0000000028  N_C0_115  -1.628528e+09m  TC=0,0
R_V1528  NTMP0000000028  nV_1528  -1.244045e+05m  TC=0,0
L_V1528  nV_1528  N_C0_115  -9.343736e+03uH
R_V1529  NTMP0000000028  nV_1529  -1.930794e+05m  TC=0,0
L_V1529  nV_1529  N_C0_115  -3.128860e+05uH
R_V1530  NTMP0000000028  nV_1530  -3.033780e+05m  TC=0,0
L_V1530  nV_1530  N_C0_115  -1.704471e+06uH
* *  Node  NTMP0000000028  to  Node  N_C0_116
R_R511  NTMP0000000028  N_C0_116  -3.855905e+08m  TC=0,0
R_V1531  NTMP0000000028  nV_1531  -2.827926e+05m  TC=0,0
L_V1531  nV_1531  N_C0_116  -2.123990e+04uH
R_V1532  NTMP0000000028  nV_1532  -1.021280e+05m  TC=0,0
L_V1532  nV_1532  N_C0_116  -1.654989e+05uH
R_V1533  NTMP0000000028  nV_1533  -2.835823e+05m  TC=0,0
L_V1533  nV_1533  N_C0_116  -1.593253e+06uH
* *  Node  NTMP0000000028  to  Node  N_C0_117
R_R512  NTMP0000000028  N_C0_117  -3.625132e+08m  TC=0,0
R_V1534  NTMP0000000028  nV_1534  -1.251923e+05m  TC=0,0
L_V1534  nV_1534  N_C0_117  -9.402901e+03uH
R_V1535  NTMP0000000028  nV_1535  -1.901392e+05m  TC=0,0
L_V1535  nV_1535  N_C0_117  -3.081213e+05uH
R_V1536  NTMP0000000028  nV_1536  -3.083356e+05m  TC=0,0
L_V1536  nV_1536  N_C0_117  -1.732324e+06uH
* *  Node  NTMP0000000028  to  Node  N_C0_118
R_R513  NTMP0000000028  N_C0_118  1.949284e+07m  TC=0,0
R_V1537  NTMP0000000028  nV_1537  -2.744319e+05m  TC=0,0
L_V1537  nV_1537  N_C0_118  -2.061195e+04uH
R_V1538  NTMP0000000028  nV_1538  -5.740551e+04m  TC=0,0
L_V1538  nV_1538  N_C0_118  -9.302588e+04uH
R_V1539  NTMP0000000028  nV_1539  1.555669e+05m  TC=0,0
L_V1539  nV_1539  N_C0_118  8.740227e+05uH
* *  Node  NTMP0000000028  to  Node  N_C0_119
R_R514  NTMP0000000028  N_C0_119  1.165824e+08m  TC=0,0
R_V1540  NTMP0000000028  nV_1540  -3.779141e+05m  TC=0,0
L_V1540  nV_1540  N_C0_119  -2.838425e+04uH
R_V1541  NTMP0000000028  nV_1541  -5.263218e+04m  TC=0,0
L_V1541  nV_1541  N_C0_119  -8.529067e+04uH
R_V1542  NTMP0000000028  nV_1542  1.338057e+05m  TC=0,0
L_V1542  nV_1542  N_C0_119  7.517615e+05uH
* *  Node  NTMP0000000028  to  Node  N_C0_120
R_R515  NTMP0000000028  N_C0_120  1.568615e+07m  TC=0,0
R_V1543  NTMP0000000028  nV_1543  -4.707350e+05m  TC=0,0
L_V1543  nV_1543  N_C0_120  -3.535582e+04uH
R_V1544  NTMP0000000028  nV_1544  -4.230117e+04m  TC=0,0
L_V1544  nV_1544  N_C0_120  -6.854923e+04uH
R_V1545  NTMP0000000028  nV_1545  1.242435e+05m  TC=0,0
L_V1545  nV_1545  N_C0_120  6.980381e+05uH
* *  Node  NTMP0000000028  to  Node  N_C0_121
R_R516  NTMP0000000028  N_C0_121  4.854740e+07m  TC=0,0
R_V1546  NTMP0000000028  nV_1546  -8.961588e+05m  TC=0,0
L_V1546  nV_1546  N_C0_121  -6.730841e+04uH
R_V1547  NTMP0000000028  nV_1547  -3.962468e+04m  TC=0,0
L_V1547  nV_1547  N_C0_121  -6.421197e+04uH
R_V1548  NTMP0000000028  nV_1548  1.098255e+05m  TC=0,0
L_V1548  nV_1548  N_C0_121  6.170337e+05uH
* *  Node  NTMP0000000028  to  Node  N_BUS_GND
R_R517  NTMP0000000028  N_BUS_GND  2.139724e+08m  TC=0,0
R_V1549  NTMP0000000028  nV_1549  -1.600828e+05m  TC=0,0
L_V1549  nV_1549  N_BUS_GND  -1.202345e+04uH
R_V1550  NTMP0000000028  nV_1550  2.333810e+05m  TC=0,0
L_V1550  nV_1550  N_BUS_GND  3.781950e+05uH
R_V1551  NTMP0000000028  nV_1551  1.811585e+05m  TC=0,0
L_V1551  nV_1551  N_BUS_GND  1.017804e+06uH
*  Node  N_C0_111  to other nodes
* *  Node  N_C0_111  to  Node  NTMP0000000030
R_R518  N_C0_111  NTMP0000000030  2.713860e+07m  TC=0,0
R_V1552  N_C0_111  nV_1552  -1.412016e+04m  TC=0,0
L_V1552  nV_1552  NTMP0000000030  -1.060533e+03uH
R_V1553  N_C0_111  nV_1553  -2.449614e+03m  TC=0,0
L_V1553  nV_1553  NTMP0000000030  -3.969610e+03uH
R_V1554  N_C0_111  nV_1554  1.964465e+03m  TC=0,0
L_V1554  nV_1554  NTMP0000000030  1.103697e+04uH
* *  Node  N_C0_111  to  Node  N_C0_112
R_R519  N_C0_111  N_C0_112  4.306636e+07m  TC=0,0
R_V1555  N_C0_111  nV_1555  -3.280380e+03m  TC=0,0
L_V1555  nV_1555  N_C0_112  -2.463818e+02uH
R_V1556  N_C0_111  nV_1556  -1.234270e+02m  TC=0,0
L_V1556  nV_1556  N_C0_112  -2.000140e+02uH
R_V1557  N_C0_111  nV_1557  1.125936e+02m  TC=0,0
L_V1557  nV_1557  N_C0_112  6.325856e+02uH
* *  Node  N_C0_111  to  Node  N_BUS_2
R_R520  N_C0_111  N_BUS_2  1.327939e+06m  TC=0,0
R_V1558  N_C0_111  nV_1558  5.145682e+02m  TC=0,0
L_V1558  nV_1558  N_BUS_2  3.864803e+01uH
R_V1559  N_C0_111  nV_1559  5.180116e+00m  TC=0,0
L_V1559  nV_1559  N_BUS_2  8.394400e+00uH
R_V1560  N_C0_111  nV_1560  1.315193e+01m  TC=0,0
L_V1560  nV_1560  N_BUS_2  7.389157e+01uH
* *  Node  N_C0_111  to  Node  N_C0_114
R_R521  N_C0_111  N_C0_114  4.928998e+07m  TC=0,0
R_V1561  N_C0_111  nV_1561  3.050664e+06m  TC=0,0
L_V1561  nV_1561  N_C0_114  2.291283e+05uH
R_V1562  N_C0_111  nV_1562  -1.364762e+05m  TC=0,0
L_V1562  nV_1562  N_C0_114  -2.211603e+05uH
R_V1563  N_C0_111  nV_1563  6.580387e+05m  TC=0,0
L_V1563  nV_1563  N_C0_114  3.697064e+06uH
* *  Node  N_C0_111  to  Node  N_C0_115
R_R522  N_C0_111  N_C0_115  6.903884e+07m  TC=0,0
R_V1564  N_C0_111  nV_1564  1.084824e+05m  TC=0,0
L_V1564  nV_1564  N_C0_115  8.147861e+03uH
R_V1565  N_C0_111  nV_1565  1.066580e+06m  TC=0,0
L_V1565  nV_1565  N_C0_115  1.728397e+06uH
R_V1566  N_C0_111  nV_1566  3.293793e+05m  TC=0,0
L_V1566  nV_1566  N_C0_115  1.850554e+06uH
* *  Node  N_C0_111  to  Node  N_C0_116
R_R523  N_C0_111  N_C0_116  8.303381e+07m  TC=0,0
R_V1567  N_C0_111  nV_1567  2.120267e+06m  TC=0,0
L_V1567  nV_1567  N_C0_116  1.592484e+05uH
R_V1568  N_C0_111  nV_1568  -1.324132e+05m  TC=0,0
L_V1568  nV_1568  N_C0_116  -2.145761e+05uH
R_V1569  N_C0_111  nV_1569  5.997189e+05m  TC=0,0
L_V1569  nV_1569  N_C0_116  3.369405e+06uH
* *  Node  N_C0_111  to  Node  N_C0_117
R_R524  N_C0_111  N_C0_117  9.900615e+07m  TC=0,0
R_V1570  N_C0_111  nV_1570  1.076009e+05m  TC=0,0
L_V1570  nV_1570  N_C0_117  8.081654e+03uH
R_V1571  N_C0_111  nV_1571  1.220076e+06m  TC=0,0
L_V1571  nV_1571  N_C0_117  1.977139e+06uH
R_V1572  N_C0_111  nV_1572  3.211804e+05m  TC=0,0
L_V1572  nV_1572  N_C0_117  1.804490e+06uH
* *  Node  N_C0_111  to  Node  N_C0_118
R_R525  N_C0_111  N_C0_118  2.721992e+07m  TC=0,0
R_V1573  N_C0_111  nV_1573  -6.389895e+04m  TC=0,0
L_V1573  nV_1573  N_C0_118  -4.799302e+03uH
R_V1574  N_C0_111  nV_1574  -4.016511e+04m  TC=0,0
L_V1574  nV_1574  N_C0_118  -6.508774e+04uH
R_V1575  N_C0_111  nV_1575  -1.561337e+05m  TC=0,0
L_V1575  nV_1575  N_C0_118  -8.772071e+05uH
* *  Node  N_C0_111  to  Node  N_C0_119
R_R526  N_C0_111  N_C0_119  5.958827e+07m  TC=0,0
R_V1576  N_C0_111  nV_1576  -6.564099e+04m  TC=0,0
L_V1576  nV_1576  N_C0_119  -4.930143e+03uH
R_V1577  N_C0_111  nV_1577  -3.913632e+04m  TC=0,0
L_V1577  nV_1577  N_C0_119  -6.342058e+04uH
R_V1578  N_C0_111  nV_1578  -1.674271e+05m  TC=0,0
L_V1578  nV_1578  N_C0_119  -9.406570e+05uH
* *  Node  N_C0_111  to  Node  N_C0_120
R_R527  N_C0_111  N_C0_120  8.472183e+06m  TC=0,0
R_V1579  N_C0_111  nV_1579  9.492629e+04m  TC=0,0
L_V1579  nV_1579  N_C0_120  7.129694e+03uH
R_V1580  N_C0_111  nV_1580  -5.094857e+04m  TC=0,0
L_V1580  nV_1580  N_C0_120  -8.256237e+04uH
R_V1581  N_C0_111  nV_1581  2.813064e+05m  TC=0,0
L_V1581  nV_1581  N_C0_120  1.580466e+06uH
* *  Node  N_C0_111  to  Node  N_C0_121
R_R528  N_C0_111  N_C0_121  3.063781e+07m  TC=0,0
R_V1582  N_C0_111  nV_1582  7.997078e+04m  TC=0,0
L_V1582  nV_1582  N_C0_121  6.006421e+03uH
R_V1583  N_C0_111  nV_1583  -4.396479e+04m  TC=0,0
L_V1583  nV_1583  N_C0_121  -7.124513e+04uH
R_V1584  N_C0_111  nV_1584  1.780162e+05m  TC=0,0
L_V1584  nV_1584  N_C0_121  1.000149e+06uH
* *  Node  N_C0_111  to  Node  N_BUS_GND
R_R529  N_C0_111  N_BUS_GND  2.235050e+08m  TC=0,0
R_V1585  N_C0_111  nV_1585  3.381704e+04m  TC=0,0
L_V1585  nV_1585  N_BUS_GND  2.539919e+03uH
R_V1586  N_C0_111  nV_1586  -2.079461e+04m  TC=0,0
L_V1586  nV_1586  N_BUS_GND  -3.369775e+04uH
R_V1587  N_C0_111  nV_1587  -1.008621e+06m  TC=0,0
L_V1587  nV_1587  N_BUS_GND  -5.666740e+06uH
*  Node  NTMP0000000030  to other nodes
* *  Node  NTMP0000000030  to  Node  N_C0_112
R_R530  NTMP0000000030  N_C0_112  1.280698e+06m  TC=0,0
R_V1588  NTMP0000000030  nV_1588  4.629184e+02m  TC=0,0
L_V1588  nV_1588  N_C0_112  3.476873e+01uH
R_V1589  NTMP0000000030  nV_1589  4.983674e+00m  TC=0,0
L_V1589  nV_1589  N_C0_112  8.076065e+00uH
R_V1590  NTMP0000000030  nV_1590  1.475813e+01m  TC=0,0
L_V1590  nV_1590  N_C0_112  8.291571e+01uH
* *  Node  NTMP0000000030  to  Node  N_BUS_2
R_R531  NTMP0000000030  N_BUS_2  7.286320e+06m  TC=0,0
R_V1591  NTMP0000000030  nV_1591  1.225223e+04m  TC=0,0
L_V1591  nV_1591  N_BUS_2  9.202367e+02uH
R_V1592  NTMP0000000030  nV_1592  2.965436e+02m  TC=0,0
L_V1592  nV_1592  N_BUS_2  4.805502e+02uH
R_V1593  NTMP0000000030  nV_1593  -2.698018e+02m  TC=0,0
L_V1593  nV_1593  N_BUS_2  -1.515829e+03uH
* *  Node  NTMP0000000030  to  Node  N_C0_114
R_R532  NTMP0000000030  N_C0_114  -3.855905e+08m  TC=0,0
R_V1594  NTMP0000000030  nV_1594  -2.827926e+05m  TC=0,0
L_V1594  nV_1594  N_C0_114  -2.123990e+04uH
R_V1595  NTMP0000000030  nV_1595  -1.021280e+05m  TC=0,0
L_V1595  nV_1595  N_C0_114  -1.654989e+05uH
R_V1596  NTMP0000000030  nV_1596  -2.835823e+05m  TC=0,0
L_V1596  nV_1596  N_C0_114  -1.593253e+06uH
* *  Node  NTMP0000000030  to  Node  N_C0_115
R_R533  NTMP0000000030  N_C0_115  -3.625132e+08m  TC=0,0
R_V1597  NTMP0000000030  nV_1597  -1.251923e+05m  TC=0,0
L_V1597  nV_1597  N_C0_115  -9.402901e+03uH
R_V1598  NTMP0000000030  nV_1598  -1.901392e+05m  TC=0,0
L_V1598  nV_1598  N_C0_115  -3.081213e+05uH
R_V1599  NTMP0000000030  nV_1599  -3.083356e+05m  TC=0,0
L_V1599  nV_1599  N_C0_115  -1.732324e+06uH
* *  Node  NTMP0000000030  to  Node  N_C0_116
R_R534  NTMP0000000030  N_C0_116  4.819181e+08m  TC=0,0
R_V1600  NTMP0000000030  nV_1600  -2.742652e+05m  TC=0,0
L_V1600  nV_1600  N_C0_116  -2.059942e+04uH
R_V1601  NTMP0000000030  nV_1601  -1.039767e+05m  TC=0,0
L_V1601  nV_1601  N_C0_116  -1.684946e+05uH
R_V1602  NTMP0000000030  nV_1602  -2.746111e+05m  TC=0,0
L_V1602  nV_1602  N_C0_116  -1.542850e+06uH
* *  Node  NTMP0000000030  to  Node  N_C0_117
R_R535  NTMP0000000030  N_C0_117  -1.628528e+09m  TC=0,0
R_V1603  NTMP0000000030  nV_1603  -1.244045e+05m  TC=0,0
L_V1603  nV_1603  N_C0_117  -9.343736e+03uH
R_V1604  NTMP0000000030  nV_1604  -1.930794e+05m  TC=0,0
L_V1604  nV_1604  N_C0_117  -3.128860e+05uH
R_V1605  NTMP0000000030  nV_1605  -3.033780e+05m  TC=0,0
L_V1605  nV_1605  N_C0_117  -1.704471e+06uH
* *  Node  NTMP0000000030  to  Node  N_C0_118
R_R536  NTMP0000000030  N_C0_118  1.165824e+08m  TC=0,0
R_V1606  NTMP0000000030  nV_1606  -3.779141e+05m  TC=0,0
L_V1606  nV_1606  N_C0_118  -2.838425e+04uH
R_V1607  NTMP0000000030  nV_1607  -5.263218e+04m  TC=0,0
L_V1607  nV_1607  N_C0_118  -8.529067e+04uH
R_V1608  NTMP0000000030  nV_1608  1.338057e+05m  TC=0,0
L_V1608  nV_1608  N_C0_118  7.517615e+05uH
* *  Node  NTMP0000000030  to  Node  N_C0_119
R_R537  NTMP0000000030  N_C0_119  1.949284e+07m  TC=0,0
R_V1609  NTMP0000000030  nV_1609  -2.744319e+05m  TC=0,0
L_V1609  nV_1609  N_C0_119  -2.061195e+04uH
R_V1610  NTMP0000000030  nV_1610  -5.740551e+04m  TC=0,0
L_V1610  nV_1610  N_C0_119  -9.302588e+04uH
R_V1611  NTMP0000000030  nV_1611  1.555669e+05m  TC=0,0
L_V1611  nV_1611  N_C0_119  8.740227e+05uH
* *  Node  NTMP0000000030  to  Node  N_C0_120
R_R538  NTMP0000000030  N_C0_120  4.854740e+07m  TC=0,0
R_V1612  NTMP0000000030  nV_1612  -8.961588e+05m  TC=0,0
L_V1612  nV_1612  N_C0_120  -6.730841e+04uH
R_V1613  NTMP0000000030  nV_1613  -3.962468e+04m  TC=0,0
L_V1613  nV_1613  N_C0_120  -6.421197e+04uH
R_V1614  NTMP0000000030  nV_1614  1.098255e+05m  TC=0,0
L_V1614  nV_1614  N_C0_120  6.170337e+05uH
* *  Node  NTMP0000000030  to  Node  N_C0_121
R_R539  NTMP0000000030  N_C0_121  1.568615e+07m  TC=0,0
R_V1615  NTMP0000000030  nV_1615  -4.707350e+05m  TC=0,0
L_V1615  nV_1615  N_C0_121  -3.535582e+04uH
R_V1616  NTMP0000000030  nV_1616  -4.230117e+04m  TC=0,0
L_V1616  nV_1616  N_C0_121  -6.854923e+04uH
R_V1617  NTMP0000000030  nV_1617  1.242435e+05m  TC=0,0
L_V1617  nV_1617  N_C0_121  6.980381e+05uH
* *  Node  NTMP0000000030  to  Node  N_BUS_GND
R_R540  NTMP0000000030  N_BUS_GND  2.139724e+08m  TC=0,0
R_V1618  NTMP0000000030  nV_1618  -1.600828e+05m  TC=0,0
L_V1618  nV_1618  N_BUS_GND  -1.202345e+04uH
R_V1619  NTMP0000000030  nV_1619  2.333810e+05m  TC=0,0
L_V1619  nV_1619  N_BUS_GND  3.781950e+05uH
R_V1620  NTMP0000000030  nV_1620  1.811585e+05m  TC=0,0
L_V1620  nV_1620  N_BUS_GND  1.017804e+06uH
*  Node  N_C0_112  to other nodes
* *  Node  N_C0_112  to  Node  N_BUS_2
R_R541  N_C0_112  N_BUS_2  1.327939e+06m  TC=0,0
R_V1621  N_C0_112  nV_1621  5.145682e+02m  TC=0,0
L_V1621  nV_1621  N_BUS_2  3.864803e+01uH
R_V1622  N_C0_112  nV_1622  5.180116e+00m  TC=0,0
L_V1622  nV_1622  N_BUS_2  8.394400e+00uH
R_V1623  N_C0_112  nV_1623  1.315193e+01m  TC=0,0
L_V1623  nV_1623  N_BUS_2  7.389157e+01uH
* *  Node  N_C0_112  to  Node  N_C0_114
R_R542  N_C0_112  N_C0_114  8.303381e+07m  TC=0,0
R_V1624  N_C0_112  nV_1624  2.120267e+06m  TC=0,0
L_V1624  nV_1624  N_C0_114  1.592484e+05uH
R_V1625  N_C0_112  nV_1625  -1.324132e+05m  TC=0,0
L_V1625  nV_1625  N_C0_114  -2.145761e+05uH
R_V1626  N_C0_112  nV_1626  5.997189e+05m  TC=0,0
L_V1626  nV_1626  N_C0_114  3.369405e+06uH
* *  Node  N_C0_112  to  Node  N_C0_115
R_R543  N_C0_112  N_C0_115  9.900615e+07m  TC=0,0
R_V1627  N_C0_112  nV_1627  1.076009e+05m  TC=0,0
L_V1627  nV_1627  N_C0_115  8.081654e+03uH
R_V1628  N_C0_112  nV_1628  1.220076e+06m  TC=0,0
L_V1628  nV_1628  N_C0_115  1.977139e+06uH
R_V1629  N_C0_112  nV_1629  3.211804e+05m  TC=0,0
L_V1629  nV_1629  N_C0_115  1.804490e+06uH
* *  Node  N_C0_112  to  Node  N_C0_116
R_R544  N_C0_112  N_C0_116  4.928998e+07m  TC=0,0
R_V1630  N_C0_112  nV_1630  3.050664e+06m  TC=0,0
L_V1630  nV_1630  N_C0_116  2.291283e+05uH
R_V1631  N_C0_112  nV_1631  -1.364762e+05m  TC=0,0
L_V1631  nV_1631  N_C0_116  -2.211603e+05uH
R_V1632  N_C0_112  nV_1632  6.580387e+05m  TC=0,0
L_V1632  nV_1632  N_C0_116  3.697064e+06uH
* *  Node  N_C0_112  to  Node  N_C0_117
R_R545  N_C0_112  N_C0_117  6.903884e+07m  TC=0,0
R_V1633  N_C0_112  nV_1633  1.084824e+05m  TC=0,0
L_V1633  nV_1633  N_C0_117  8.147861e+03uH
R_V1634  N_C0_112  nV_1634  1.066580e+06m  TC=0,0
L_V1634  nV_1634  N_C0_117  1.728397e+06uH
R_V1635  N_C0_112  nV_1635  3.293793e+05m  TC=0,0
L_V1635  nV_1635  N_C0_117  1.850554e+06uH
* *  Node  N_C0_112  to  Node  N_C0_118
R_R546  N_C0_112  N_C0_118  5.958827e+07m  TC=0,0
R_V1636  N_C0_112  nV_1636  -6.564099e+04m  TC=0,0
L_V1636  nV_1636  N_C0_118  -4.930143e+03uH
R_V1637  N_C0_112  nV_1637  -3.913632e+04m  TC=0,0
L_V1637  nV_1637  N_C0_118  -6.342058e+04uH
R_V1638  N_C0_112  nV_1638  -1.674271e+05m  TC=0,0
L_V1638  nV_1638  N_C0_118  -9.406570e+05uH
* *  Node  N_C0_112  to  Node  N_C0_119
R_R547  N_C0_112  N_C0_119  2.721992e+07m  TC=0,0
R_V1639  N_C0_112  nV_1639  -6.389895e+04m  TC=0,0
L_V1639  nV_1639  N_C0_119  -4.799302e+03uH
R_V1640  N_C0_112  nV_1640  -4.016511e+04m  TC=0,0
L_V1640  nV_1640  N_C0_119  -6.508774e+04uH
R_V1641  N_C0_112  nV_1641  -1.561337e+05m  TC=0,0
L_V1641  nV_1641  N_C0_119  -8.772071e+05uH
* *  Node  N_C0_112  to  Node  N_C0_120
R_R548  N_C0_112  N_C0_120  3.063781e+07m  TC=0,0
R_V1642  N_C0_112  nV_1642  7.997078e+04m  TC=0,0
L_V1642  nV_1642  N_C0_120  6.006421e+03uH
R_V1643  N_C0_112  nV_1643  -4.396479e+04m  TC=0,0
L_V1643  nV_1643  N_C0_120  -7.124513e+04uH
R_V1644  N_C0_112  nV_1644  1.780162e+05m  TC=0,0
L_V1644  nV_1644  N_C0_120  1.000149e+06uH
* *  Node  N_C0_112  to  Node  N_C0_121
R_R549  N_C0_112  N_C0_121  8.472183e+06m  TC=0,0
R_V1645  N_C0_112  nV_1645  9.492629e+04m  TC=0,0
L_V1645  nV_1645  N_C0_121  7.129694e+03uH
R_V1646  N_C0_112  nV_1646  -5.094857e+04m  TC=0,0
L_V1646  nV_1646  N_C0_121  -8.256237e+04uH
R_V1647  N_C0_112  nV_1647  2.813064e+05m  TC=0,0
L_V1647  nV_1647  N_C0_121  1.580466e+06uH
* *  Node  N_C0_112  to  Node  N_BUS_GND
R_R550  N_C0_112  N_BUS_GND  2.235050e+08m  TC=0,0
R_V1648  N_C0_112  nV_1648  3.381704e+04m  TC=0,0
L_V1648  nV_1648  N_BUS_GND  2.539919e+03uH
R_V1649  N_C0_112  nV_1649  -2.079461e+04m  TC=0,0
L_V1649  nV_1649  N_BUS_GND  -3.369775e+04uH
R_V1650  N_C0_112  nV_1650  -1.008621e+06m  TC=0,0
L_V1650  nV_1650  N_BUS_GND  -5.666740e+06uH
*  Node  N_BUS_2  to other nodes
* *  Node  N_BUS_2  to  Node  N_C0_114
R_R551  N_BUS_2  N_C0_114  3.164890e+07m  TC=0,0
R_V1651  N_BUS_2  nV_1651  8.050519e+04m  TC=0,0
L_V1651  nV_1651  N_C0_114  6.046559e+03uH
R_V1652  N_BUS_2  nV_1652  -1.871928e+05m  TC=0,0
L_V1652  nV_1652  N_C0_114  -3.033468e+05uH
R_V1653  N_BUS_2  nV_1653  1.410972e+05m  TC=0,0
L_V1653  nV_1653  N_C0_114  7.927275e+05uH
* *  Node  N_BUS_2  to  Node  N_C0_115
R_R552  N_BUS_2  N_C0_115  4.259905e+07m  TC=0,0
R_V1654  N_BUS_2  nV_1654  4.707541e+04m  TC=0,0
L_V1654  nV_1654  N_C0_115  3.535725e+03uH
R_V1655  N_BUS_2  nV_1655  3.989593e+05m  TC=0,0
L_V1655  nV_1655  N_C0_115  6.465152e+05uH
R_V1656  N_BUS_2  nV_1656  1.995252e+05m  TC=0,0
L_V1656  nV_1656  N_C0_115  1.120994e+06uH
* *  Node  N_BUS_2  to  Node  N_C0_116
R_R553  N_BUS_2  N_C0_116  3.164890e+07m  TC=0,0
R_V1657  N_BUS_2  nV_1657  8.050519e+04m  TC=0,0
L_V1657  nV_1657  N_C0_116  6.046559e+03uH
R_V1658  N_BUS_2  nV_1658  -1.871928e+05m  TC=0,0
L_V1658  nV_1658  N_C0_116  -3.033468e+05uH
R_V1659  N_BUS_2  nV_1659  1.410972e+05m  TC=0,0
L_V1659  nV_1659  N_C0_116  7.927275e+05uH
* *  Node  N_BUS_2  to  Node  N_C0_117
R_R554  N_BUS_2  N_C0_117  4.259905e+07m  TC=0,0
R_V1660  N_BUS_2  nV_1660  4.707541e+04m  TC=0,0
L_V1660  nV_1660  N_C0_117  3.535725e+03uH
R_V1661  N_BUS_2  nV_1661  3.989593e+05m  TC=0,0
L_V1661  nV_1661  N_C0_117  6.465152e+05uH
R_V1662  N_BUS_2  nV_1662  1.995252e+05m  TC=0,0
L_V1662  nV_1662  N_C0_117  1.120994e+06uH
* *  Node  N_BUS_2  to  Node  N_C0_118
R_R555  N_BUS_2  N_C0_118  2.394623e+07m  TC=0,0
R_V1663  N_BUS_2  nV_1663  -3.354636e+05m  TC=0,0
L_V1663  nV_1663  N_C0_118  -2.519589e+04uH
R_V1664  N_BUS_2  nV_1664  -4.314507e+04m  TC=0,0
L_V1664  nV_1664  N_C0_118  -6.991677e+04uH
R_V1665  N_BUS_2  nV_1665  2.660834e+05m  TC=0,0
L_V1665  nV_1665  N_C0_118  1.494938e+06uH
* *  Node  N_BUS_2  to  Node  N_C0_119
R_R556  N_BUS_2  N_C0_119  2.394623e+07m  TC=0,0
R_V1666  N_BUS_2  nV_1666  -3.354636e+05m  TC=0,0
L_V1666  nV_1666  N_C0_119  -2.519589e+04uH
R_V1667  N_BUS_2  nV_1667  -4.314507e+04m  TC=0,0
L_V1667  nV_1667  N_C0_119  -6.991677e+04uH
R_V1668  N_BUS_2  nV_1668  2.660834e+05m  TC=0,0
L_V1668  nV_1668  N_C0_119  1.494938e+06uH
* *  Node  N_BUS_2  to  Node  N_C0_120
R_R557  N_BUS_2  N_C0_120  1.248410e+07m  TC=0,0
R_V1669  N_BUS_2  nV_1669  3.286900e+04m  TC=0,0
L_V1669  nV_1669  N_C0_120  2.468715e+03uH
R_V1670  N_BUS_2  nV_1670  -6.068502e+04m  TC=0,0
L_V1670  nV_1670  N_C0_120  -9.834034e+04uH
R_V1671  N_BUS_2  nV_1671  -9.778635e+04m  TC=0,0
L_V1671  nV_1671  N_C0_120  -5.493938e+05uH
* *  Node  N_BUS_2  to  Node  N_C0_121
R_R558  N_BUS_2  N_C0_121  1.248410e+07m  TC=0,0
R_V1672  N_BUS_2  nV_1672  3.286900e+04m  TC=0,0
L_V1672  nV_1672  N_C0_121  2.468715e+03uH
R_V1673  N_BUS_2  nV_1673  -6.068502e+04m  TC=0,0
L_V1673  nV_1673  N_C0_121  -9.834034e+04uH
R_V1674  N_BUS_2  nV_1674  -9.778635e+04m  TC=0,0
L_V1674  nV_1674  N_C0_121  -5.493938e+05uH
* *  Node  N_BUS_2  to  Node  N_BUS_GND
R_R559  N_BUS_2  N_BUS_GND  1.024311e+08m  TC=0,0
R_V1675  N_BUS_2  nV_1675  3.375503e+04m  TC=0,0
L_V1675  nV_1675  N_BUS_GND  2.535262e+03uH
R_V1676  N_BUS_2  nV_1676  -1.773218e+04m  TC=0,0
L_V1676  nV_1676  N_BUS_GND  -2.873508e+04uH
R_V1677  N_BUS_2  nV_1677  -3.045872e+05m  TC=0,0
L_V1677  nV_1677  N_BUS_GND  -1.711265e+06uH
*  Node  N_C0_114  to other nodes
* *  Node  N_C0_114  to  Node  N_C0_115
R_R560  N_C0_114  N_C0_115  7.623393e+06m  TC=0,0
R_V1678  N_C0_114  nV_1678  -3.491474e+03m  TC=0,0
L_V1678  nV_1678  N_C0_115  -2.622365e+02uH
R_V1679  N_C0_114  nV_1679  6.033951e+01m  TC=0,0
L_V1679  nV_1679  N_C0_115  9.778043e+01uH
R_V1680  N_C0_114  nV_1680  -1.001647e+02m  TC=0,0
L_V1680  nV_1680  N_C0_115  -5.627559e+02uH
* *  Node  N_C0_114  to  Node  N_C0_116
R_R561  N_C0_114  N_C0_116  8.759413e+06m  TC=0,0
R_V1681  N_C0_114  nV_1681  -3.296968e+03m  TC=0,0
L_V1681  nV_1681  N_C0_116  -2.476277e+02uH
R_V1682  N_C0_114  nV_1682  6.105192e+01m  TC=0,0
L_V1682  nV_1682  N_C0_116  9.893490e+01uH
R_V1683  N_C0_114  nV_1683  -1.025452e+02m  TC=0,0
L_V1683  nV_1683  N_C0_116  -5.761304e+02uH
* *  Node  N_C0_114  to  Node  N_C0_117
R_R562  N_C0_114  N_C0_117  1.583047e+07m  TC=0,0
R_V1684  N_C0_114  nV_1684  -4.134506e+03m  TC=0,0
L_V1684  nV_1684  N_C0_117  -3.105332e+02uH
R_V1685  N_C0_114  nV_1685  9.022717e+01m  TC=0,0
L_V1685  nV_1685  N_C0_117  1.462135e+02uH
R_V1686  N_C0_114  nV_1686  -1.635479e+02m  TC=0,0
L_V1686  nV_1686  N_C0_117  -9.188622e+02uH
* *  Node  N_C0_114  to  Node  N_C0_118
R_R563  N_C0_114  N_C0_118  1.636949e+07m  TC=0,0
R_V1687  N_C0_114  nV_1687  -6.259996e+03m  TC=0,0
L_V1687  nV_1687  N_C0_118  -4.701738e+02uH
R_V1688  N_C0_114  nV_1688  9.136573e+01m  TC=0,0
L_V1688  nV_1688  N_C0_118  1.480586e+02uH
R_V1689  N_C0_114  nV_1689  -1.530868e+02m  TC=0,0
L_V1689  nV_1689  N_C0_118  -8.600888e+02uH
* *  Node  N_C0_114  to  Node  N_C0_119
R_R564  N_C0_114  N_C0_119  5.245796e+07m  TC=0,0
R_V1690  N_C0_114  nV_1690  -7.854127e+03m  TC=0,0
L_V1690  nV_1690  N_C0_119  -5.899053e+02uH
R_V1691  N_C0_114  nV_1691  1.428151e+02m  TC=0,0
L_V1691  nV_1691  N_C0_119  2.314326e+02uH
R_V1692  N_C0_114  nV_1692  -2.621167e+02m  TC=0,0
L_V1692  nV_1692  N_C0_119  -1.472652e+03uH
* *  Node  N_C0_114  to  Node  N_C0_120
R_R565  N_C0_114  N_C0_120  1.029875e+08m  TC=0,0
R_V1693  N_C0_114  nV_1693  -1.446739e+04m  TC=0,0
L_V1693  nV_1693  N_C0_120  -1.086612e+03uH
R_V1694  N_C0_114  nV_1694  2.628175e+02m  TC=0,0
L_V1694  nV_1694  N_C0_120  4.258968e+02uH
R_V1695  N_C0_114  nV_1695  -4.920953e+02m  TC=0,0
L_V1695  nV_1695  N_C0_120  -2.764743e+03uH
* *  Node  N_C0_114  to  Node  N_C0_121
R_R566  N_C0_114  N_C0_121  1.382290e+08m  TC=0,0
R_V1696  N_C0_114  nV_1696  -1.512220e+04m  TC=0,0
L_V1696  nV_1696  N_C0_121  -1.135793e+03uH
R_V1697  N_C0_114  nV_1697  2.897940e+02m  TC=0,0
L_V1697  nV_1697  N_C0_121  4.696123e+02uH
R_V1698  N_C0_114  nV_1698  -5.556551e+02m  TC=0,0
L_V1698  nV_1698  N_C0_121  -3.121841e+03uH
* *  Node  N_C0_114  to  Node  N_BUS_GND
R_R567  N_C0_114  N_BUS_GND  -4.777980e+07m  TC=0,0
R_V1699  N_C0_114  nV_1699  -1.623187e+04m  TC=0,0
L_V1699  nV_1699  N_BUS_GND  -1.219138e+03uH
R_V1700  N_C0_114  nV_1700  -1.339915e+02m  TC=0,0
L_V1700  nV_1700  N_BUS_GND  -2.171338e+02uH
R_V1701  N_C0_114  nV_1701  1.397465e+02m  TC=0,0
L_V1701  nV_1701  N_BUS_GND  7.851390e+02uH
*  Node  N_C0_115  to other nodes
* *  Node  N_C0_115  to  Node  N_C0_116
R_R568  N_C0_115  N_C0_116  1.583047e+07m  TC=0,0
R_V1702  N_C0_115  nV_1702  -4.134506e+03m  TC=0,0
L_V1702  nV_1702  N_C0_116  -3.105332e+02uH
R_V1703  N_C0_115  nV_1703  9.022717e+01m  TC=0,0
L_V1703  nV_1703  N_C0_116  1.462135e+02uH
R_V1704  N_C0_115  nV_1704  -1.635479e+02m  TC=0,0
L_V1704  nV_1704  N_C0_116  -9.188622e+02uH
* *  Node  N_C0_115  to  Node  N_C0_117
R_R569  N_C0_115  N_C0_117  6.872043e+06m  TC=0,0
R_V1705  N_C0_115  nV_1705  -2.970681e+03m  TC=0,0
L_V1705  nV_1705  N_C0_117  -2.231210e+02uH
R_V1706  N_C0_115  nV_1706  5.944814e+01m  TC=0,0
L_V1706  nV_1706  N_C0_117  9.633596e+01uH
R_V1707  N_C0_115  nV_1707  -9.823756e+01m  TC=0,0
L_V1707  nV_1707  N_C0_117  -5.519288e+02uH
* *  Node  N_C0_115  to  Node  N_C0_118
R_R570  N_C0_115  N_C0_118  3.836298e+07m  TC=0,0
R_V1708  N_C0_115  nV_1708  -1.151922e+04m  TC=0,0
L_V1708  nV_1708  N_C0_118  -8.651820e+02uH
R_V1709  N_C0_115  nV_1709  1.574265e+02m  TC=0,0
L_V1709  nV_1709  N_C0_118  2.551103e+02uH
R_V1710  N_C0_115  nV_1710  -2.885843e+02m  TC=0,0
L_V1710  nV_1710  N_C0_118  -1.621355e+03uH
* *  Node  N_C0_115  to  Node  N_C0_119
R_R571  N_C0_115  N_C0_119  8.342241e+07m  TC=0,0
R_V1711  N_C0_115  nV_1711  -1.326006e+04m  TC=0,0
L_V1711  nV_1711  N_C0_119  -9.959324e+02uH
R_V1712  N_C0_115  nV_1712  2.003578e+02m  TC=0,0
L_V1712  nV_1712  N_C0_119  3.246807e+02uH
R_V1713  N_C0_115  nV_1713  -3.921320e+02m  TC=0,0
L_V1713  nV_1713  N_C0_119  -2.203118e+03uH
* *  Node  N_C0_115  to  Node  N_C0_120
R_R572  N_C0_115  N_C0_120  1.092944e+08m  TC=0,0
R_V1714  N_C0_115  nV_1714  -3.176959e+04m  TC=0,0
L_V1714  nV_1714  N_C0_120  -2.386140e+03uH
R_V1715  N_C0_115  nV_1715  3.371711e+02m  TC=0,0
L_V1715  nV_1715  N_C0_120  5.463873e+02uH
R_V1716  N_C0_115  nV_1716  -6.460082e+02m  TC=0,0
L_V1716  nV_1716  N_C0_120  -3.629473e+03uH
* *  Node  N_C0_115  to  Node  N_C0_121
R_R573  N_C0_115  N_C0_121  1.327995e+08m  TC=0,0
R_V1717  N_C0_115  nV_1717  -3.352747e+04m  TC=0,0
L_V1717  nV_1717  N_C0_121  -2.518171e+03uH
R_V1718  N_C0_115  nV_1718  3.609486e+02m  TC=0,0
L_V1718  nV_1718  N_C0_121  5.849187e+02uH
R_V1719  N_C0_115  nV_1719  -7.046168e+02m  TC=0,0
L_V1719  nV_1719  N_C0_121  -3.958754e+03uH
* *  Node  N_C0_115  to  Node  N_BUS_GND
R_R574  N_C0_115  N_BUS_GND  -6.987728e+07m  TC=0,0
R_V1720  N_C0_115  nV_1720  -1.903785e+04m  TC=0,0
L_V1720  nV_1720  N_BUS_GND  -1.429889e+03uH
R_V1721  N_C0_115  nV_1721  -2.165020e+02m  TC=0,0
L_V1721  nV_1721  N_BUS_GND  -3.508424e+02uH
R_V1722  N_C0_115  nV_1722  2.306850e+02m  TC=0,0
L_V1722  nV_1722  N_BUS_GND  1.296059e+03uH
*  Node  N_C0_116  to other nodes
* *  Node  N_C0_116  to  Node  N_C0_117
R_R575  N_C0_116  N_C0_117  7.623393e+06m  TC=0,0
R_V1723  N_C0_116  nV_1723  -3.491474e+03m  TC=0,0
L_V1723  nV_1723  N_C0_117  -2.622365e+02uH
R_V1724  N_C0_116  nV_1724  6.033951e+01m  TC=0,0
L_V1724  nV_1724  N_C0_117  9.778043e+01uH
R_V1725  N_C0_116  nV_1725  -1.001647e+02m  TC=0,0
L_V1725  nV_1725  N_C0_117  -5.627559e+02uH
* *  Node  N_C0_116  to  Node  N_C0_118
R_R576  N_C0_116  N_C0_118  5.245796e+07m  TC=0,0
R_V1726  N_C0_116  nV_1726  -7.854127e+03m  TC=0,0
L_V1726  nV_1726  N_C0_118  -5.899053e+02uH
R_V1727  N_C0_116  nV_1727  1.428151e+02m  TC=0,0
L_V1727  nV_1727  N_C0_118  2.314326e+02uH
R_V1728  N_C0_116  nV_1728  -2.621167e+02m  TC=0,0
L_V1728  nV_1728  N_C0_118  -1.472652e+03uH
* *  Node  N_C0_116  to  Node  N_C0_119
R_R577  N_C0_116  N_C0_119  1.636949e+07m  TC=0,0
R_V1729  N_C0_116  nV_1729  -6.259996e+03m  TC=0,0
L_V1729  nV_1729  N_C0_119  -4.701738e+02uH
R_V1730  N_C0_116  nV_1730  9.136573e+01m  TC=0,0
L_V1730  nV_1730  N_C0_119  1.480586e+02uH
R_V1731  N_C0_116  nV_1731  -1.530868e+02m  TC=0,0
L_V1731  nV_1731  N_C0_119  -8.600888e+02uH
* *  Node  N_C0_116  to  Node  N_C0_120
R_R578  N_C0_116  N_C0_120  1.382290e+08m  TC=0,0
R_V1732  N_C0_116  nV_1732  -1.512220e+04m  TC=0,0
L_V1732  nV_1732  N_C0_120  -1.135793e+03uH
R_V1733  N_C0_116  nV_1733  2.897940e+02m  TC=0,0
L_V1733  nV_1733  N_C0_120  4.696123e+02uH
R_V1734  N_C0_116  nV_1734  -5.556551e+02m  TC=0,0
L_V1734  nV_1734  N_C0_120  -3.121841e+03uH
* *  Node  N_C0_116  to  Node  N_C0_121
R_R579  N_C0_116  N_C0_121  1.029875e+08m  TC=0,0
R_V1735  N_C0_116  nV_1735  -1.446739e+04m  TC=0,0
L_V1735  nV_1735  N_C0_121  -1.086612e+03uH
R_V1736  N_C0_116  nV_1736  2.628175e+02m  TC=0,0
L_V1736  nV_1736  N_C0_121  4.258968e+02uH
R_V1737  N_C0_116  nV_1737  -4.920953e+02m  TC=0,0
L_V1737  nV_1737  N_C0_121  -2.764743e+03uH
* *  Node  N_C0_116  to  Node  N_BUS_GND
R_R580  N_C0_116  N_BUS_GND  -4.777980e+07m  TC=0,0
R_V1738  N_C0_116  nV_1738  -1.623187e+04m  TC=0,0
L_V1738  nV_1738  N_BUS_GND  -1.219138e+03uH
R_V1739  N_C0_116  nV_1739  -1.339915e+02m  TC=0,0
L_V1739  nV_1739  N_BUS_GND  -2.171338e+02uH
R_V1740  N_C0_116  nV_1740  1.397465e+02m  TC=0,0
L_V1740  nV_1740  N_BUS_GND  7.851390e+02uH
*  Node  N_C0_117  to other nodes
* *  Node  N_C0_117  to  Node  N_C0_118
R_R581  N_C0_117  N_C0_118  8.342241e+07m  TC=0,0
R_V1741  N_C0_117  nV_1741  -1.326006e+04m  TC=0,0
L_V1741  nV_1741  N_C0_118  -9.959324e+02uH
R_V1742  N_C0_117  nV_1742  2.003578e+02m  TC=0,0
L_V1742  nV_1742  N_C0_118  3.246807e+02uH
R_V1743  N_C0_117  nV_1743  -3.921320e+02m  TC=0,0
L_V1743  nV_1743  N_C0_118  -2.203118e+03uH
* *  Node  N_C0_117  to  Node  N_C0_119
R_R582  N_C0_117  N_C0_119  3.836298e+07m  TC=0,0
R_V1744  N_C0_117  nV_1744  -1.151922e+04m  TC=0,0
L_V1744  nV_1744  N_C0_119  -8.651820e+02uH
R_V1745  N_C0_117  nV_1745  1.574265e+02m  TC=0,0
L_V1745  nV_1745  N_C0_119  2.551103e+02uH
R_V1746  N_C0_117  nV_1746  -2.885843e+02m  TC=0,0
L_V1746  nV_1746  N_C0_119  -1.621355e+03uH
* *  Node  N_C0_117  to  Node  N_C0_120
R_R583  N_C0_117  N_C0_120  1.327995e+08m  TC=0,0
R_V1747  N_C0_117  nV_1747  -3.352747e+04m  TC=0,0
L_V1747  nV_1747  N_C0_120  -2.518171e+03uH
R_V1748  N_C0_117  nV_1748  3.609486e+02m  TC=0,0
L_V1748  nV_1748  N_C0_120  5.849187e+02uH
R_V1749  N_C0_117  nV_1749  -7.046168e+02m  TC=0,0
L_V1749  nV_1749  N_C0_120  -3.958754e+03uH
* *  Node  N_C0_117  to  Node  N_C0_121
R_R584  N_C0_117  N_C0_121  1.092944e+08m  TC=0,0
R_V1750  N_C0_117  nV_1750  -3.176959e+04m  TC=0,0
L_V1750  nV_1750  N_C0_121  -2.386140e+03uH
R_V1751  N_C0_117  nV_1751  3.371711e+02m  TC=0,0
L_V1751  nV_1751  N_C0_121  5.463873e+02uH
R_V1752  N_C0_117  nV_1752  -6.460082e+02m  TC=0,0
L_V1752  nV_1752  N_C0_121  -3.629473e+03uH
* *  Node  N_C0_117  to  Node  N_BUS_GND
R_R585  N_C0_117  N_BUS_GND  -6.987728e+07m  TC=0,0
R_V1753  N_C0_117  nV_1753  -1.903785e+04m  TC=0,0
L_V1753  nV_1753  N_BUS_GND  -1.429889e+03uH
R_V1754  N_C0_117  nV_1754  -2.165020e+02m  TC=0,0
L_V1754  nV_1754  N_BUS_GND  -3.508424e+02uH
R_V1755  N_C0_117  nV_1755  2.306850e+02m  TC=0,0
L_V1755  nV_1755  N_BUS_GND  1.296059e+03uH
*  Node  N_C0_118  to other nodes
* *  Node  N_C0_118  to  Node  N_C0_119
R_R586  N_C0_118  N_C0_119  5.638103e+07m  TC=0,0
R_V1756  N_C0_118  nV_1756  -4.614654e+03m  TC=0,0
L_V1756  nV_1756  N_C0_119  -3.465960e+02uH
R_V1757  N_C0_118  nV_1757  1.539737e+02m  TC=0,0
L_V1757  nV_1757  N_C0_119  2.495150e+02uH
R_V1758  N_C0_118  nV_1758  -2.721067e+02m  TC=0,0
L_V1758  nV_1758  N_C0_119  -1.528779e+03uH
* *  Node  N_C0_118  to  Node  N_C0_120
R_R587  N_C0_118  N_C0_120  2.589830e+07m  TC=0,0
R_V1759  N_C0_118  nV_1759  -7.872769e+03m  TC=0,0
L_V1759  nV_1759  N_C0_120  -5.913055e+02uH
R_V1760  N_C0_118  nV_1760  1.447612e+02m  TC=0,0
L_V1760  nV_1760  N_C0_120  2.345861e+02uH
R_V1761  N_C0_118  nV_1761  -2.386507e+02m  TC=0,0
L_V1761  nV_1761  N_C0_120  -1.340813e+03uH
* *  Node  N_C0_118  to  Node  N_C0_121
R_R588  N_C0_118  N_C0_121  5.765778e+07m  TC=0,0
R_V1762  N_C0_118  nV_1762  -9.262607e+03m  TC=0,0
L_V1762  nV_1762  N_C0_121  -6.956930e+02uH
R_V1763  N_C0_118  nV_1763  2.167330e+02m  TC=0,0
L_V1763  nV_1763  N_C0_121  3.512168e+02uH
R_V1764  N_C0_118  nV_1764  -3.787954e+02m  TC=0,0
L_V1764  nV_1764  N_C0_121  -2.128189e+03uH
* *  Node  N_C0_118  to  Node  N_BUS_GND
R_R589  N_C0_118  N_BUS_GND  -4.394633e+07m  TC=0,0
R_V1765  N_C0_118  nV_1765  -1.463802e+04m  TC=0,0
L_V1765  nV_1765  N_BUS_GND  -1.099428e+03uH
R_V1766  N_C0_118  nV_1766  -1.008500e+02m  TC=0,0
L_V1766  nV_1766  N_BUS_GND  -1.634279e+02uH
R_V1767  N_C0_118  nV_1767  1.031914e+02m  TC=0,0
L_V1767  nV_1767  N_BUS_GND  5.797608e+02uH
*  Node  N_C0_119  to other nodes
* *  Node  N_C0_119  to  Node  N_C0_120
R_R590  N_C0_119  N_C0_120  5.765778e+07m  TC=0,0
R_V1768  N_C0_119  nV_1768  -9.262607e+03m  TC=0,0
L_V1768  nV_1768  N_C0_120  -6.956930e+02uH
R_V1769  N_C0_119  nV_1769  2.167330e+02m  TC=0,0
L_V1769  nV_1769  N_C0_120  3.512168e+02uH
R_V1770  N_C0_119  nV_1770  -3.787954e+02m  TC=0,0
L_V1770  nV_1770  N_C0_120  -2.128189e+03uH
* *  Node  N_C0_119  to  Node  N_C0_121
R_R591  N_C0_119  N_C0_121  2.589830e+07m  TC=0,0
R_V1771  N_C0_119  nV_1771  -7.872769e+03m  TC=0,0
L_V1771  nV_1771  N_C0_121  -5.913055e+02uH
R_V1772  N_C0_119  nV_1772  1.447612e+02m  TC=0,0
L_V1772  nV_1772  N_C0_121  2.345861e+02uH
R_V1773  N_C0_119  nV_1773  -2.386507e+02m  TC=0,0
L_V1773  nV_1773  N_C0_121  -1.340813e+03uH
* *  Node  N_C0_119  to  Node  N_BUS_GND
R_R592  N_C0_119  N_BUS_GND  -4.394633e+07m  TC=0,0
R_V1774  N_C0_119  nV_1774  -1.463802e+04m  TC=0,0
L_V1774  nV_1774  N_BUS_GND  -1.099428e+03uH
R_V1775  N_C0_119  nV_1775  -1.008500e+02m  TC=0,0
L_V1775  nV_1775  N_BUS_GND  -1.634279e+02uH
R_V1776  N_C0_119  nV_1776  1.031914e+02m  TC=0,0
L_V1776  nV_1776  N_BUS_GND  5.797608e+02uH
*  Node  N_C0_120  to other nodes
* *  Node  N_C0_120  to  Node  N_C0_121
R_R593  N_C0_120  N_C0_121  2.041915e+07m  TC=0,0
R_V1777  N_C0_120  nV_1777  -4.093725e+03m  TC=0,0
L_V1777  nV_1777  N_C0_121  -3.074702e+02uH
R_V1778  N_C0_120  nV_1778  1.357298e+02m  TC=0,0
L_V1778  nV_1778  N_C0_121  2.199507e+02uH
R_V1779  N_C0_120  nV_1779  -2.201623e+02m  TC=0,0
L_V1779  nV_1779  N_C0_121  -1.236940e+03uH
* *  Node  N_C0_120  to  Node  N_BUS_GND
R_R594  N_C0_120  N_BUS_GND  -8.439274e+07m  TC=0,0
R_V1780  N_C0_120  nV_1780  -1.996513e+04m  TC=0,0
L_V1780  nV_1780  N_BUS_GND  -1.499534e+03uH
R_V1781  N_C0_120  nV_1781  -1.838968e+02m  TC=0,0
L_V1781  nV_1781  N_BUS_GND  -2.980055e+02uH
R_V1782  N_C0_120  nV_1782  1.898220e+02m  TC=0,0
L_V1782  nV_1782  N_BUS_GND  1.066478e+03uH
*  Node  N_C0_121  to other nodes
* *  Node  N_C0_121  to  Node  N_BUS_GND
R_R595  N_C0_121  N_BUS_GND  -8.439274e+07m  TC=0,0
R_V1783  N_C0_121  nV_1783  -1.996513e+04m  TC=0,0
L_V1783  nV_1783  N_BUS_GND  -1.499534e+03uH
R_V1784  N_C0_121  nV_1784  -1.838968e+02m  TC=0,0
L_V1784  nV_1784  N_BUS_GND  -2.980055e+02uH
R_V1785  N_C0_121  nV_1785  1.898220e+02m  TC=0,0
L_V1785  nV_1785  N_BUS_GND  1.066478e+03uH
* *  Node N_T0m to ground
X_GN_T0m  N_T0m  TubeTower40m_grid_Ri  PARAMS: Ig=8.127142e-01  R0=8.278948e+03
* *  Node N_C0_93 to ground
X_GN_C0_93  N_C0_93  TubeTower40m_grid_Ri  PARAMS: Ig=1.507917e+01  R0=1.922009e+03
* *  Node N_C0_94 to ground
X_GN_C0_94  N_C0_94  TubeTower40m_grid_Ri  PARAMS: Ig=2.075676e+01  R0=1.638190e+03
* *  Node N_C0_95 to ground
X_GN_C0_95  N_C0_95  TubeTower40m_grid_Ri  PARAMS: Ig=3.400299e+00  R0=4.047488e+03
* *  Node N_C0_96 to ground
X_GN_C0_96  N_C0_96  TubeTower40m_grid_Ri  PARAMS: Ig=2.075676e+01  R0=1.638190e+03
* *  Node N_C0_97 to ground
X_GN_C0_97  N_C0_97  TubeTower40m_grid_Ri  PARAMS: Ig=4.622922e+01  R0=1.097705e+03
* *  Node N_C0_98 to ground
X_GN_C0_98  N_C0_98  TubeTower40m_grid_Ri  PARAMS: Ig=5.845890e+02  R0=3.086873e+02
* *  Node N_C0_99 to ground
X_GN_C0_99  N_C0_99  TubeTower40m_grid_Ri  PARAMS: Ig=2.406024e+01  R0=1.521578e+03
* *  Node N_C0_100 to ground
X_GN_C0_100  N_C0_100  TubeTower40m_grid_Ri  PARAMS: Ig=2.406024e+01  R0=1.521578e+03
* *  Node N_C0_101 to ground
X_GN_C0_101  N_C0_101  TubeTower40m_grid_Ri  PARAMS: Ig=5.845890e+02  R0=3.086873e+02
* *  Node N_C0_102 to ground
X_GN_C0_102  N_C0_102  TubeTower40m_grid_Ri  PARAMS: Ig=2.482107e+02  R0=4.737332e+02
* *  Node N_C0_103 to ground
X_GN_C0_103  N_C0_103  TubeTower40m_grid_Ri  PARAMS: Ig=3.343993e+01  R0=1.290659e+03
* *  Node N_C0_104 to ground
X_GN_C0_104  N_C0_104  TubeTower40m_grid_Ri  PARAMS: Ig=2.482107e+02  R0=4.737332e+02
* *  Node NTMP0000000019 to ground
X_GNTMP0000000019  NTMP0000000019  TubeTower40m_grid_Ri  PARAMS: Ig=3.642662e+01  R0=1.236615e+03
* *  Node N_C0_105 to ground
X_GN_C0_105  N_C0_105  TubeTower40m_grid_Ri  PARAMS: Ig=1.830262e+02  R0=5.516802e+02
* *  Node NTMP0000000021 to ground
X_GNTMP0000000021  NTMP0000000021  TubeTower40m_grid_Ri  PARAMS: Ig=3.642662e+01  R0=1.236615e+03
* *  Node N_C0_106 to ground
X_GN_C0_106  N_C0_106  TubeTower40m_grid_Ri  PARAMS: Ig=1.830262e+02  R0=5.516802e+02
* *  Node N_C0_107 to ground
X_GN_C0_107  N_C0_107  TubeTower40m_grid_Ri  PARAMS: Ig=9.504699e+01  R0=7.655524e+02
* *  Node N_C0_108 to ground
X_GN_C0_108  N_C0_108  TubeTower40m_grid_Ri  PARAMS: Ig=3.881312e+01  R0=1.197994e+03
* *  Node N_C0_109 to ground
X_GN_C0_109  N_C0_109  TubeTower40m_grid_Ri  PARAMS: Ig=1.008842e+01  R0=2.349808e+03
* *  Node N_C0_110 to ground
X_GN_C0_110  N_C0_110  TubeTower40m_grid_Ri  PARAMS: Ig=1.008842e+01  R0=2.349808e+03
* *  Node NTMP0000000028 to ground
X_GNTMP0000000028  NTMP0000000028  TubeTower40m_grid_Ri  PARAMS: Ig=1.003313e+01  R0=2.356274e+03
* *  Node N_C0_111 to ground
X_GN_C0_111  N_C0_111  TubeTower40m_grid_Ri  PARAMS: Ig=2.294443e+01  R0=1.558136e+03
* *  Node NTMP0000000030 to ground
X_GNTMP0000000030  NTMP0000000030  TubeTower40m_grid_Ri  PARAMS: Ig=1.003313e+01  R0=2.356274e+03
* *  Node N_C0_112 to ground
X_GN_C0_112  N_C0_112  TubeTower40m_grid_Ri  PARAMS: Ig=2.294443e+01  R0=1.558136e+03
* *  Node N_BUS_2 to ground
X_GN_BUS_2  N_BUS_2  TubeTower40m_grid_Ri  PARAMS: Ig=4.064598e+01  R0=1.170672e+03
* *  Node N_C0_114 to ground
X_GN_C0_114  N_C0_114  TubeTower40m_grid_Ri  PARAMS: Ig=2.001146e+01  R0=1.668417e+03
* *  Node N_C0_115 to ground
X_GN_C0_115  N_C0_115  TubeTower40m_grid_Ri  PARAMS: Ig=4.470457e+01  R0=1.116267e+03
* *  Node N_C0_116 to ground
X_GN_C0_116  N_C0_116  TubeTower40m_grid_Ri  PARAMS: Ig=2.001146e+01  R0=1.668417e+03
* *  Node N_C0_117 to ground
X_GN_C0_117  N_C0_117  TubeTower40m_grid_Ri  PARAMS: Ig=4.470457e+01  R0=1.116267e+03
* *  Node N_C0_118 to ground
X_GN_C0_118  N_C0_118  TubeTower40m_grid_Ri  PARAMS: Ig=3.592913e+01  R0=1.245147e+03
* *  Node N_C0_119 to ground
X_GN_C0_119  N_C0_119  TubeTower40m_grid_Ri  PARAMS: Ig=3.592913e+01  R0=1.245147e+03
* *  Node N_C0_120 to ground
X_GN_C0_120  N_C0_120  TubeTower40m_grid_Ri  PARAMS: Ig=7.553313e+01  R0=8.587670e+02
* *  Node N_C0_121 to ground
X_GN_C0_121  N_C0_121  TubeTower40m_grid_Ri  PARAMS: Ig=7.553313e+01  R0=8.587670e+02
* *  Node N_BUS_GND to ground
X_GN_BUS_GND  N_BUS_GND  TubeTower40m_grid_Ri  PARAMS: Ig=1.502728e-01  R0=1.925324e+04
.ENDS TubeTower40m_grid
* Nonlinear Ground Resistance Used in Ground Grid
.SUBCKT  TubeTower40m_grid_Ri  1  PARAMS: Ig=1000  R0=20
R_R_ROD    1  2  1u  TC=0,0
V_I_SENSE  2  3  0V
H_I_SENSE  4  0  V_I_SENSE   1
R_I_SENSE  4  0  1G   TC=0,0
E_VAR  3  0
+  VALUE={V(4)*R0/SQRT(1+ABS(V(4))/Ig)}
.ENDS TubeTower40m_grid_Ri
