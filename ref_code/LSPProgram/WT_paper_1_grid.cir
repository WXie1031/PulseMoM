.SUBCKT WT_paper_1_grid
**************************************
*   Model Generated by Chen Hongcai  *
*   Hong Kong Polytechic University  *
*         All Rights Reserved        *
*       Email:  hc.chen@live.com     *
**************************************
* Model generated on 04-Aug-2018
* MODEL FORMAT: PSpice
*  Node  N_C0_33  to other nodes
* *  Node  N_C0_33  to  Node  N_C0_34
R_R1  N_C0_33  N_C0_34  1.448166e+06m  TC=0,0
R_V1  N_C0_33  nV_1  8.194570e+01m  TC=0,0
L_V1  nV_1  N_C0_34  3.173626e+01uH
R_V2  N_C0_33  nV_2  5.830817e+00m  TC=0,0
L_V3  nV_2  nV_3  1.718081e+01uH
R_V3  nV_3  N_C0_34  1.046906e+00m  TC=0,0
C_V3  nV_3  N_C0_34  3.232424e+06uF
