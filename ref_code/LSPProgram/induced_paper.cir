**************************************
*   Model Generated by Chen Hongcai  *
*   Hong Kong Polytechic University  *
*         All Rights Reserved        *
*       Email:  hc.chen@live.com     *
**************************************
* Model generated on 02-May-2017
* MODEL FORMAT: PSpice
.SUBCKT induced_paper NP01 NP09 NP15 NN01 NN09
+ NN15 NG01 NG09 NG15
* *  Branch  NP01 - NTMP0000000001
R_R1  NP01  nU_1  32.914993m  TC=0,0
V_Ui1  nU_1  nR_1  STIMULUS=U_IND_0000000001
R_V1  nR_1  nV_1  23.280268m  TC=0,0
L_V1  nR_1  nV_1  0.014646uH
R_V2  nV_1  nV_2  7.852787m  TC=0,0
L_V2  nV_1  nV_2  0.073723uH
L_L1  nV_2  NTMP0000000001  6.519695uH
K_K1  L_L1  L_L2  0.1050
K_K2  L_L1  L_L3  0.0397
K_K3  L_L1  L_L4  0.0258
K_K4  L_L1  L_L5  0.0192
K_K5  L_L1  L_L6  0.0153
K_K6  L_L1  L_L7  0.0127
K_K7  L_L1  L_L8  0.0109
K_K8  L_L1  L_L9  0.0095
K_K9  L_L1  L_L10  0.0084
K_K10  L_L1  L_L11  0.0076
K_K11  L_L1  L_L12  0.0069
K_K12  L_L1  L_L13  0.0063
K_K13  L_L1  L_L14  0.0058
K_K14  L_L1  L_L15  0.0054
K_K15  L_L1  L_L16  0.0051
K_K16  L_L1  L_L17  0.0047
K_K17  L_L1  L_L18  0.0045
K_K18  L_L1  L_L19  0.0042
K_K19  L_L1  L_L20  0.0040
K_K20  L_L1  L_L21  0.0038
K_K21  L_L1  L_L22  0.0036
K_K22  L_L1  L_L23  0.0034
K_K23  L_L1  L_L24  0.0033
K_K24  L_L1  L_L25  0.0032
K_K25  L_L1  L_L26  0.0030
K_K26  L_L1  L_L27  0.0029
K_K27  L_L1  L_L28  0.0028
K_K28  L_L1  L_L29  0.0027
K_K29  L_L1  L_L30  0.0026
K_K30  L_L1  L_L31  0.0025
K_K31  L_L1  L_L32  0.0024
K_K32  L_L1  L_L33  0.0024
K_K33  L_L1  L_L34  0.0023
K_K34  L_L1  L_L35  0.0022
K_K35  L_L1  L_L36  0.0022
K_K36  L_L1  L_L37  0.0021
K_K37  L_L1  L_L38  0.0020
K_K38  L_L1  L_L39  0.0020
K_K39  L_L1  L_L40  0.0019
K_K40  L_L1  L_L41  0.0019
K_K41  L_L1  L_L42  0.0018
K_K42  L_L1  L_L43  0.0018
K_K43  L_L1  L_L44  0.0018
K_K44  L_L1  L_L45  0.0017
K_K45  L_L1  L_L46  0.0017
K_K46  L_L1  L_L47  0.0017
K_K47  L_L1  L_L48  0.0016
K_K48  L_L1  L_L49  0.0016
K_K49  L_L1  L_L50  0.0015
K_K50  L_L1  L_L51  0.0015
K_K51  L_L1  L_L52  0.0015
K_K52  L_L1  L_L53  0.0015
K_K53  L_L1  L_L54  0.0014
K_K54  L_L1  L_L55  0.0014
K_K55  L_L1  L_L56  0.0014
K_K56  L_L1  L_L57  0.0014
K_K57  L_L1  L_L58  0.0013
K_K58  L_L1  L_L59  0.0013
K_K59  L_L1  L_L60  0.0013
K_K60  L_L1  L_L61  0.0013
K_K61  L_L1  L_L62  0.0013
K_K62  L_L1  L_L63  0.0012
K_K63  L_L1  L_L64  0.0012
K_K64  L_L1  L_L65  0.0012
K_K65  L_L1  L_L66  0.0012
K_K66  L_L1  L_L67  0.0011
K_K67  L_L1  L_L68  0.0011
K_K68  L_L1  L_L69  0.0011
K_K69  L_L1  L_L70  0.0011
K_K70  L_L1  L_L71  0.0011
K_K71  L_L1  L_L72  0.0011
K_K72  L_L1  L_L73  0.0011
K_K73  L_L1  L_L74  0.0010
K_K74  L_L1  L_L75  0.0010
K_K75  L_L1  L_L76  0.0010
K_K76  L_L1  L_L139  0.1569
K_K77  L_L1  L_L140  0.0812
K_K78  L_L1  L_L141  0.0389
K_K79  L_L1  L_L142  0.0256
K_K80  L_L1  L_L143  0.0191
K_K81  L_L1  L_L144  0.0152
K_K82  L_L1  L_L145  0.0127
K_K83  L_L1  L_L146  0.0109
K_K84  L_L1  L_L147  0.0095
K_K85  L_L1  L_L148  0.0084
K_K86  L_L1  L_L149  0.0076
K_K87  L_L1  L_L150  0.0069
K_K88  L_L1  L_L151  0.0063
K_K89  L_L1  L_L152  0.0058
K_K90  L_L1  L_L153  0.0054
K_K91  L_L1  L_L154  0.0051
K_K92  L_L1  L_L155  0.0047
K_K93  L_L1  L_L156  0.0045
K_K94  L_L1  L_L157  0.0042
K_K95  L_L1  L_L158  0.0040
K_K96  L_L1  L_L159  0.0038
K_K97  L_L1  L_L160  0.0036
K_K98  L_L1  L_L161  0.0034
K_K99  L_L1  L_L162  0.0033
K_K100  L_L1  L_L163  0.0032
K_K101  L_L1  L_L164  0.0030
K_K102  L_L1  L_L165  0.0029
K_K103  L_L1  L_L166  0.0028
K_K104  L_L1  L_L167  0.0027
K_K105  L_L1  L_L168  0.0026
K_K106  L_L1  L_L169  0.0025
K_K107  L_L1  L_L170  0.0024
K_K108  L_L1  L_L171  0.0024
K_K109  L_L1  L_L172  0.0023
K_K110  L_L1  L_L173  0.0022
K_K111  L_L1  L_L174  0.0022
K_K112  L_L1  L_L175  0.0021
K_K113  L_L1  L_L176  0.0020
K_K114  L_L1  L_L177  0.0020
K_K115  L_L1  L_L178  0.0019
K_K116  L_L1  L_L179  0.0019
K_K117  L_L1  L_L180  0.0018
K_K118  L_L1  L_L181  0.0018
K_K119  L_L1  L_L182  0.0018
K_K120  L_L1  L_L183  0.0017
K_K121  L_L1  L_L184  0.0017
K_K122  L_L1  L_L185  0.0016
K_K123  L_L1  L_L186  0.0016
K_K124  L_L1  L_L187  0.0016
K_K125  L_L1  L_L188  0.0015
K_K126  L_L1  L_L189  0.0015
K_K127  L_L1  L_L190  0.0015
K_K128  L_L1  L_L191  0.0015
K_K129  L_L1  L_L192  0.0014
K_K130  L_L1  L_L193  0.0014
K_K131  L_L1  L_L194  0.0014
K_K132  L_L1  L_L195  0.0014
K_K133  L_L1  L_L196  0.0013
K_K134  L_L1  L_L197  0.0013
K_K135  L_L1  L_L198  0.0013
K_K136  L_L1  L_L199  0.0013
K_K137  L_L1  L_L200  0.0012
K_K138  L_L1  L_L201  0.0012
K_K139  L_L1  L_L202  0.0012
K_K140  L_L1  L_L203  0.0012
K_K141  L_L1  L_L204  0.0012
K_K142  L_L1  L_L205  0.0011
K_K143  L_L1  L_L206  0.0011
K_K144  L_L1  L_L207  0.0011
K_K145  L_L1  L_L208  0.0011
K_K146  L_L1  L_L209  0.0011
K_K147  L_L1  L_L210  0.0011
K_K148  L_L1  L_L211  0.0011
K_K149  L_L1  L_L212  0.0010
K_K150  L_L1  L_L213  0.0010
K_K151  L_L1  L_L214  0.0010
* *  Branch  NTMP0000000001 - NTMP0000000002
R_R2  NTMP0000000001  nU_2  32.914993m  TC=0,0
V_Ui2  nU_2  nR_2  STIMULUS=U_IND_0000000002
R_V3  nR_2  nV_3  23.280268m  TC=0,0
L_V3  nR_2  nV_3  0.014646uH
R_V4  nV_3  nV_4  7.852787m  TC=0,0
L_V4  nV_3  nV_4  0.073723uH
L_L2  nV_4  NTMP0000000002  6.519695uH
K_K152  L_L2  L_L3  0.1050
K_K153  L_L2  L_L4  0.0397
K_K154  L_L2  L_L5  0.0258
K_K155  L_L2  L_L6  0.0192
K_K156  L_L2  L_L7  0.0153
K_K157  L_L2  L_L8  0.0127
K_K158  L_L2  L_L9  0.0109
K_K159  L_L2  L_L10  0.0095
K_K160  L_L2  L_L11  0.0084
K_K161  L_L2  L_L12  0.0076
K_K162  L_L2  L_L13  0.0069
K_K163  L_L2  L_L14  0.0063
K_K164  L_L2  L_L15  0.0058
K_K165  L_L2  L_L16  0.0054
K_K166  L_L2  L_L17  0.0051
K_K167  L_L2  L_L18  0.0047
K_K168  L_L2  L_L19  0.0045
K_K169  L_L2  L_L20  0.0042
K_K170  L_L2  L_L21  0.0040
K_K171  L_L2  L_L22  0.0038
K_K172  L_L2  L_L23  0.0036
K_K173  L_L2  L_L24  0.0034
K_K174  L_L2  L_L25  0.0033
K_K175  L_L2  L_L26  0.0032
K_K176  L_L2  L_L27  0.0030
K_K177  L_L2  L_L28  0.0029
K_K178  L_L2  L_L29  0.0028
K_K179  L_L2  L_L30  0.0027
K_K180  L_L2  L_L31  0.0026
K_K181  L_L2  L_L32  0.0025
K_K182  L_L2  L_L33  0.0024
K_K183  L_L2  L_L34  0.0024
K_K184  L_L2  L_L35  0.0023
K_K185  L_L2  L_L36  0.0022
K_K186  L_L2  L_L37  0.0022
K_K187  L_L2  L_L38  0.0021
K_K188  L_L2  L_L39  0.0020
K_K189  L_L2  L_L40  0.0020
K_K190  L_L2  L_L41  0.0019
K_K191  L_L2  L_L42  0.0019
K_K192  L_L2  L_L43  0.0018
K_K193  L_L2  L_L44  0.0018
K_K194  L_L2  L_L45  0.0018
K_K195  L_L2  L_L46  0.0017
K_K196  L_L2  L_L47  0.0017
K_K197  L_L2  L_L48  0.0017
K_K198  L_L2  L_L49  0.0016
K_K199  L_L2  L_L50  0.0016
K_K200  L_L2  L_L51  0.0015
K_K201  L_L2  L_L52  0.0015
K_K202  L_L2  L_L53  0.0015
K_K203  L_L2  L_L54  0.0015
K_K204  L_L2  L_L55  0.0014
K_K205  L_L2  L_L56  0.0014
K_K206  L_L2  L_L57  0.0014
K_K207  L_L2  L_L58  0.0014
K_K208  L_L2  L_L59  0.0013
K_K209  L_L2  L_L60  0.0013
K_K210  L_L2  L_L61  0.0013
K_K211  L_L2  L_L62  0.0013
K_K212  L_L2  L_L63  0.0013
K_K213  L_L2  L_L64  0.0012
K_K214  L_L2  L_L65  0.0012
K_K215  L_L2  L_L66  0.0012
K_K216  L_L2  L_L67  0.0012
K_K217  L_L2  L_L68  0.0011
K_K218  L_L2  L_L69  0.0011
K_K219  L_L2  L_L70  0.0011
K_K220  L_L2  L_L71  0.0011
K_K221  L_L2  L_L72  0.0011
K_K222  L_L2  L_L73  0.0011
K_K223  L_L2  L_L74  0.0011
K_K224  L_L2  L_L75  0.0010
K_K225  L_L2  L_L76  0.0010
K_K226  L_L2  L_L77  0.0010
K_K227  L_L2  L_L139  0.0812
K_K228  L_L2  L_L140  0.1569
K_K229  L_L2  L_L141  0.0812
K_K230  L_L2  L_L142  0.0389
K_K231  L_L2  L_L143  0.0256
K_K232  L_L2  L_L144  0.0191
K_K233  L_L2  L_L145  0.0152
K_K234  L_L2  L_L146  0.0127
K_K235  L_L2  L_L147  0.0109
K_K236  L_L2  L_L148  0.0095
K_K237  L_L2  L_L149  0.0084
K_K238  L_L2  L_L150  0.0076
K_K239  L_L2  L_L151  0.0069
K_K240  L_L2  L_L152  0.0063
K_K241  L_L2  L_L153  0.0058
K_K242  L_L2  L_L154  0.0054
K_K243  L_L2  L_L155  0.0051
K_K244  L_L2  L_L156  0.0047
K_K245  L_L2  L_L157  0.0045
K_K246  L_L2  L_L158  0.0042
K_K247  L_L2  L_L159  0.0040
K_K248  L_L2  L_L160  0.0038
K_K249  L_L2  L_L161  0.0036
K_K250  L_L2  L_L162  0.0034
K_K251  L_L2  L_L163  0.0033
K_K252  L_L2  L_L164  0.0032
K_K253  L_L2  L_L165  0.0030
K_K254  L_L2  L_L166  0.0029
K_K255  L_L2  L_L167  0.0028
K_K256  L_L2  L_L168  0.0027
K_K257  L_L2  L_L169  0.0026
K_K258  L_L2  L_L170  0.0025
K_K259  L_L2  L_L171  0.0024
K_K260  L_L2  L_L172  0.0024
K_K261  L_L2  L_L173  0.0023
K_K262  L_L2  L_L174  0.0022
K_K263  L_L2  L_L175  0.0022
K_K264  L_L2  L_L176  0.0021
K_K265  L_L2  L_L177  0.0020
K_K266  L_L2  L_L178  0.0020
K_K267  L_L2  L_L179  0.0019
K_K268  L_L2  L_L180  0.0019
K_K269  L_L2  L_L181  0.0018
K_K270  L_L2  L_L182  0.0018
K_K271  L_L2  L_L183  0.0018
K_K272  L_L2  L_L184  0.0017
K_K273  L_L2  L_L185  0.0017
K_K274  L_L2  L_L186  0.0016
K_K275  L_L2  L_L187  0.0016
K_K276  L_L2  L_L188  0.0016
K_K277  L_L2  L_L189  0.0015
K_K278  L_L2  L_L190  0.0015
K_K279  L_L2  L_L191  0.0015
K_K280  L_L2  L_L192  0.0015
K_K281  L_L2  L_L193  0.0014
K_K282  L_L2  L_L194  0.0014
K_K283  L_L2  L_L195  0.0014
K_K284  L_L2  L_L196  0.0014
K_K285  L_L2  L_L197  0.0013
K_K286  L_L2  L_L198  0.0013
K_K287  L_L2  L_L199  0.0013
K_K288  L_L2  L_L200  0.0013
K_K289  L_L2  L_L201  0.0012
K_K290  L_L2  L_L202  0.0012
K_K291  L_L2  L_L203  0.0012
K_K292  L_L2  L_L204  0.0012
K_K293  L_L2  L_L205  0.0012
K_K294  L_L2  L_L206  0.0011
K_K295  L_L2  L_L207  0.0011
K_K296  L_L2  L_L208  0.0011
K_K297  L_L2  L_L209  0.0011
K_K298  L_L2  L_L210  0.0011
K_K299  L_L2  L_L211  0.0011
K_K300  L_L2  L_L212  0.0011
K_K301  L_L2  L_L213  0.0010
K_K302  L_L2  L_L214  0.0010
K_K303  L_L2  L_L215  0.0010
* *  Branch  NTMP0000000002 - NTMP0000000003
R_R3  NTMP0000000002  nU_3  32.914993m  TC=0,0
V_Ui3  nU_3  nR_3  STIMULUS=U_IND_0000000003
R_V5  nR_3  nV_5  23.280268m  TC=0,0
L_V5  nR_3  nV_5  0.014646uH
R_V6  nV_5  nV_6  7.852787m  TC=0,0
L_V6  nV_5  nV_6  0.073723uH
L_L3  nV_6  NTMP0000000003  6.519695uH
K_K304  L_L3  L_L4  0.1050
K_K305  L_L3  L_L5  0.0397
K_K306  L_L3  L_L6  0.0258
K_K307  L_L3  L_L7  0.0192
K_K308  L_L3  L_L8  0.0153
K_K309  L_L3  L_L9  0.0127
K_K310  L_L3  L_L10  0.0109
K_K311  L_L3  L_L11  0.0095
K_K312  L_L3  L_L12  0.0084
K_K313  L_L3  L_L13  0.0076
K_K314  L_L3  L_L14  0.0069
K_K315  L_L3  L_L15  0.0063
K_K316  L_L3  L_L16  0.0058
K_K317  L_L3  L_L17  0.0054
K_K318  L_L3  L_L18  0.0051
K_K319  L_L3  L_L19  0.0047
K_K320  L_L3  L_L20  0.0045
K_K321  L_L3  L_L21  0.0042
K_K322  L_L3  L_L22  0.0040
K_K323  L_L3  L_L23  0.0038
K_K324  L_L3  L_L24  0.0036
K_K325  L_L3  L_L25  0.0034
K_K326  L_L3  L_L26  0.0033
K_K327  L_L3  L_L27  0.0032
K_K328  L_L3  L_L28  0.0030
K_K329  L_L3  L_L29  0.0029
K_K330  L_L3  L_L30  0.0028
K_K331  L_L3  L_L31  0.0027
K_K332  L_L3  L_L32  0.0026
K_K333  L_L3  L_L33  0.0025
K_K334  L_L3  L_L34  0.0024
K_K335  L_L3  L_L35  0.0024
K_K336  L_L3  L_L36  0.0023
K_K337  L_L3  L_L37  0.0022
K_K338  L_L3  L_L38  0.0022
K_K339  L_L3  L_L39  0.0021
K_K340  L_L3  L_L40  0.0020
K_K341  L_L3  L_L41  0.0020
K_K342  L_L3  L_L42  0.0019
K_K343  L_L3  L_L43  0.0019
K_K344  L_L3  L_L44  0.0018
K_K345  L_L3  L_L45  0.0018
K_K346  L_L3  L_L46  0.0018
K_K347  L_L3  L_L47  0.0017
K_K348  L_L3  L_L48  0.0017
K_K349  L_L3  L_L49  0.0017
K_K350  L_L3  L_L50  0.0016
K_K351  L_L3  L_L51  0.0016
K_K352  L_L3  L_L52  0.0015
K_K353  L_L3  L_L53  0.0015
K_K354  L_L3  L_L54  0.0015
K_K355  L_L3  L_L55  0.0015
K_K356  L_L3  L_L56  0.0014
K_K357  L_L3  L_L57  0.0014
K_K358  L_L3  L_L58  0.0014
K_K359  L_L3  L_L59  0.0014
K_K360  L_L3  L_L60  0.0013
K_K361  L_L3  L_L61  0.0013
K_K362  L_L3  L_L62  0.0013
K_K363  L_L3  L_L63  0.0013
K_K364  L_L3  L_L64  0.0013
K_K365  L_L3  L_L65  0.0012
K_K366  L_L3  L_L66  0.0012
K_K367  L_L3  L_L67  0.0012
K_K368  L_L3  L_L68  0.0012
K_K369  L_L3  L_L69  0.0011
K_K370  L_L3  L_L70  0.0011
K_K371  L_L3  L_L71  0.0011
K_K372  L_L3  L_L72  0.0011
K_K373  L_L3  L_L73  0.0011
K_K374  L_L3  L_L74  0.0011
K_K375  L_L3  L_L75  0.0011
K_K376  L_L3  L_L76  0.0010
K_K377  L_L3  L_L77  0.0010
K_K378  L_L3  L_L78  0.0010
K_K379  L_L3  L_L139  0.0389
K_K380  L_L3  L_L140  0.0812
K_K381  L_L3  L_L141  0.1569
K_K382  L_L3  L_L142  0.0812
K_K383  L_L3  L_L143  0.0389
K_K384  L_L3  L_L144  0.0256
K_K385  L_L3  L_L145  0.0191
K_K386  L_L3  L_L146  0.0152
K_K387  L_L3  L_L147  0.0127
K_K388  L_L3  L_L148  0.0109
K_K389  L_L3  L_L149  0.0095
K_K390  L_L3  L_L150  0.0084
K_K391  L_L3  L_L151  0.0076
K_K392  L_L3  L_L152  0.0069
K_K393  L_L3  L_L153  0.0063
K_K394  L_L3  L_L154  0.0058
K_K395  L_L3  L_L155  0.0054
K_K396  L_L3  L_L156  0.0051
K_K397  L_L3  L_L157  0.0047
K_K398  L_L3  L_L158  0.0045
K_K399  L_L3  L_L159  0.0042
K_K400  L_L3  L_L160  0.0040
K_K401  L_L3  L_L161  0.0038
K_K402  L_L3  L_L162  0.0036
K_K403  L_L3  L_L163  0.0034
K_K404  L_L3  L_L164  0.0033
K_K405  L_L3  L_L165  0.0032
K_K406  L_L3  L_L166  0.0030
K_K407  L_L3  L_L167  0.0029
K_K408  L_L3  L_L168  0.0028
K_K409  L_L3  L_L169  0.0027
K_K410  L_L3  L_L170  0.0026
K_K411  L_L3  L_L171  0.0025
K_K412  L_L3  L_L172  0.0024
K_K413  L_L3  L_L173  0.0024
K_K414  L_L3  L_L174  0.0023
K_K415  L_L3  L_L175  0.0022
K_K416  L_L3  L_L176  0.0022
K_K417  L_L3  L_L177  0.0021
K_K418  L_L3  L_L178  0.0020
K_K419  L_L3  L_L179  0.0020
K_K420  L_L3  L_L180  0.0019
K_K421  L_L3  L_L181  0.0019
K_K422  L_L3  L_L182  0.0018
K_K423  L_L3  L_L183  0.0018
K_K424  L_L3  L_L184  0.0018
K_K425  L_L3  L_L185  0.0017
K_K426  L_L3  L_L186  0.0017
K_K427  L_L3  L_L187  0.0016
K_K428  L_L3  L_L188  0.0016
K_K429  L_L3  L_L189  0.0016
K_K430  L_L3  L_L190  0.0015
K_K431  L_L3  L_L191  0.0015
K_K432  L_L3  L_L192  0.0015
K_K433  L_L3  L_L193  0.0015
K_K434  L_L3  L_L194  0.0014
K_K435  L_L3  L_L195  0.0014
K_K436  L_L3  L_L196  0.0014
K_K437  L_L3  L_L197  0.0014
K_K438  L_L3  L_L198  0.0013
K_K439  L_L3  L_L199  0.0013
K_K440  L_L3  L_L200  0.0013
K_K441  L_L3  L_L201  0.0013
K_K442  L_L3  L_L202  0.0012
K_K443  L_L3  L_L203  0.0012
K_K444  L_L3  L_L204  0.0012
K_K445  L_L3  L_L205  0.0012
K_K446  L_L3  L_L206  0.0012
K_K447  L_L3  L_L207  0.0011
K_K448  L_L3  L_L208  0.0011
K_K449  L_L3  L_L209  0.0011
K_K450  L_L3  L_L210  0.0011
K_K451  L_L3  L_L211  0.0011
K_K452  L_L3  L_L212  0.0011
K_K453  L_L3  L_L213  0.0011
K_K454  L_L3  L_L214  0.0010
K_K455  L_L3  L_L215  0.0010
K_K456  L_L3  L_L216  0.0010
* *  Branch  NTMP0000000003 - NTMP0000000004
R_R4  NTMP0000000003  nU_4  32.914993m  TC=0,0
V_Ui4  nU_4  nR_4  STIMULUS=U_IND_0000000004
R_V7  nR_4  nV_7  23.280268m  TC=0,0
L_V7  nR_4  nV_7  0.014646uH
R_V8  nV_7  nV_8  7.852787m  TC=0,0
L_V8  nV_7  nV_8  0.073723uH
L_L4  nV_8  NTMP0000000004  6.519695uH
K_K457  L_L4  L_L5  0.1050
K_K458  L_L4  L_L6  0.0397
K_K459  L_L4  L_L7  0.0258
K_K460  L_L4  L_L8  0.0192
K_K461  L_L4  L_L9  0.0153
K_K462  L_L4  L_L10  0.0127
K_K463  L_L4  L_L11  0.0109
K_K464  L_L4  L_L12  0.0095
K_K465  L_L4  L_L13  0.0084
K_K466  L_L4  L_L14  0.0076
K_K467  L_L4  L_L15  0.0069
K_K468  L_L4  L_L16  0.0063
K_K469  L_L4  L_L17  0.0058
K_K470  L_L4  L_L18  0.0054
K_K471  L_L4  L_L19  0.0051
K_K472  L_L4  L_L20  0.0047
K_K473  L_L4  L_L21  0.0045
K_K474  L_L4  L_L22  0.0042
K_K475  L_L4  L_L23  0.0040
K_K476  L_L4  L_L24  0.0038
K_K477  L_L4  L_L25  0.0036
K_K478  L_L4  L_L26  0.0034
K_K479  L_L4  L_L27  0.0033
K_K480  L_L4  L_L28  0.0032
K_K481  L_L4  L_L29  0.0030
K_K482  L_L4  L_L30  0.0029
K_K483  L_L4  L_L31  0.0028
K_K484  L_L4  L_L32  0.0027
K_K485  L_L4  L_L33  0.0026
K_K486  L_L4  L_L34  0.0025
K_K487  L_L4  L_L35  0.0024
K_K488  L_L4  L_L36  0.0024
K_K489  L_L4  L_L37  0.0023
K_K490  L_L4  L_L38  0.0022
K_K491  L_L4  L_L39  0.0022
K_K492  L_L4  L_L40  0.0021
K_K493  L_L4  L_L41  0.0020
K_K494  L_L4  L_L42  0.0020
K_K495  L_L4  L_L43  0.0019
K_K496  L_L4  L_L44  0.0019
K_K497  L_L4  L_L45  0.0019
K_K498  L_L4  L_L46  0.0018
K_K499  L_L4  L_L47  0.0018
K_K500  L_L4  L_L48  0.0017
K_K501  L_L4  L_L49  0.0017
K_K502  L_L4  L_L50  0.0017
K_K503  L_L4  L_L51  0.0016
K_K504  L_L4  L_L52  0.0016
K_K505  L_L4  L_L53  0.0015
K_K506  L_L4  L_L54  0.0015
K_K507  L_L4  L_L55  0.0015
K_K508  L_L4  L_L56  0.0015
K_K509  L_L4  L_L57  0.0014
K_K510  L_L4  L_L58  0.0014
K_K511  L_L4  L_L59  0.0014
K_K512  L_L4  L_L60  0.0014
K_K513  L_L4  L_L61  0.0013
K_K514  L_L4  L_L62  0.0013
K_K515  L_L4  L_L63  0.0013
K_K516  L_L4  L_L64  0.0013
K_K517  L_L4  L_L65  0.0013
K_K518  L_L4  L_L66  0.0012
K_K519  L_L4  L_L67  0.0012
K_K520  L_L4  L_L68  0.0012
K_K521  L_L4  L_L69  0.0012
K_K522  L_L4  L_L70  0.0011
K_K523  L_L4  L_L71  0.0011
K_K524  L_L4  L_L72  0.0011
K_K525  L_L4  L_L73  0.0011
K_K526  L_L4  L_L74  0.0011
K_K527  L_L4  L_L75  0.0011
K_K528  L_L4  L_L76  0.0011
K_K529  L_L4  L_L77  0.0010
K_K530  L_L4  L_L78  0.0010
K_K531  L_L4  L_L79  0.0010
K_K532  L_L4  L_L139  0.0256
K_K533  L_L4  L_L140  0.0389
K_K534  L_L4  L_L141  0.0812
K_K535  L_L4  L_L142  0.1569
K_K536  L_L4  L_L143  0.0812
K_K537  L_L4  L_L144  0.0389
K_K538  L_L4  L_L145  0.0256
K_K539  L_L4  L_L146  0.0191
K_K540  L_L4  L_L147  0.0152
K_K541  L_L4  L_L148  0.0127
K_K542  L_L4  L_L149  0.0109
K_K543  L_L4  L_L150  0.0095
K_K544  L_L4  L_L151  0.0084
K_K545  L_L4  L_L152  0.0076
K_K546  L_L4  L_L153  0.0069
K_K547  L_L4  L_L154  0.0063
K_K548  L_L4  L_L155  0.0058
K_K549  L_L4  L_L156  0.0054
K_K550  L_L4  L_L157  0.0051
K_K551  L_L4  L_L158  0.0047
K_K552  L_L4  L_L159  0.0045
K_K553  L_L4  L_L160  0.0042
K_K554  L_L4  L_L161  0.0040
K_K555  L_L4  L_L162  0.0038
K_K556  L_L4  L_L163  0.0036
K_K557  L_L4  L_L164  0.0034
K_K558  L_L4  L_L165  0.0033
K_K559  L_L4  L_L166  0.0032
K_K560  L_L4  L_L167  0.0030
K_K561  L_L4  L_L168  0.0029
K_K562  L_L4  L_L169  0.0028
K_K563  L_L4  L_L170  0.0027
K_K564  L_L4  L_L171  0.0026
K_K565  L_L4  L_L172  0.0025
K_K566  L_L4  L_L173  0.0024
K_K567  L_L4  L_L174  0.0024
K_K568  L_L4  L_L175  0.0023
K_K569  L_L4  L_L176  0.0022
K_K570  L_L4  L_L177  0.0022
K_K571  L_L4  L_L178  0.0021
K_K572  L_L4  L_L179  0.0020
K_K573  L_L4  L_L180  0.0020
K_K574  L_L4  L_L181  0.0019
K_K575  L_L4  L_L182  0.0019
K_K576  L_L4  L_L183  0.0018
K_K577  L_L4  L_L184  0.0018
K_K578  L_L4  L_L185  0.0018
K_K579  L_L4  L_L186  0.0017
K_K580  L_L4  L_L187  0.0017
K_K581  L_L4  L_L188  0.0016
K_K582  L_L4  L_L189  0.0016
K_K583  L_L4  L_L190  0.0016
K_K584  L_L4  L_L191  0.0015
K_K585  L_L4  L_L192  0.0015
K_K586  L_L4  L_L193  0.0015
K_K587  L_L4  L_L194  0.0015
K_K588  L_L4  L_L195  0.0014
K_K589  L_L4  L_L196  0.0014
K_K590  L_L4  L_L197  0.0014
K_K591  L_L4  L_L198  0.0014
K_K592  L_L4  L_L199  0.0013
K_K593  L_L4  L_L200  0.0013
K_K594  L_L4  L_L201  0.0013
K_K595  L_L4  L_L202  0.0013
K_K596  L_L4  L_L203  0.0012
K_K597  L_L4  L_L204  0.0012
K_K598  L_L4  L_L205  0.0012
K_K599  L_L4  L_L206  0.0012
K_K600  L_L4  L_L207  0.0012
K_K601  L_L4  L_L208  0.0011
K_K602  L_L4  L_L209  0.0011
K_K603  L_L4  L_L210  0.0011
K_K604  L_L4  L_L211  0.0011
K_K605  L_L4  L_L212  0.0011
K_K606  L_L4  L_L213  0.0011
K_K607  L_L4  L_L214  0.0011
K_K608  L_L4  L_L215  0.0010
K_K609  L_L4  L_L216  0.0010
K_K610  L_L4  L_L217  0.0010
* *  Branch  NTMP0000000004 - NTMP0000000005
R_R5  NTMP0000000004  nU_5  32.914993m  TC=0,0
V_Ui5  nU_5  nR_5  STIMULUS=U_IND_0000000005
R_V9  nR_5  nV_9  23.280268m  TC=0,0
L_V9  nR_5  nV_9  0.014646uH
R_V10  nV_9  nV_10  7.852787m  TC=0,0
L_V10  nV_9  nV_10  0.073723uH
L_L5  nV_10  NTMP0000000005  6.519695uH
K_K611  L_L5  L_L6  0.1050
K_K612  L_L5  L_L7  0.0397
K_K613  L_L5  L_L8  0.0258
K_K614  L_L5  L_L9  0.0192
K_K615  L_L5  L_L10  0.0153
K_K616  L_L5  L_L11  0.0127
K_K617  L_L5  L_L12  0.0109
K_K618  L_L5  L_L13  0.0095
K_K619  L_L5  L_L14  0.0084
K_K620  L_L5  L_L15  0.0076
K_K621  L_L5  L_L16  0.0069
K_K622  L_L5  L_L17  0.0063
K_K623  L_L5  L_L18  0.0058
K_K624  L_L5  L_L19  0.0054
K_K625  L_L5  L_L20  0.0051
K_K626  L_L5  L_L21  0.0047
K_K627  L_L5  L_L22  0.0045
K_K628  L_L5  L_L23  0.0042
K_K629  L_L5  L_L24  0.0040
K_K630  L_L5  L_L25  0.0038
K_K631  L_L5  L_L26  0.0036
K_K632  L_L5  L_L27  0.0034
K_K633  L_L5  L_L28  0.0033
K_K634  L_L5  L_L29  0.0032
K_K635  L_L5  L_L30  0.0030
K_K636  L_L5  L_L31  0.0029
K_K637  L_L5  L_L32  0.0028
K_K638  L_L5  L_L33  0.0027
K_K639  L_L5  L_L34  0.0026
K_K640  L_L5  L_L35  0.0025
K_K641  L_L5  L_L36  0.0024
K_K642  L_L5  L_L37  0.0024
K_K643  L_L5  L_L38  0.0023
K_K644  L_L5  L_L39  0.0022
K_K645  L_L5  L_L40  0.0022
K_K646  L_L5  L_L41  0.0021
K_K647  L_L5  L_L42  0.0020
K_K648  L_L5  L_L43  0.0020
K_K649  L_L5  L_L44  0.0019
K_K650  L_L5  L_L45  0.0019
K_K651  L_L5  L_L46  0.0018
K_K652  L_L5  L_L47  0.0018
K_K653  L_L5  L_L48  0.0018
K_K654  L_L5  L_L49  0.0017
K_K655  L_L5  L_L50  0.0017
K_K656  L_L5  L_L51  0.0016
K_K657  L_L5  L_L52  0.0016
K_K658  L_L5  L_L53  0.0016
K_K659  L_L5  L_L54  0.0015
K_K660  L_L5  L_L55  0.0015
K_K661  L_L5  L_L56  0.0015
K_K662  L_L5  L_L57  0.0015
K_K663  L_L5  L_L58  0.0014
K_K664  L_L5  L_L59  0.0014
K_K665  L_L5  L_L60  0.0014
K_K666  L_L5  L_L61  0.0014
K_K667  L_L5  L_L62  0.0013
K_K668  L_L5  L_L63  0.0013
K_K669  L_L5  L_L64  0.0013
K_K670  L_L5  L_L65  0.0013
K_K671  L_L5  L_L66  0.0013
K_K672  L_L5  L_L67  0.0012
K_K673  L_L5  L_L68  0.0012
K_K674  L_L5  L_L69  0.0012
K_K675  L_L5  L_L70  0.0012
K_K676  L_L5  L_L71  0.0011
K_K677  L_L5  L_L72  0.0011
K_K678  L_L5  L_L73  0.0011
K_K679  L_L5  L_L74  0.0011
K_K680  L_L5  L_L75  0.0011
K_K681  L_L5  L_L76  0.0011
K_K682  L_L5  L_L77  0.0011
K_K683  L_L5  L_L78  0.0010
K_K684  L_L5  L_L79  0.0010
K_K685  L_L5  L_L80  0.0010
K_K686  L_L5  L_L139  0.0191
K_K687  L_L5  L_L140  0.0256
K_K688  L_L5  L_L141  0.0389
K_K689  L_L5  L_L142  0.0812
K_K690  L_L5  L_L143  0.1569
K_K691  L_L5  L_L144  0.0812
K_K692  L_L5  L_L145  0.0389
K_K693  L_L5  L_L146  0.0256
K_K694  L_L5  L_L147  0.0191
K_K695  L_L5  L_L148  0.0152
K_K696  L_L5  L_L149  0.0127
K_K697  L_L5  L_L150  0.0109
K_K698  L_L5  L_L151  0.0095
K_K699  L_L5  L_L152  0.0084
K_K700  L_L5  L_L153  0.0076
K_K701  L_L5  L_L154  0.0069
K_K702  L_L5  L_L155  0.0063
K_K703  L_L5  L_L156  0.0058
K_K704  L_L5  L_L157  0.0054
K_K705  L_L5  L_L158  0.0051
K_K706  L_L5  L_L159  0.0047
K_K707  L_L5  L_L160  0.0045
K_K708  L_L5  L_L161  0.0042
K_K709  L_L5  L_L162  0.0040
K_K710  L_L5  L_L163  0.0038
K_K711  L_L5  L_L164  0.0036
K_K712  L_L5  L_L165  0.0034
K_K713  L_L5  L_L166  0.0033
K_K714  L_L5  L_L167  0.0032
K_K715  L_L5  L_L168  0.0030
K_K716  L_L5  L_L169  0.0029
K_K717  L_L5  L_L170  0.0028
K_K718  L_L5  L_L171  0.0027
K_K719  L_L5  L_L172  0.0026
K_K720  L_L5  L_L173  0.0025
K_K721  L_L5  L_L174  0.0024
K_K722  L_L5  L_L175  0.0024
K_K723  L_L5  L_L176  0.0023
K_K724  L_L5  L_L177  0.0022
K_K725  L_L5  L_L178  0.0022
K_K726  L_L5  L_L179  0.0021
K_K727  L_L5  L_L180  0.0020
K_K728  L_L5  L_L181  0.0020
K_K729  L_L5  L_L182  0.0019
K_K730  L_L5  L_L183  0.0019
K_K731  L_L5  L_L184  0.0018
K_K732  L_L5  L_L185  0.0018
K_K733  L_L5  L_L186  0.0018
K_K734  L_L5  L_L187  0.0017
K_K735  L_L5  L_L188  0.0017
K_K736  L_L5  L_L189  0.0016
K_K737  L_L5  L_L190  0.0016
K_K738  L_L5  L_L191  0.0016
K_K739  L_L5  L_L192  0.0015
K_K740  L_L5  L_L193  0.0015
K_K741  L_L5  L_L194  0.0015
K_K742  L_L5  L_L195  0.0015
K_K743  L_L5  L_L196  0.0014
K_K744  L_L5  L_L197  0.0014
K_K745  L_L5  L_L198  0.0014
K_K746  L_L5  L_L199  0.0014
K_K747  L_L5  L_L200  0.0013
K_K748  L_L5  L_L201  0.0013
K_K749  L_L5  L_L202  0.0013
K_K750  L_L5  L_L203  0.0013
K_K751  L_L5  L_L204  0.0012
K_K752  L_L5  L_L205  0.0012
K_K753  L_L5  L_L206  0.0012
K_K754  L_L5  L_L207  0.0012
K_K755  L_L5  L_L208  0.0012
K_K756  L_L5  L_L209  0.0011
K_K757  L_L5  L_L210  0.0011
K_K758  L_L5  L_L211  0.0011
K_K759  L_L5  L_L212  0.0011
K_K760  L_L5  L_L213  0.0011
K_K761  L_L5  L_L214  0.0011
K_K762  L_L5  L_L215  0.0011
K_K763  L_L5  L_L216  0.0010
K_K764  L_L5  L_L217  0.0010
K_K765  L_L5  L_L218  0.0010
* *  Branch  NTMP0000000005 - NTMP0000000006
R_R6  NTMP0000000005  nU_6  32.914993m  TC=0,0
V_Ui6  nU_6  nR_6  STIMULUS=U_IND_0000000006
R_V11  nR_6  nV_11  23.280268m  TC=0,0
L_V11  nR_6  nV_11  0.014646uH
R_V12  nV_11  nV_12  7.852787m  TC=0,0
L_V12  nV_11  nV_12  0.073723uH
L_L6  nV_12  NTMP0000000006  6.519695uH
K_K766  L_L6  L_L7  0.1050
K_K767  L_L6  L_L8  0.0397
K_K768  L_L6  L_L9  0.0258
K_K769  L_L6  L_L10  0.0192
K_K770  L_L6  L_L11  0.0153
K_K771  L_L6  L_L12  0.0127
K_K772  L_L6  L_L13  0.0109
K_K773  L_L6  L_L14  0.0095
K_K774  L_L6  L_L15  0.0084
K_K775  L_L6  L_L16  0.0076
K_K776  L_L6  L_L17  0.0069
K_K777  L_L6  L_L18  0.0063
K_K778  L_L6  L_L19  0.0058
K_K779  L_L6  L_L20  0.0054
K_K780  L_L6  L_L21  0.0051
K_K781  L_L6  L_L22  0.0047
K_K782  L_L6  L_L23  0.0045
K_K783  L_L6  L_L24  0.0042
K_K784  L_L6  L_L25  0.0040
K_K785  L_L6  L_L26  0.0038
K_K786  L_L6  L_L27  0.0036
K_K787  L_L6  L_L28  0.0034
K_K788  L_L6  L_L29  0.0033
K_K789  L_L6  L_L30  0.0032
K_K790  L_L6  L_L31  0.0030
K_K791  L_L6  L_L32  0.0029
K_K792  L_L6  L_L33  0.0028
K_K793  L_L6  L_L34  0.0027
K_K794  L_L6  L_L35  0.0026
K_K795  L_L6  L_L36  0.0025
K_K796  L_L6  L_L37  0.0024
K_K797  L_L6  L_L38  0.0024
K_K798  L_L6  L_L39  0.0023
K_K799  L_L6  L_L40  0.0022
K_K800  L_L6  L_L41  0.0022
K_K801  L_L6  L_L42  0.0021
K_K802  L_L6  L_L43  0.0020
K_K803  L_L6  L_L44  0.0020
K_K804  L_L6  L_L45  0.0019
K_K805  L_L6  L_L46  0.0019
K_K806  L_L6  L_L47  0.0018
K_K807  L_L6  L_L48  0.0018
K_K808  L_L6  L_L49  0.0018
K_K809  L_L6  L_L50  0.0017
K_K810  L_L6  L_L51  0.0017
K_K811  L_L6  L_L52  0.0016
K_K812  L_L6  L_L53  0.0016
K_K813  L_L6  L_L54  0.0016
K_K814  L_L6  L_L55  0.0016
K_K815  L_L6  L_L56  0.0015
K_K816  L_L6  L_L57  0.0015
K_K817  L_L6  L_L58  0.0015
K_K818  L_L6  L_L59  0.0014
K_K819  L_L6  L_L60  0.0014
K_K820  L_L6  L_L61  0.0014
K_K821  L_L6  L_L62  0.0014
K_K822  L_L6  L_L63  0.0013
K_K823  L_L6  L_L64  0.0013
K_K824  L_L6  L_L65  0.0013
K_K825  L_L6  L_L66  0.0013
K_K826  L_L6  L_L67  0.0013
K_K827  L_L6  L_L68  0.0012
K_K828  L_L6  L_L69  0.0012
K_K829  L_L6  L_L70  0.0012
K_K830  L_L6  L_L71  0.0012
K_K831  L_L6  L_L72  0.0011
K_K832  L_L6  L_L73  0.0011
K_K833  L_L6  L_L74  0.0011
K_K834  L_L6  L_L75  0.0011
K_K835  L_L6  L_L76  0.0011
K_K836  L_L6  L_L77  0.0011
K_K837  L_L6  L_L78  0.0011
K_K838  L_L6  L_L79  0.0010
K_K839  L_L6  L_L80  0.0010
K_K840  L_L6  L_L81  0.0010
K_K841  L_L6  L_L139  0.0152
K_K842  L_L6  L_L140  0.0191
K_K843  L_L6  L_L141  0.0256
K_K844  L_L6  L_L142  0.0389
K_K845  L_L6  L_L143  0.0812
K_K846  L_L6  L_L144  0.1569
K_K847  L_L6  L_L145  0.0812
K_K848  L_L6  L_L146  0.0389
K_K849  L_L6  L_L147  0.0256
K_K850  L_L6  L_L148  0.0191
K_K851  L_L6  L_L149  0.0152
K_K852  L_L6  L_L150  0.0127
K_K853  L_L6  L_L151  0.0109
K_K854  L_L6  L_L152  0.0095
K_K855  L_L6  L_L153  0.0084
K_K856  L_L6  L_L154  0.0076
K_K857  L_L6  L_L155  0.0069
K_K858  L_L6  L_L156  0.0063
K_K859  L_L6  L_L157  0.0058
K_K860  L_L6  L_L158  0.0054
K_K861  L_L6  L_L159  0.0051
K_K862  L_L6  L_L160  0.0047
K_K863  L_L6  L_L161  0.0045
K_K864  L_L6  L_L162  0.0042
K_K865  L_L6  L_L163  0.0040
K_K866  L_L6  L_L164  0.0038
K_K867  L_L6  L_L165  0.0036
K_K868  L_L6  L_L166  0.0034
K_K869  L_L6  L_L167  0.0033
K_K870  L_L6  L_L168  0.0032
K_K871  L_L6  L_L169  0.0030
K_K872  L_L6  L_L170  0.0029
K_K873  L_L6  L_L171  0.0028
K_K874  L_L6  L_L172  0.0027
K_K875  L_L6  L_L173  0.0026
K_K876  L_L6  L_L174  0.0025
K_K877  L_L6  L_L175  0.0024
K_K878  L_L6  L_L176  0.0024
K_K879  L_L6  L_L177  0.0023
K_K880  L_L6  L_L178  0.0022
K_K881  L_L6  L_L179  0.0022
K_K882  L_L6  L_L180  0.0021
K_K883  L_L6  L_L181  0.0020
K_K884  L_L6  L_L182  0.0020
K_K885  L_L6  L_L183  0.0019
K_K886  L_L6  L_L184  0.0019
K_K887  L_L6  L_L185  0.0018
K_K888  L_L6  L_L186  0.0018
K_K889  L_L6  L_L187  0.0018
K_K890  L_L6  L_L188  0.0017
K_K891  L_L6  L_L189  0.0017
K_K892  L_L6  L_L190  0.0016
K_K893  L_L6  L_L191  0.0016
K_K894  L_L6  L_L192  0.0016
K_K895  L_L6  L_L193  0.0015
K_K896  L_L6  L_L194  0.0015
K_K897  L_L6  L_L195  0.0015
K_K898  L_L6  L_L196  0.0015
K_K899  L_L6  L_L197  0.0014
K_K900  L_L6  L_L198  0.0014
K_K901  L_L6  L_L199  0.0014
K_K902  L_L6  L_L200  0.0014
K_K903  L_L6  L_L201  0.0013
K_K904  L_L6  L_L202  0.0013
K_K905  L_L6  L_L203  0.0013
K_K906  L_L6  L_L204  0.0013
K_K907  L_L6  L_L205  0.0012
K_K908  L_L6  L_L206  0.0012
K_K909  L_L6  L_L207  0.0012
K_K910  L_L6  L_L208  0.0012
K_K911  L_L6  L_L209  0.0012
K_K912  L_L6  L_L210  0.0011
K_K913  L_L6  L_L211  0.0011
K_K914  L_L6  L_L212  0.0011
K_K915  L_L6  L_L213  0.0011
K_K916  L_L6  L_L214  0.0011
K_K917  L_L6  L_L215  0.0011
K_K918  L_L6  L_L216  0.0011
K_K919  L_L6  L_L217  0.0010
K_K920  L_L6  L_L218  0.0010
K_K921  L_L6  L_L219  0.0010
* *  Branch  NTMP0000000006 - NTMP0000000007
R_R7  NTMP0000000006  nU_7  32.914993m  TC=0,0
V_Ui7  nU_7  nR_7  STIMULUS=U_IND_0000000007
R_V13  nR_7  nV_13  23.280268m  TC=0,0
L_V13  nR_7  nV_13  0.014646uH
R_V14  nV_13  nV_14  7.852787m  TC=0,0
L_V14  nV_13  nV_14  0.073723uH
L_L7  nV_14  NTMP0000000007  6.519695uH
K_K922  L_L7  L_L8  0.1050
K_K923  L_L7  L_L9  0.0397
K_K924  L_L7  L_L10  0.0258
K_K925  L_L7  L_L11  0.0192
K_K926  L_L7  L_L12  0.0153
K_K927  L_L7  L_L13  0.0127
K_K928  L_L7  L_L14  0.0109
K_K929  L_L7  L_L15  0.0095
K_K930  L_L7  L_L16  0.0084
K_K931  L_L7  L_L17  0.0076
K_K932  L_L7  L_L18  0.0069
K_K933  L_L7  L_L19  0.0063
K_K934  L_L7  L_L20  0.0058
K_K935  L_L7  L_L21  0.0054
K_K936  L_L7  L_L22  0.0051
K_K937  L_L7  L_L23  0.0047
K_K938  L_L7  L_L24  0.0045
K_K939  L_L7  L_L25  0.0042
K_K940  L_L7  L_L26  0.0040
K_K941  L_L7  L_L27  0.0038
K_K942  L_L7  L_L28  0.0036
K_K943  L_L7  L_L29  0.0034
K_K944  L_L7  L_L30  0.0033
K_K945  L_L7  L_L31  0.0032
K_K946  L_L7  L_L32  0.0030
K_K947  L_L7  L_L33  0.0029
K_K948  L_L7  L_L34  0.0028
K_K949  L_L7  L_L35  0.0027
K_K950  L_L7  L_L36  0.0026
K_K951  L_L7  L_L37  0.0025
K_K952  L_L7  L_L38  0.0024
K_K953  L_L7  L_L39  0.0024
K_K954  L_L7  L_L40  0.0023
K_K955  L_L7  L_L41  0.0022
K_K956  L_L7  L_L42  0.0022
K_K957  L_L7  L_L43  0.0021
K_K958  L_L7  L_L44  0.0020
K_K959  L_L7  L_L45  0.0020
K_K960  L_L7  L_L46  0.0019
K_K961  L_L7  L_L47  0.0019
K_K962  L_L7  L_L48  0.0018
K_K963  L_L7  L_L49  0.0018
K_K964  L_L7  L_L50  0.0018
K_K965  L_L7  L_L51  0.0017
K_K966  L_L7  L_L52  0.0017
K_K967  L_L7  L_L53  0.0016
K_K968  L_L7  L_L54  0.0016
K_K969  L_L7  L_L55  0.0016
K_K970  L_L7  L_L56  0.0015
K_K971  L_L7  L_L57  0.0015
K_K972  L_L7  L_L58  0.0015
K_K973  L_L7  L_L59  0.0015
K_K974  L_L7  L_L60  0.0014
K_K975  L_L7  L_L61  0.0014
K_K976  L_L7  L_L62  0.0014
K_K977  L_L7  L_L63  0.0014
K_K978  L_L7  L_L64  0.0013
K_K979  L_L7  L_L65  0.0013
K_K980  L_L7  L_L66  0.0013
K_K981  L_L7  L_L67  0.0013
K_K982  L_L7  L_L68  0.0013
K_K983  L_L7  L_L69  0.0012
K_K984  L_L7  L_L70  0.0012
K_K985  L_L7  L_L71  0.0012
K_K986  L_L7  L_L72  0.0012
K_K987  L_L7  L_L73  0.0011
K_K988  L_L7  L_L74  0.0011
K_K989  L_L7  L_L75  0.0011
K_K990  L_L7  L_L76  0.0011
K_K991  L_L7  L_L77  0.0011
K_K992  L_L7  L_L78  0.0011
K_K993  L_L7  L_L79  0.0011
K_K994  L_L7  L_L80  0.0010
K_K995  L_L7  L_L81  0.0010
K_K996  L_L7  L_L82  0.0010
K_K997  L_L7  L_L139  0.0127
K_K998  L_L7  L_L140  0.0152
K_K999  L_L7  L_L141  0.0191
K_K1000  L_L7  L_L142  0.0256
K_K1001  L_L7  L_L143  0.0389
K_K1002  L_L7  L_L144  0.0812
K_K1003  L_L7  L_L145  0.1569
K_K1004  L_L7  L_L146  0.0812
K_K1005  L_L7  L_L147  0.0389
K_K1006  L_L7  L_L148  0.0256
K_K1007  L_L7  L_L149  0.0191
K_K1008  L_L7  L_L150  0.0152
K_K1009  L_L7  L_L151  0.0127
K_K1010  L_L7  L_L152  0.0109
K_K1011  L_L7  L_L153  0.0095
K_K1012  L_L7  L_L154  0.0084
K_K1013  L_L7  L_L155  0.0076
K_K1014  L_L7  L_L156  0.0069
K_K1015  L_L7  L_L157  0.0063
K_K1016  L_L7  L_L158  0.0058
K_K1017  L_L7  L_L159  0.0054
K_K1018  L_L7  L_L160  0.0051
K_K1019  L_L7  L_L161  0.0047
K_K1020  L_L7  L_L162  0.0045
K_K1021  L_L7  L_L163  0.0042
K_K1022  L_L7  L_L164  0.0040
K_K1023  L_L7  L_L165  0.0038
K_K1024  L_L7  L_L166  0.0036
K_K1025  L_L7  L_L167  0.0034
K_K1026  L_L7  L_L168  0.0033
K_K1027  L_L7  L_L169  0.0032
K_K1028  L_L7  L_L170  0.0030
K_K1029  L_L7  L_L171  0.0029
K_K1030  L_L7  L_L172  0.0028
K_K1031  L_L7  L_L173  0.0027
K_K1032  L_L7  L_L174  0.0026
K_K1033  L_L7  L_L175  0.0025
K_K1034  L_L7  L_L176  0.0024
K_K1035  L_L7  L_L177  0.0024
K_K1036  L_L7  L_L178  0.0023
K_K1037  L_L7  L_L179  0.0022
K_K1038  L_L7  L_L180  0.0022
K_K1039  L_L7  L_L181  0.0021
K_K1040  L_L7  L_L182  0.0020
K_K1041  L_L7  L_L183  0.0020
K_K1042  L_L7  L_L184  0.0019
K_K1043  L_L7  L_L185  0.0019
K_K1044  L_L7  L_L186  0.0018
K_K1045  L_L7  L_L187  0.0018
K_K1046  L_L7  L_L188  0.0018
K_K1047  L_L7  L_L189  0.0017
K_K1048  L_L7  L_L190  0.0017
K_K1049  L_L7  L_L191  0.0016
K_K1050  L_L7  L_L192  0.0016
K_K1051  L_L7  L_L193  0.0016
K_K1052  L_L7  L_L194  0.0015
K_K1053  L_L7  L_L195  0.0015
K_K1054  L_L7  L_L196  0.0015
K_K1055  L_L7  L_L197  0.0015
K_K1056  L_L7  L_L198  0.0014
K_K1057  L_L7  L_L199  0.0014
K_K1058  L_L7  L_L200  0.0014
K_K1059  L_L7  L_L201  0.0014
K_K1060  L_L7  L_L202  0.0013
K_K1061  L_L7  L_L203  0.0013
K_K1062  L_L7  L_L204  0.0013
K_K1063  L_L7  L_L205  0.0013
K_K1064  L_L7  L_L206  0.0012
K_K1065  L_L7  L_L207  0.0012
K_K1066  L_L7  L_L208  0.0012
K_K1067  L_L7  L_L209  0.0012
K_K1068  L_L7  L_L210  0.0012
K_K1069  L_L7  L_L211  0.0011
K_K1070  L_L7  L_L212  0.0011
K_K1071  L_L7  L_L213  0.0011
K_K1072  L_L7  L_L214  0.0011
K_K1073  L_L7  L_L215  0.0011
K_K1074  L_L7  L_L216  0.0011
K_K1075  L_L7  L_L217  0.0011
K_K1076  L_L7  L_L218  0.0010
K_K1077  L_L7  L_L219  0.0010
K_K1078  L_L7  L_L220  0.0010
* *  Branch  NTMP0000000007 - NTMP0000000008
R_R8  NTMP0000000007  nU_8  32.914993m  TC=0,0
V_Ui8  nU_8  nR_8  STIMULUS=U_IND_0000000008
R_V15  nR_8  nV_15  23.280268m  TC=0,0
L_V15  nR_8  nV_15  0.014646uH
R_V16  nV_15  nV_16  7.852787m  TC=0,0
L_V16  nV_15  nV_16  0.073723uH
L_L8  nV_16  NTMP0000000008  6.519695uH
K_K1079  L_L8  L_L9  0.1050
K_K1080  L_L8  L_L10  0.0397
K_K1081  L_L8  L_L11  0.0258
K_K1082  L_L8  L_L12  0.0192
K_K1083  L_L8  L_L13  0.0153
K_K1084  L_L8  L_L14  0.0127
K_K1085  L_L8  L_L15  0.0109
K_K1086  L_L8  L_L16  0.0095
K_K1087  L_L8  L_L17  0.0084
K_K1088  L_L8  L_L18  0.0076
K_K1089  L_L8  L_L19  0.0069
K_K1090  L_L8  L_L20  0.0063
K_K1091  L_L8  L_L21  0.0058
K_K1092  L_L8  L_L22  0.0054
K_K1093  L_L8  L_L23  0.0051
K_K1094  L_L8  L_L24  0.0047
K_K1095  L_L8  L_L25  0.0045
K_K1096  L_L8  L_L26  0.0042
K_K1097  L_L8  L_L27  0.0040
K_K1098  L_L8  L_L28  0.0038
K_K1099  L_L8  L_L29  0.0036
K_K1100  L_L8  L_L30  0.0034
K_K1101  L_L8  L_L31  0.0033
K_K1102  L_L8  L_L32  0.0032
K_K1103  L_L8  L_L33  0.0030
K_K1104  L_L8  L_L34  0.0029
K_K1105  L_L8  L_L35  0.0028
K_K1106  L_L8  L_L36  0.0027
K_K1107  L_L8  L_L37  0.0026
K_K1108  L_L8  L_L38  0.0025
K_K1109  L_L8  L_L39  0.0024
K_K1110  L_L8  L_L40  0.0024
K_K1111  L_L8  L_L41  0.0023
K_K1112  L_L8  L_L42  0.0022
K_K1113  L_L8  L_L43  0.0022
K_K1114  L_L8  L_L44  0.0021
K_K1115  L_L8  L_L45  0.0020
K_K1116  L_L8  L_L46  0.0020
K_K1117  L_L8  L_L47  0.0019
K_K1118  L_L8  L_L48  0.0019
K_K1119  L_L8  L_L49  0.0018
K_K1120  L_L8  L_L50  0.0018
K_K1121  L_L8  L_L51  0.0018
K_K1122  L_L8  L_L52  0.0017
K_K1123  L_L8  L_L53  0.0017
K_K1124  L_L8  L_L54  0.0016
K_K1125  L_L8  L_L55  0.0016
K_K1126  L_L8  L_L56  0.0016
K_K1127  L_L8  L_L57  0.0015
K_K1128  L_L8  L_L58  0.0015
K_K1129  L_L8  L_L59  0.0015
K_K1130  L_L8  L_L60  0.0015
K_K1131  L_L8  L_L61  0.0014
K_K1132  L_L8  L_L62  0.0014
K_K1133  L_L8  L_L63  0.0014
K_K1134  L_L8  L_L64  0.0014
K_K1135  L_L8  L_L65  0.0013
K_K1136  L_L8  L_L66  0.0013
K_K1137  L_L8  L_L67  0.0013
K_K1138  L_L8  L_L68  0.0013
K_K1139  L_L8  L_L69  0.0013
K_K1140  L_L8  L_L70  0.0012
K_K1141  L_L8  L_L71  0.0012
K_K1142  L_L8  L_L72  0.0012
K_K1143  L_L8  L_L73  0.0012
K_K1144  L_L8  L_L74  0.0011
K_K1145  L_L8  L_L75  0.0011
K_K1146  L_L8  L_L76  0.0011
K_K1147  L_L8  L_L77  0.0011
K_K1148  L_L8  L_L78  0.0011
K_K1149  L_L8  L_L79  0.0011
K_K1150  L_L8  L_L80  0.0011
K_K1151  L_L8  L_L81  0.0010
K_K1152  L_L8  L_L82  0.0010
K_K1153  L_L8  L_L83  0.0010
K_K1154  L_L8  L_L139  0.0109
K_K1155  L_L8  L_L140  0.0127
K_K1156  L_L8  L_L141  0.0152
K_K1157  L_L8  L_L142  0.0191
K_K1158  L_L8  L_L143  0.0256
K_K1159  L_L8  L_L144  0.0389
K_K1160  L_L8  L_L145  0.0812
K_K1161  L_L8  L_L146  0.1569
K_K1162  L_L8  L_L147  0.0812
K_K1163  L_L8  L_L148  0.0389
K_K1164  L_L8  L_L149  0.0256
K_K1165  L_L8  L_L150  0.0191
K_K1166  L_L8  L_L151  0.0152
K_K1167  L_L8  L_L152  0.0127
K_K1168  L_L8  L_L153  0.0109
K_K1169  L_L8  L_L154  0.0095
K_K1170  L_L8  L_L155  0.0084
K_K1171  L_L8  L_L156  0.0076
K_K1172  L_L8  L_L157  0.0069
K_K1173  L_L8  L_L158  0.0063
K_K1174  L_L8  L_L159  0.0058
K_K1175  L_L8  L_L160  0.0054
K_K1176  L_L8  L_L161  0.0051
K_K1177  L_L8  L_L162  0.0047
K_K1178  L_L8  L_L163  0.0045
K_K1179  L_L8  L_L164  0.0042
K_K1180  L_L8  L_L165  0.0040
K_K1181  L_L8  L_L166  0.0038
K_K1182  L_L8  L_L167  0.0036
K_K1183  L_L8  L_L168  0.0034
K_K1184  L_L8  L_L169  0.0033
K_K1185  L_L8  L_L170  0.0032
K_K1186  L_L8  L_L171  0.0030
K_K1187  L_L8  L_L172  0.0029
K_K1188  L_L8  L_L173  0.0028
K_K1189  L_L8  L_L174  0.0027
K_K1190  L_L8  L_L175  0.0026
K_K1191  L_L8  L_L176  0.0025
K_K1192  L_L8  L_L177  0.0024
K_K1193  L_L8  L_L178  0.0024
K_K1194  L_L8  L_L179  0.0023
K_K1195  L_L8  L_L180  0.0022
K_K1196  L_L8  L_L181  0.0022
K_K1197  L_L8  L_L182  0.0021
K_K1198  L_L8  L_L183  0.0020
K_K1199  L_L8  L_L184  0.0020
K_K1200  L_L8  L_L185  0.0019
K_K1201  L_L8  L_L186  0.0019
K_K1202  L_L8  L_L187  0.0018
K_K1203  L_L8  L_L188  0.0018
K_K1204  L_L8  L_L189  0.0018
K_K1205  L_L8  L_L190  0.0017
K_K1206  L_L8  L_L191  0.0017
K_K1207  L_L8  L_L192  0.0016
K_K1208  L_L8  L_L193  0.0016
K_K1209  L_L8  L_L194  0.0016
K_K1210  L_L8  L_L195  0.0015
K_K1211  L_L8  L_L196  0.0015
K_K1212  L_L8  L_L197  0.0015
K_K1213  L_L8  L_L198  0.0015
K_K1214  L_L8  L_L199  0.0014
K_K1215  L_L8  L_L200  0.0014
K_K1216  L_L8  L_L201  0.0014
K_K1217  L_L8  L_L202  0.0014
K_K1218  L_L8  L_L203  0.0013
K_K1219  L_L8  L_L204  0.0013
K_K1220  L_L8  L_L205  0.0013
K_K1221  L_L8  L_L206  0.0013
K_K1222  L_L8  L_L207  0.0012
K_K1223  L_L8  L_L208  0.0012
K_K1224  L_L8  L_L209  0.0012
K_K1225  L_L8  L_L210  0.0012
K_K1226  L_L8  L_L211  0.0012
K_K1227  L_L8  L_L212  0.0011
K_K1228  L_L8  L_L213  0.0011
K_K1229  L_L8  L_L214  0.0011
K_K1230  L_L8  L_L215  0.0011
K_K1231  L_L8  L_L216  0.0011
K_K1232  L_L8  L_L217  0.0011
K_K1233  L_L8  L_L218  0.0011
K_K1234  L_L8  L_L219  0.0010
K_K1235  L_L8  L_L220  0.0010
K_K1236  L_L8  L_L221  0.0010
* *  Branch  NTMP0000000008 - NTMP0000000009
R_R9  NTMP0000000008  nU_9  32.914993m  TC=0,0
V_Ui9  nU_9  nR_9  STIMULUS=U_IND_0000000009
R_V17  nR_9  nV_17  23.280268m  TC=0,0
L_V17  nR_9  nV_17  0.014646uH
R_V18  nV_17  nV_18  7.852787m  TC=0,0
L_V18  nV_17  nV_18  0.073723uH
L_L9  nV_18  NTMP0000000009  6.519695uH
K_K1237  L_L9  L_L10  0.1050
K_K1238  L_L9  L_L11  0.0397
K_K1239  L_L9  L_L12  0.0258
K_K1240  L_L9  L_L13  0.0192
K_K1241  L_L9  L_L14  0.0153
K_K1242  L_L9  L_L15  0.0127
K_K1243  L_L9  L_L16  0.0109
K_K1244  L_L9  L_L17  0.0095
K_K1245  L_L9  L_L18  0.0084
K_K1246  L_L9  L_L19  0.0076
K_K1247  L_L9  L_L20  0.0069
K_K1248  L_L9  L_L21  0.0063
K_K1249  L_L9  L_L22  0.0058
K_K1250  L_L9  L_L23  0.0054
K_K1251  L_L9  L_L24  0.0051
K_K1252  L_L9  L_L25  0.0047
K_K1253  L_L9  L_L26  0.0045
K_K1254  L_L9  L_L27  0.0042
K_K1255  L_L9  L_L28  0.0040
K_K1256  L_L9  L_L29  0.0038
K_K1257  L_L9  L_L30  0.0036
K_K1258  L_L9  L_L31  0.0034
K_K1259  L_L9  L_L32  0.0033
K_K1260  L_L9  L_L33  0.0032
K_K1261  L_L9  L_L34  0.0030
K_K1262  L_L9  L_L35  0.0029
K_K1263  L_L9  L_L36  0.0028
K_K1264  L_L9  L_L37  0.0027
K_K1265  L_L9  L_L38  0.0026
K_K1266  L_L9  L_L39  0.0025
K_K1267  L_L9  L_L40  0.0024
K_K1268  L_L9  L_L41  0.0024
K_K1269  L_L9  L_L42  0.0023
K_K1270  L_L9  L_L43  0.0022
K_K1271  L_L9  L_L44  0.0022
K_K1272  L_L9  L_L45  0.0021
K_K1273  L_L9  L_L46  0.0020
K_K1274  L_L9  L_L47  0.0020
K_K1275  L_L9  L_L48  0.0019
K_K1276  L_L9  L_L49  0.0019
K_K1277  L_L9  L_L50  0.0018
K_K1278  L_L9  L_L51  0.0018
K_K1279  L_L9  L_L52  0.0018
K_K1280  L_L9  L_L53  0.0017
K_K1281  L_L9  L_L54  0.0017
K_K1282  L_L9  L_L55  0.0016
K_K1283  L_L9  L_L56  0.0016
K_K1284  L_L9  L_L57  0.0016
K_K1285  L_L9  L_L58  0.0015
K_K1286  L_L9  L_L59  0.0015
K_K1287  L_L9  L_L60  0.0015
K_K1288  L_L9  L_L61  0.0015
K_K1289  L_L9  L_L62  0.0014
K_K1290  L_L9  L_L63  0.0014
K_K1291  L_L9  L_L64  0.0014
K_K1292  L_L9  L_L65  0.0014
K_K1293  L_L9  L_L66  0.0013
K_K1294  L_L9  L_L67  0.0013
K_K1295  L_L9  L_L68  0.0013
K_K1296  L_L9  L_L69  0.0013
K_K1297  L_L9  L_L70  0.0013
K_K1298  L_L9  L_L71  0.0012
K_K1299  L_L9  L_L72  0.0012
K_K1300  L_L9  L_L73  0.0012
K_K1301  L_L9  L_L74  0.0012
K_K1302  L_L9  L_L75  0.0011
K_K1303  L_L9  L_L76  0.0011
K_K1304  L_L9  L_L77  0.0011
K_K1305  L_L9  L_L78  0.0011
K_K1306  L_L9  L_L79  0.0011
K_K1307  L_L9  L_L80  0.0011
K_K1308  L_L9  L_L81  0.0011
K_K1309  L_L9  L_L82  0.0010
K_K1310  L_L9  L_L83  0.0010
K_K1311  L_L9  L_L84  0.0010
K_K1312  L_L9  L_L139  0.0095
K_K1313  L_L9  L_L140  0.0109
K_K1314  L_L9  L_L141  0.0127
K_K1315  L_L9  L_L142  0.0152
K_K1316  L_L9  L_L143  0.0191
K_K1317  L_L9  L_L144  0.0256
K_K1318  L_L9  L_L145  0.0389
K_K1319  L_L9  L_L146  0.0812
K_K1320  L_L9  L_L147  0.1569
K_K1321  L_L9  L_L148  0.0812
K_K1322  L_L9  L_L149  0.0389
K_K1323  L_L9  L_L150  0.0256
K_K1324  L_L9  L_L151  0.0191
K_K1325  L_L9  L_L152  0.0152
K_K1326  L_L9  L_L153  0.0127
K_K1327  L_L9  L_L154  0.0109
K_K1328  L_L9  L_L155  0.0095
K_K1329  L_L9  L_L156  0.0084
K_K1330  L_L9  L_L157  0.0076
K_K1331  L_L9  L_L158  0.0069
K_K1332  L_L9  L_L159  0.0063
K_K1333  L_L9  L_L160  0.0058
K_K1334  L_L9  L_L161  0.0054
K_K1335  L_L9  L_L162  0.0051
K_K1336  L_L9  L_L163  0.0047
K_K1337  L_L9  L_L164  0.0045
K_K1338  L_L9  L_L165  0.0042
K_K1339  L_L9  L_L166  0.0040
K_K1340  L_L9  L_L167  0.0038
K_K1341  L_L9  L_L168  0.0036
K_K1342  L_L9  L_L169  0.0034
K_K1343  L_L9  L_L170  0.0033
K_K1344  L_L9  L_L171  0.0032
K_K1345  L_L9  L_L172  0.0030
K_K1346  L_L9  L_L173  0.0029
K_K1347  L_L9  L_L174  0.0028
K_K1348  L_L9  L_L175  0.0027
K_K1349  L_L9  L_L176  0.0026
K_K1350  L_L9  L_L177  0.0025
K_K1351  L_L9  L_L178  0.0024
K_K1352  L_L9  L_L179  0.0024
K_K1353  L_L9  L_L180  0.0023
K_K1354  L_L9  L_L181  0.0022
K_K1355  L_L9  L_L182  0.0022
K_K1356  L_L9  L_L183  0.0021
K_K1357  L_L9  L_L184  0.0020
K_K1358  L_L9  L_L185  0.0020
K_K1359  L_L9  L_L186  0.0019
K_K1360  L_L9  L_L187  0.0019
K_K1361  L_L9  L_L188  0.0018
K_K1362  L_L9  L_L189  0.0018
K_K1363  L_L9  L_L190  0.0018
K_K1364  L_L9  L_L191  0.0017
K_K1365  L_L9  L_L192  0.0017
K_K1366  L_L9  L_L193  0.0016
K_K1367  L_L9  L_L194  0.0016
K_K1368  L_L9  L_L195  0.0016
K_K1369  L_L9  L_L196  0.0015
K_K1370  L_L9  L_L197  0.0015
K_K1371  L_L9  L_L198  0.0015
K_K1372  L_L9  L_L199  0.0015
K_K1373  L_L9  L_L200  0.0014
K_K1374  L_L9  L_L201  0.0014
K_K1375  L_L9  L_L202  0.0014
K_K1376  L_L9  L_L203  0.0014
K_K1377  L_L9  L_L204  0.0013
K_K1378  L_L9  L_L205  0.0013
K_K1379  L_L9  L_L206  0.0013
K_K1380  L_L9  L_L207  0.0013
K_K1381  L_L9  L_L208  0.0012
K_K1382  L_L9  L_L209  0.0012
K_K1383  L_L9  L_L210  0.0012
K_K1384  L_L9  L_L211  0.0012
K_K1385  L_L9  L_L212  0.0012
K_K1386  L_L9  L_L213  0.0011
K_K1387  L_L9  L_L214  0.0011
K_K1388  L_L9  L_L215  0.0011
K_K1389  L_L9  L_L216  0.0011
K_K1390  L_L9  L_L217  0.0011
K_K1391  L_L9  L_L218  0.0011
K_K1392  L_L9  L_L219  0.0011
K_K1393  L_L9  L_L220  0.0010
K_K1394  L_L9  L_L221  0.0010
K_K1395  L_L9  L_L222  0.0010
* *  Branch  NTMP0000000009 - NTMP0000000010
R_R10  NTMP0000000009  nU_10  32.914993m  TC=0,0
V_Ui10  nU_10  nR_10  STIMULUS=U_IND_0000000010
R_V19  nR_10  nV_19  23.280268m  TC=0,0
L_V19  nR_10  nV_19  0.014646uH
R_V20  nV_19  nV_20  7.852787m  TC=0,0
L_V20  nV_19  nV_20  0.073723uH
L_L10  nV_20  NTMP0000000010  6.519695uH
K_K1396  L_L10  L_L11  0.1050
K_K1397  L_L10  L_L12  0.0397
K_K1398  L_L10  L_L13  0.0258
K_K1399  L_L10  L_L14  0.0192
K_K1400  L_L10  L_L15  0.0153
K_K1401  L_L10  L_L16  0.0127
K_K1402  L_L10  L_L17  0.0109
K_K1403  L_L10  L_L18  0.0095
K_K1404  L_L10  L_L19  0.0084
K_K1405  L_L10  L_L20  0.0076
K_K1406  L_L10  L_L21  0.0069
K_K1407  L_L10  L_L22  0.0063
K_K1408  L_L10  L_L23  0.0058
K_K1409  L_L10  L_L24  0.0054
K_K1410  L_L10  L_L25  0.0051
K_K1411  L_L10  L_L26  0.0047
K_K1412  L_L10  L_L27  0.0045
K_K1413  L_L10  L_L28  0.0042
K_K1414  L_L10  L_L29  0.0040
K_K1415  L_L10  L_L30  0.0038
K_K1416  L_L10  L_L31  0.0036
K_K1417  L_L10  L_L32  0.0034
K_K1418  L_L10  L_L33  0.0033
K_K1419  L_L10  L_L34  0.0032
K_K1420  L_L10  L_L35  0.0030
K_K1421  L_L10  L_L36  0.0029
K_K1422  L_L10  L_L37  0.0028
K_K1423  L_L10  L_L38  0.0027
K_K1424  L_L10  L_L39  0.0026
K_K1425  L_L10  L_L40  0.0025
K_K1426  L_L10  L_L41  0.0024
K_K1427  L_L10  L_L42  0.0024
K_K1428  L_L10  L_L43  0.0023
K_K1429  L_L10  L_L44  0.0022
K_K1430  L_L10  L_L45  0.0022
K_K1431  L_L10  L_L46  0.0021
K_K1432  L_L10  L_L47  0.0020
K_K1433  L_L10  L_L48  0.0020
K_K1434  L_L10  L_L49  0.0019
K_K1435  L_L10  L_L50  0.0019
K_K1436  L_L10  L_L51  0.0018
K_K1437  L_L10  L_L52  0.0018
K_K1438  L_L10  L_L53  0.0018
K_K1439  L_L10  L_L54  0.0017
K_K1440  L_L10  L_L55  0.0017
K_K1441  L_L10  L_L56  0.0016
K_K1442  L_L10  L_L57  0.0016
K_K1443  L_L10  L_L58  0.0016
K_K1444  L_L10  L_L59  0.0015
K_K1445  L_L10  L_L60  0.0015
K_K1446  L_L10  L_L61  0.0015
K_K1447  L_L10  L_L62  0.0015
K_K1448  L_L10  L_L63  0.0014
K_K1449  L_L10  L_L64  0.0014
K_K1450  L_L10  L_L65  0.0014
K_K1451  L_L10  L_L66  0.0014
K_K1452  L_L10  L_L67  0.0013
K_K1453  L_L10  L_L68  0.0013
K_K1454  L_L10  L_L69  0.0013
K_K1455  L_L10  L_L70  0.0013
K_K1456  L_L10  L_L71  0.0013
K_K1457  L_L10  L_L72  0.0012
K_K1458  L_L10  L_L73  0.0012
K_K1459  L_L10  L_L74  0.0012
K_K1460  L_L10  L_L75  0.0012
K_K1461  L_L10  L_L76  0.0011
K_K1462  L_L10  L_L77  0.0011
K_K1463  L_L10  L_L78  0.0011
K_K1464  L_L10  L_L79  0.0011
K_K1465  L_L10  L_L80  0.0011
K_K1466  L_L10  L_L81  0.0011
K_K1467  L_L10  L_L82  0.0011
K_K1468  L_L10  L_L83  0.0010
K_K1469  L_L10  L_L84  0.0010
K_K1470  L_L10  L_L85  0.0010
K_K1471  L_L10  L_L139  0.0084
K_K1472  L_L10  L_L140  0.0095
K_K1473  L_L10  L_L141  0.0109
K_K1474  L_L10  L_L142  0.0127
K_K1475  L_L10  L_L143  0.0152
K_K1476  L_L10  L_L144  0.0191
K_K1477  L_L10  L_L145  0.0256
K_K1478  L_L10  L_L146  0.0389
K_K1479  L_L10  L_L147  0.0812
K_K1480  L_L10  L_L148  0.1569
K_K1481  L_L10  L_L149  0.0812
K_K1482  L_L10  L_L150  0.0389
K_K1483  L_L10  L_L151  0.0256
K_K1484  L_L10  L_L152  0.0191
K_K1485  L_L10  L_L153  0.0152
K_K1486  L_L10  L_L154  0.0127
K_K1487  L_L10  L_L155  0.0109
K_K1488  L_L10  L_L156  0.0095
K_K1489  L_L10  L_L157  0.0084
K_K1490  L_L10  L_L158  0.0076
K_K1491  L_L10  L_L159  0.0069
K_K1492  L_L10  L_L160  0.0063
K_K1493  L_L10  L_L161  0.0058
K_K1494  L_L10  L_L162  0.0054
K_K1495  L_L10  L_L163  0.0051
K_K1496  L_L10  L_L164  0.0047
K_K1497  L_L10  L_L165  0.0045
K_K1498  L_L10  L_L166  0.0042
K_K1499  L_L10  L_L167  0.0040
K_K1500  L_L10  L_L168  0.0038
K_K1501  L_L10  L_L169  0.0036
K_K1502  L_L10  L_L170  0.0034
K_K1503  L_L10  L_L171  0.0033
K_K1504  L_L10  L_L172  0.0032
K_K1505  L_L10  L_L173  0.0030
K_K1506  L_L10  L_L174  0.0029
K_K1507  L_L10  L_L175  0.0028
K_K1508  L_L10  L_L176  0.0027
K_K1509  L_L10  L_L177  0.0026
K_K1510  L_L10  L_L178  0.0025
K_K1511  L_L10  L_L179  0.0024
K_K1512  L_L10  L_L180  0.0024
K_K1513  L_L10  L_L181  0.0023
K_K1514  L_L10  L_L182  0.0022
K_K1515  L_L10  L_L183  0.0022
K_K1516  L_L10  L_L184  0.0021
K_K1517  L_L10  L_L185  0.0020
K_K1518  L_L10  L_L186  0.0020
K_K1519  L_L10  L_L187  0.0019
K_K1520  L_L10  L_L188  0.0019
K_K1521  L_L10  L_L189  0.0018
K_K1522  L_L10  L_L190  0.0018
K_K1523  L_L10  L_L191  0.0018
K_K1524  L_L10  L_L192  0.0017
K_K1525  L_L10  L_L193  0.0017
K_K1526  L_L10  L_L194  0.0016
K_K1527  L_L10  L_L195  0.0016
K_K1528  L_L10  L_L196  0.0016
K_K1529  L_L10  L_L197  0.0015
K_K1530  L_L10  L_L198  0.0015
K_K1531  L_L10  L_L199  0.0015
K_K1532  L_L10  L_L200  0.0015
K_K1533  L_L10  L_L201  0.0014
K_K1534  L_L10  L_L202  0.0014
K_K1535  L_L10  L_L203  0.0014
K_K1536  L_L10  L_L204  0.0014
K_K1537  L_L10  L_L205  0.0013
K_K1538  L_L10  L_L206  0.0013
K_K1539  L_L10  L_L207  0.0013
K_K1540  L_L10  L_L208  0.0013
K_K1541  L_L10  L_L209  0.0012
K_K1542  L_L10  L_L210  0.0012
K_K1543  L_L10  L_L211  0.0012
K_K1544  L_L10  L_L212  0.0012
K_K1545  L_L10  L_L213  0.0012
K_K1546  L_L10  L_L214  0.0011
K_K1547  L_L10  L_L215  0.0011
K_K1548  L_L10  L_L216  0.0011
K_K1549  L_L10  L_L217  0.0011
K_K1550  L_L10  L_L218  0.0011
K_K1551  L_L10  L_L219  0.0011
K_K1552  L_L10  L_L220  0.0011
K_K1553  L_L10  L_L221  0.0010
K_K1554  L_L10  L_L222  0.0010
K_K1555  L_L10  L_L223  0.0010
* *  Branch  NTMP0000000010 - NTMP0000000011
R_R11  NTMP0000000010  nU_11  32.914993m  TC=0,0
V_Ui11  nU_11  nR_11  STIMULUS=U_IND_0000000011
R_V21  nR_11  nV_21  23.280268m  TC=0,0
L_V21  nR_11  nV_21  0.014646uH
R_V22  nV_21  nV_22  7.852787m  TC=0,0
L_V22  nV_21  nV_22  0.073723uH
L_L11  nV_22  NTMP0000000011  6.519695uH
K_K1556  L_L11  L_L12  0.1050
K_K1557  L_L11  L_L13  0.0397
K_K1558  L_L11  L_L14  0.0258
K_K1559  L_L11  L_L15  0.0192
K_K1560  L_L11  L_L16  0.0153
K_K1561  L_L11  L_L17  0.0127
K_K1562  L_L11  L_L18  0.0109
K_K1563  L_L11  L_L19  0.0095
K_K1564  L_L11  L_L20  0.0084
K_K1565  L_L11  L_L21  0.0076
K_K1566  L_L11  L_L22  0.0069
K_K1567  L_L11  L_L23  0.0063
K_K1568  L_L11  L_L24  0.0058
K_K1569  L_L11  L_L25  0.0054
K_K1570  L_L11  L_L26  0.0051
K_K1571  L_L11  L_L27  0.0047
K_K1572  L_L11  L_L28  0.0045
K_K1573  L_L11  L_L29  0.0042
K_K1574  L_L11  L_L30  0.0040
K_K1575  L_L11  L_L31  0.0038
K_K1576  L_L11  L_L32  0.0036
K_K1577  L_L11  L_L33  0.0034
K_K1578  L_L11  L_L34  0.0033
K_K1579  L_L11  L_L35  0.0032
K_K1580  L_L11  L_L36  0.0030
K_K1581  L_L11  L_L37  0.0029
K_K1582  L_L11  L_L38  0.0028
K_K1583  L_L11  L_L39  0.0027
K_K1584  L_L11  L_L40  0.0026
K_K1585  L_L11  L_L41  0.0025
K_K1586  L_L11  L_L42  0.0024
K_K1587  L_L11  L_L43  0.0024
K_K1588  L_L11  L_L44  0.0023
K_K1589  L_L11  L_L45  0.0022
K_K1590  L_L11  L_L46  0.0022
K_K1591  L_L11  L_L47  0.0021
K_K1592  L_L11  L_L48  0.0020
K_K1593  L_L11  L_L49  0.0020
K_K1594  L_L11  L_L50  0.0019
K_K1595  L_L11  L_L51  0.0019
K_K1596  L_L11  L_L52  0.0018
K_K1597  L_L11  L_L53  0.0018
K_K1598  L_L11  L_L54  0.0018
K_K1599  L_L11  L_L55  0.0017
K_K1600  L_L11  L_L56  0.0017
K_K1601  L_L11  L_L57  0.0016
K_K1602  L_L11  L_L58  0.0016
K_K1603  L_L11  L_L59  0.0016
K_K1604  L_L11  L_L60  0.0015
K_K1605  L_L11  L_L61  0.0015
K_K1606  L_L11  L_L62  0.0015
K_K1607  L_L11  L_L63  0.0015
K_K1608  L_L11  L_L64  0.0014
K_K1609  L_L11  L_L65  0.0014
K_K1610  L_L11  L_L66  0.0014
K_K1611  L_L11  L_L67  0.0014
K_K1612  L_L11  L_L68  0.0013
K_K1613  L_L11  L_L69  0.0013
K_K1614  L_L11  L_L70  0.0013
K_K1615  L_L11  L_L71  0.0013
K_K1616  L_L11  L_L72  0.0013
K_K1617  L_L11  L_L73  0.0012
K_K1618  L_L11  L_L74  0.0012
K_K1619  L_L11  L_L75  0.0012
K_K1620  L_L11  L_L76  0.0012
K_K1621  L_L11  L_L77  0.0011
K_K1622  L_L11  L_L78  0.0011
K_K1623  L_L11  L_L79  0.0011
K_K1624  L_L11  L_L80  0.0011
K_K1625  L_L11  L_L81  0.0011
K_K1626  L_L11  L_L82  0.0011
K_K1627  L_L11  L_L83  0.0011
K_K1628  L_L11  L_L84  0.0010
K_K1629  L_L11  L_L85  0.0010
K_K1630  L_L11  L_L86  0.0010
K_K1631  L_L11  L_L139  0.0076
K_K1632  L_L11  L_L140  0.0084
K_K1633  L_L11  L_L141  0.0095
K_K1634  L_L11  L_L142  0.0109
K_K1635  L_L11  L_L143  0.0127
K_K1636  L_L11  L_L144  0.0152
K_K1637  L_L11  L_L145  0.0191
K_K1638  L_L11  L_L146  0.0256
K_K1639  L_L11  L_L147  0.0389
K_K1640  L_L11  L_L148  0.0812
K_K1641  L_L11  L_L149  0.1569
K_K1642  L_L11  L_L150  0.0812
K_K1643  L_L11  L_L151  0.0389
K_K1644  L_L11  L_L152  0.0256
K_K1645  L_L11  L_L153  0.0191
K_K1646  L_L11  L_L154  0.0152
K_K1647  L_L11  L_L155  0.0127
K_K1648  L_L11  L_L156  0.0109
K_K1649  L_L11  L_L157  0.0095
K_K1650  L_L11  L_L158  0.0084
K_K1651  L_L11  L_L159  0.0076
K_K1652  L_L11  L_L160  0.0069
K_K1653  L_L11  L_L161  0.0063
K_K1654  L_L11  L_L162  0.0058
K_K1655  L_L11  L_L163  0.0054
K_K1656  L_L11  L_L164  0.0051
K_K1657  L_L11  L_L165  0.0047
K_K1658  L_L11  L_L166  0.0045
K_K1659  L_L11  L_L167  0.0042
K_K1660  L_L11  L_L168  0.0040
K_K1661  L_L11  L_L169  0.0038
K_K1662  L_L11  L_L170  0.0036
K_K1663  L_L11  L_L171  0.0034
K_K1664  L_L11  L_L172  0.0033
K_K1665  L_L11  L_L173  0.0032
K_K1666  L_L11  L_L174  0.0030
K_K1667  L_L11  L_L175  0.0029
K_K1668  L_L11  L_L176  0.0028
K_K1669  L_L11  L_L177  0.0027
K_K1670  L_L11  L_L178  0.0026
K_K1671  L_L11  L_L179  0.0025
K_K1672  L_L11  L_L180  0.0024
K_K1673  L_L11  L_L181  0.0024
K_K1674  L_L11  L_L182  0.0023
K_K1675  L_L11  L_L183  0.0022
K_K1676  L_L11  L_L184  0.0022
K_K1677  L_L11  L_L185  0.0021
K_K1678  L_L11  L_L186  0.0020
K_K1679  L_L11  L_L187  0.0020
K_K1680  L_L11  L_L188  0.0019
K_K1681  L_L11  L_L189  0.0019
K_K1682  L_L11  L_L190  0.0018
K_K1683  L_L11  L_L191  0.0018
K_K1684  L_L11  L_L192  0.0018
K_K1685  L_L11  L_L193  0.0017
K_K1686  L_L11  L_L194  0.0017
K_K1687  L_L11  L_L195  0.0016
K_K1688  L_L11  L_L196  0.0016
K_K1689  L_L11  L_L197  0.0016
K_K1690  L_L11  L_L198  0.0015
K_K1691  L_L11  L_L199  0.0015
K_K1692  L_L11  L_L200  0.0015
K_K1693  L_L11  L_L201  0.0015
K_K1694  L_L11  L_L202  0.0014
K_K1695  L_L11  L_L203  0.0014
K_K1696  L_L11  L_L204  0.0014
K_K1697  L_L11  L_L205  0.0014
K_K1698  L_L11  L_L206  0.0013
K_K1699  L_L11  L_L207  0.0013
K_K1700  L_L11  L_L208  0.0013
K_K1701  L_L11  L_L209  0.0013
K_K1702  L_L11  L_L210  0.0012
K_K1703  L_L11  L_L211  0.0012
K_K1704  L_L11  L_L212  0.0012
K_K1705  L_L11  L_L213  0.0012
K_K1706  L_L11  L_L214  0.0012
K_K1707  L_L11  L_L215  0.0011
K_K1708  L_L11  L_L216  0.0011
K_K1709  L_L11  L_L217  0.0011
K_K1710  L_L11  L_L218  0.0011
K_K1711  L_L11  L_L219  0.0011
K_K1712  L_L11  L_L220  0.0011
K_K1713  L_L11  L_L221  0.0011
K_K1714  L_L11  L_L222  0.0010
K_K1715  L_L11  L_L223  0.0010
K_K1716  L_L11  L_L224  0.0010
* *  Branch  NTMP0000000011 - NTMP0000000012
R_R12  NTMP0000000011  nU_12  32.914993m  TC=0,0
V_Ui12  nU_12  nR_12  STIMULUS=U_IND_0000000012
R_V23  nR_12  nV_23  23.280268m  TC=0,0
L_V23  nR_12  nV_23  0.014646uH
R_V24  nV_23  nV_24  7.852787m  TC=0,0
L_V24  nV_23  nV_24  0.073723uH
L_L12  nV_24  NTMP0000000012  6.519695uH
K_K1717  L_L12  L_L13  0.1050
K_K1718  L_L12  L_L14  0.0397
K_K1719  L_L12  L_L15  0.0258
K_K1720  L_L12  L_L16  0.0192
K_K1721  L_L12  L_L17  0.0153
K_K1722  L_L12  L_L18  0.0127
K_K1723  L_L12  L_L19  0.0109
K_K1724  L_L12  L_L20  0.0095
K_K1725  L_L12  L_L21  0.0084
K_K1726  L_L12  L_L22  0.0076
K_K1727  L_L12  L_L23  0.0069
K_K1728  L_L12  L_L24  0.0063
K_K1729  L_L12  L_L25  0.0058
K_K1730  L_L12  L_L26  0.0054
K_K1731  L_L12  L_L27  0.0051
K_K1732  L_L12  L_L28  0.0047
K_K1733  L_L12  L_L29  0.0045
K_K1734  L_L12  L_L30  0.0042
K_K1735  L_L12  L_L31  0.0040
K_K1736  L_L12  L_L32  0.0038
K_K1737  L_L12  L_L33  0.0036
K_K1738  L_L12  L_L34  0.0034
K_K1739  L_L12  L_L35  0.0033
K_K1740  L_L12  L_L36  0.0032
K_K1741  L_L12  L_L37  0.0030
K_K1742  L_L12  L_L38  0.0029
K_K1743  L_L12  L_L39  0.0028
K_K1744  L_L12  L_L40  0.0027
K_K1745  L_L12  L_L41  0.0026
K_K1746  L_L12  L_L42  0.0025
K_K1747  L_L12  L_L43  0.0024
K_K1748  L_L12  L_L44  0.0024
K_K1749  L_L12  L_L45  0.0023
K_K1750  L_L12  L_L46  0.0022
K_K1751  L_L12  L_L47  0.0022
K_K1752  L_L12  L_L48  0.0021
K_K1753  L_L12  L_L49  0.0020
K_K1754  L_L12  L_L50  0.0020
K_K1755  L_L12  L_L51  0.0019
K_K1756  L_L12  L_L52  0.0019
K_K1757  L_L12  L_L53  0.0019
K_K1758  L_L12  L_L54  0.0018
K_K1759  L_L12  L_L55  0.0018
K_K1760  L_L12  L_L56  0.0017
K_K1761  L_L12  L_L57  0.0017
K_K1762  L_L12  L_L58  0.0017
K_K1763  L_L12  L_L59  0.0016
K_K1764  L_L12  L_L60  0.0016
K_K1765  L_L12  L_L61  0.0015
K_K1766  L_L12  L_L62  0.0015
K_K1767  L_L12  L_L63  0.0015
K_K1768  L_L12  L_L64  0.0015
K_K1769  L_L12  L_L65  0.0014
K_K1770  L_L12  L_L66  0.0014
K_K1771  L_L12  L_L67  0.0014
K_K1772  L_L12  L_L68  0.0014
K_K1773  L_L12  L_L69  0.0013
K_K1774  L_L12  L_L70  0.0013
K_K1775  L_L12  L_L71  0.0013
K_K1776  L_L12  L_L72  0.0013
K_K1777  L_L12  L_L73  0.0013
K_K1778  L_L12  L_L74  0.0012
K_K1779  L_L12  L_L75  0.0012
K_K1780  L_L12  L_L76  0.0012
K_K1781  L_L12  L_L77  0.0012
K_K1782  L_L12  L_L78  0.0011
K_K1783  L_L12  L_L79  0.0011
K_K1784  L_L12  L_L80  0.0011
K_K1785  L_L12  L_L81  0.0011
K_K1786  L_L12  L_L82  0.0011
K_K1787  L_L12  L_L83  0.0011
K_K1788  L_L12  L_L84  0.0011
K_K1789  L_L12  L_L85  0.0010
K_K1790  L_L12  L_L86  0.0010
K_K1791  L_L12  L_L87  0.0010
K_K1792  L_L12  L_L139  0.0069
K_K1793  L_L12  L_L140  0.0076
K_K1794  L_L12  L_L141  0.0084
K_K1795  L_L12  L_L142  0.0095
K_K1796  L_L12  L_L143  0.0109
K_K1797  L_L12  L_L144  0.0127
K_K1798  L_L12  L_L145  0.0152
K_K1799  L_L12  L_L146  0.0191
K_K1800  L_L12  L_L147  0.0256
K_K1801  L_L12  L_L148  0.0389
K_K1802  L_L12  L_L149  0.0812
K_K1803  L_L12  L_L150  0.1569
K_K1804  L_L12  L_L151  0.0812
K_K1805  L_L12  L_L152  0.0389
K_K1806  L_L12  L_L153  0.0256
K_K1807  L_L12  L_L154  0.0191
K_K1808  L_L12  L_L155  0.0152
K_K1809  L_L12  L_L156  0.0127
K_K1810  L_L12  L_L157  0.0109
K_K1811  L_L12  L_L158  0.0095
K_K1812  L_L12  L_L159  0.0084
K_K1813  L_L12  L_L160  0.0076
K_K1814  L_L12  L_L161  0.0069
K_K1815  L_L12  L_L162  0.0063
K_K1816  L_L12  L_L163  0.0058
K_K1817  L_L12  L_L164  0.0054
K_K1818  L_L12  L_L165  0.0051
K_K1819  L_L12  L_L166  0.0047
K_K1820  L_L12  L_L167  0.0045
K_K1821  L_L12  L_L168  0.0042
K_K1822  L_L12  L_L169  0.0040
K_K1823  L_L12  L_L170  0.0038
K_K1824  L_L12  L_L171  0.0036
K_K1825  L_L12  L_L172  0.0034
K_K1826  L_L12  L_L173  0.0033
K_K1827  L_L12  L_L174  0.0032
K_K1828  L_L12  L_L175  0.0030
K_K1829  L_L12  L_L176  0.0029
K_K1830  L_L12  L_L177  0.0028
K_K1831  L_L12  L_L178  0.0027
K_K1832  L_L12  L_L179  0.0026
K_K1833  L_L12  L_L180  0.0025
K_K1834  L_L12  L_L181  0.0024
K_K1835  L_L12  L_L182  0.0024
K_K1836  L_L12  L_L183  0.0023
K_K1837  L_L12  L_L184  0.0022
K_K1838  L_L12  L_L185  0.0022
K_K1839  L_L12  L_L186  0.0021
K_K1840  L_L12  L_L187  0.0020
K_K1841  L_L12  L_L188  0.0020
K_K1842  L_L12  L_L189  0.0019
K_K1843  L_L12  L_L190  0.0019
K_K1844  L_L12  L_L191  0.0018
K_K1845  L_L12  L_L192  0.0018
K_K1846  L_L12  L_L193  0.0018
K_K1847  L_L12  L_L194  0.0017
K_K1848  L_L12  L_L195  0.0017
K_K1849  L_L12  L_L196  0.0016
K_K1850  L_L12  L_L197  0.0016
K_K1851  L_L12  L_L198  0.0016
K_K1852  L_L12  L_L199  0.0015
K_K1853  L_L12  L_L200  0.0015
K_K1854  L_L12  L_L201  0.0015
K_K1855  L_L12  L_L202  0.0015
K_K1856  L_L12  L_L203  0.0014
K_K1857  L_L12  L_L204  0.0014
K_K1858  L_L12  L_L205  0.0014
K_K1859  L_L12  L_L206  0.0014
K_K1860  L_L12  L_L207  0.0013
K_K1861  L_L12  L_L208  0.0013
K_K1862  L_L12  L_L209  0.0013
K_K1863  L_L12  L_L210  0.0013
K_K1864  L_L12  L_L211  0.0012
K_K1865  L_L12  L_L212  0.0012
K_K1866  L_L12  L_L213  0.0012
K_K1867  L_L12  L_L214  0.0012
K_K1868  L_L12  L_L215  0.0012
K_K1869  L_L12  L_L216  0.0011
K_K1870  L_L12  L_L217  0.0011
K_K1871  L_L12  L_L218  0.0011
K_K1872  L_L12  L_L219  0.0011
K_K1873  L_L12  L_L220  0.0011
K_K1874  L_L12  L_L221  0.0011
K_K1875  L_L12  L_L222  0.0011
K_K1876  L_L12  L_L223  0.0010
K_K1877  L_L12  L_L224  0.0010
K_K1878  L_L12  L_L225  0.0010
* *  Branch  NTMP0000000012 - NTMP0000000013
R_R13  NTMP0000000012  nU_13  32.914993m  TC=0,0
V_Ui13  nU_13  nR_13  STIMULUS=U_IND_0000000013
R_V25  nR_13  nV_25  23.280268m  TC=0,0
L_V25  nR_13  nV_25  0.014646uH
R_V26  nV_25  nV_26  7.852787m  TC=0,0
L_V26  nV_25  nV_26  0.073723uH
L_L13  nV_26  NTMP0000000013  6.519695uH
K_K1879  L_L13  L_L14  0.1050
K_K1880  L_L13  L_L15  0.0397
K_K1881  L_L13  L_L16  0.0258
K_K1882  L_L13  L_L17  0.0192
K_K1883  L_L13  L_L18  0.0153
K_K1884  L_L13  L_L19  0.0127
K_K1885  L_L13  L_L20  0.0109
K_K1886  L_L13  L_L21  0.0095
K_K1887  L_L13  L_L22  0.0084
K_K1888  L_L13  L_L23  0.0076
K_K1889  L_L13  L_L24  0.0069
K_K1890  L_L13  L_L25  0.0063
K_K1891  L_L13  L_L26  0.0058
K_K1892  L_L13  L_L27  0.0054
K_K1893  L_L13  L_L28  0.0051
K_K1894  L_L13  L_L29  0.0047
K_K1895  L_L13  L_L30  0.0045
K_K1896  L_L13  L_L31  0.0042
K_K1897  L_L13  L_L32  0.0040
K_K1898  L_L13  L_L33  0.0038
K_K1899  L_L13  L_L34  0.0036
K_K1900  L_L13  L_L35  0.0034
K_K1901  L_L13  L_L36  0.0033
K_K1902  L_L13  L_L37  0.0032
K_K1903  L_L13  L_L38  0.0030
K_K1904  L_L13  L_L39  0.0029
K_K1905  L_L13  L_L40  0.0028
K_K1906  L_L13  L_L41  0.0027
K_K1907  L_L13  L_L42  0.0026
K_K1908  L_L13  L_L43  0.0025
K_K1909  L_L13  L_L44  0.0024
K_K1910  L_L13  L_L45  0.0024
K_K1911  L_L13  L_L46  0.0023
K_K1912  L_L13  L_L47  0.0022
K_K1913  L_L13  L_L48  0.0022
K_K1914  L_L13  L_L49  0.0021
K_K1915  L_L13  L_L50  0.0020
K_K1916  L_L13  L_L51  0.0020
K_K1917  L_L13  L_L52  0.0019
K_K1918  L_L13  L_L53  0.0019
K_K1919  L_L13  L_L54  0.0019
K_K1920  L_L13  L_L55  0.0018
K_K1921  L_L13  L_L56  0.0018
K_K1922  L_L13  L_L57  0.0017
K_K1923  L_L13  L_L58  0.0017
K_K1924  L_L13  L_L59  0.0017
K_K1925  L_L13  L_L60  0.0016
K_K1926  L_L13  L_L61  0.0016
K_K1927  L_L13  L_L62  0.0015
K_K1928  L_L13  L_L63  0.0015
K_K1929  L_L13  L_L64  0.0015
K_K1930  L_L13  L_L65  0.0015
K_K1931  L_L13  L_L66  0.0014
K_K1932  L_L13  L_L67  0.0014
K_K1933  L_L13  L_L68  0.0014
K_K1934  L_L13  L_L69  0.0014
K_K1935  L_L13  L_L70  0.0013
K_K1936  L_L13  L_L71  0.0013
K_K1937  L_L13  L_L72  0.0013
K_K1938  L_L13  L_L73  0.0013
K_K1939  L_L13  L_L74  0.0013
K_K1940  L_L13  L_L75  0.0012
K_K1941  L_L13  L_L76  0.0012
K_K1942  L_L13  L_L77  0.0012
K_K1943  L_L13  L_L78  0.0012
K_K1944  L_L13  L_L79  0.0011
K_K1945  L_L13  L_L80  0.0011
K_K1946  L_L13  L_L81  0.0011
K_K1947  L_L13  L_L82  0.0011
K_K1948  L_L13  L_L83  0.0011
K_K1949  L_L13  L_L84  0.0011
K_K1950  L_L13  L_L85  0.0011
K_K1951  L_L13  L_L86  0.0010
K_K1952  L_L13  L_L87  0.0010
K_K1953  L_L13  L_L88  0.0010
K_K1954  L_L13  L_L139  0.0063
K_K1955  L_L13  L_L140  0.0069
K_K1956  L_L13  L_L141  0.0076
K_K1957  L_L13  L_L142  0.0084
K_K1958  L_L13  L_L143  0.0095
K_K1959  L_L13  L_L144  0.0109
K_K1960  L_L13  L_L145  0.0127
K_K1961  L_L13  L_L146  0.0152
K_K1962  L_L13  L_L147  0.0191
K_K1963  L_L13  L_L148  0.0256
K_K1964  L_L13  L_L149  0.0389
K_K1965  L_L13  L_L150  0.0812
K_K1966  L_L13  L_L151  0.1569
K_K1967  L_L13  L_L152  0.0812
K_K1968  L_L13  L_L153  0.0389
K_K1969  L_L13  L_L154  0.0256
K_K1970  L_L13  L_L155  0.0191
K_K1971  L_L13  L_L156  0.0152
K_K1972  L_L13  L_L157  0.0127
K_K1973  L_L13  L_L158  0.0109
K_K1974  L_L13  L_L159  0.0095
K_K1975  L_L13  L_L160  0.0084
K_K1976  L_L13  L_L161  0.0076
K_K1977  L_L13  L_L162  0.0069
K_K1978  L_L13  L_L163  0.0063
K_K1979  L_L13  L_L164  0.0058
K_K1980  L_L13  L_L165  0.0054
K_K1981  L_L13  L_L166  0.0051
K_K1982  L_L13  L_L167  0.0047
K_K1983  L_L13  L_L168  0.0045
K_K1984  L_L13  L_L169  0.0042
K_K1985  L_L13  L_L170  0.0040
K_K1986  L_L13  L_L171  0.0038
K_K1987  L_L13  L_L172  0.0036
K_K1988  L_L13  L_L173  0.0034
K_K1989  L_L13  L_L174  0.0033
K_K1990  L_L13  L_L175  0.0032
K_K1991  L_L13  L_L176  0.0030
K_K1992  L_L13  L_L177  0.0029
K_K1993  L_L13  L_L178  0.0028
K_K1994  L_L13  L_L179  0.0027
K_K1995  L_L13  L_L180  0.0026
K_K1996  L_L13  L_L181  0.0025
K_K1997  L_L13  L_L182  0.0024
K_K1998  L_L13  L_L183  0.0024
K_K1999  L_L13  L_L184  0.0023
K_K2000  L_L13  L_L185  0.0022
K_K2001  L_L13  L_L186  0.0022
K_K2002  L_L13  L_L187  0.0021
K_K2003  L_L13  L_L188  0.0020
K_K2004  L_L13  L_L189  0.0020
K_K2005  L_L13  L_L190  0.0019
K_K2006  L_L13  L_L191  0.0019
K_K2007  L_L13  L_L192  0.0018
K_K2008  L_L13  L_L193  0.0018
K_K2009  L_L13  L_L194  0.0018
K_K2010  L_L13  L_L195  0.0017
K_K2011  L_L13  L_L196  0.0017
K_K2012  L_L13  L_L197  0.0016
K_K2013  L_L13  L_L198  0.0016
K_K2014  L_L13  L_L199  0.0016
K_K2015  L_L13  L_L200  0.0015
K_K2016  L_L13  L_L201  0.0015
K_K2017  L_L13  L_L202  0.0015
K_K2018  L_L13  L_L203  0.0015
K_K2019  L_L13  L_L204  0.0014
K_K2020  L_L13  L_L205  0.0014
K_K2021  L_L13  L_L206  0.0014
K_K2022  L_L13  L_L207  0.0014
K_K2023  L_L13  L_L208  0.0013
K_K2024  L_L13  L_L209  0.0013
K_K2025  L_L13  L_L210  0.0013
K_K2026  L_L13  L_L211  0.0013
K_K2027  L_L13  L_L212  0.0012
K_K2028  L_L13  L_L213  0.0012
K_K2029  L_L13  L_L214  0.0012
K_K2030  L_L13  L_L215  0.0012
K_K2031  L_L13  L_L216  0.0012
K_K2032  L_L13  L_L217  0.0011
K_K2033  L_L13  L_L218  0.0011
K_K2034  L_L13  L_L219  0.0011
K_K2035  L_L13  L_L220  0.0011
K_K2036  L_L13  L_L221  0.0011
K_K2037  L_L13  L_L222  0.0011
K_K2038  L_L13  L_L223  0.0011
K_K2039  L_L13  L_L224  0.0010
K_K2040  L_L13  L_L225  0.0010
K_K2041  L_L13  L_L226  0.0010
* *  Branch  NTMP0000000013 - NTMP0000000014
R_R14  NTMP0000000013  nU_14  32.914993m  TC=0,0
V_Ui14  nU_14  nR_14  STIMULUS=U_IND_0000000014
R_V27  nR_14  nV_27  23.280268m  TC=0,0
L_V27  nR_14  nV_27  0.014646uH
R_V28  nV_27  nV_28  7.852787m  TC=0,0
L_V28  nV_27  nV_28  0.073723uH
L_L14  nV_28  NTMP0000000014  6.519695uH
K_K2042  L_L14  L_L15  0.1050
K_K2043  L_L14  L_L16  0.0397
K_K2044  L_L14  L_L17  0.0258
K_K2045  L_L14  L_L18  0.0192
K_K2046  L_L14  L_L19  0.0153
K_K2047  L_L14  L_L20  0.0127
K_K2048  L_L14  L_L21  0.0109
K_K2049  L_L14  L_L22  0.0095
K_K2050  L_L14  L_L23  0.0084
K_K2051  L_L14  L_L24  0.0076
K_K2052  L_L14  L_L25  0.0069
K_K2053  L_L14  L_L26  0.0063
K_K2054  L_L14  L_L27  0.0058
K_K2055  L_L14  L_L28  0.0054
K_K2056  L_L14  L_L29  0.0051
K_K2057  L_L14  L_L30  0.0047
K_K2058  L_L14  L_L31  0.0045
K_K2059  L_L14  L_L32  0.0042
K_K2060  L_L14  L_L33  0.0040
K_K2061  L_L14  L_L34  0.0038
K_K2062  L_L14  L_L35  0.0036
K_K2063  L_L14  L_L36  0.0034
K_K2064  L_L14  L_L37  0.0033
K_K2065  L_L14  L_L38  0.0032
K_K2066  L_L14  L_L39  0.0030
K_K2067  L_L14  L_L40  0.0029
K_K2068  L_L14  L_L41  0.0028
K_K2069  L_L14  L_L42  0.0027
K_K2070  L_L14  L_L43  0.0026
K_K2071  L_L14  L_L44  0.0025
K_K2072  L_L14  L_L45  0.0024
K_K2073  L_L14  L_L46  0.0024
K_K2074  L_L14  L_L47  0.0023
K_K2075  L_L14  L_L48  0.0022
K_K2076  L_L14  L_L49  0.0022
K_K2077  L_L14  L_L50  0.0021
K_K2078  L_L14  L_L51  0.0020
K_K2079  L_L14  L_L52  0.0020
K_K2080  L_L14  L_L53  0.0019
K_K2081  L_L14  L_L54  0.0019
K_K2082  L_L14  L_L55  0.0019
K_K2083  L_L14  L_L56  0.0018
K_K2084  L_L14  L_L57  0.0018
K_K2085  L_L14  L_L58  0.0017
K_K2086  L_L14  L_L59  0.0017
K_K2087  L_L14  L_L60  0.0017
K_K2088  L_L14  L_L61  0.0016
K_K2089  L_L14  L_L62  0.0016
K_K2090  L_L14  L_L63  0.0015
K_K2091  L_L14  L_L64  0.0015
K_K2092  L_L14  L_L65  0.0015
K_K2093  L_L14  L_L66  0.0015
K_K2094  L_L14  L_L67  0.0014
K_K2095  L_L14  L_L68  0.0014
K_K2096  L_L14  L_L69  0.0014
K_K2097  L_L14  L_L70  0.0014
K_K2098  L_L14  L_L71  0.0013
K_K2099  L_L14  L_L72  0.0013
K_K2100  L_L14  L_L73  0.0013
K_K2101  L_L14  L_L74  0.0013
K_K2102  L_L14  L_L75  0.0013
K_K2103  L_L14  L_L76  0.0012
K_K2104  L_L14  L_L77  0.0012
K_K2105  L_L14  L_L78  0.0012
K_K2106  L_L14  L_L79  0.0012
K_K2107  L_L14  L_L80  0.0011
K_K2108  L_L14  L_L81  0.0011
K_K2109  L_L14  L_L82  0.0011
K_K2110  L_L14  L_L83  0.0011
K_K2111  L_L14  L_L84  0.0011
K_K2112  L_L14  L_L85  0.0011
K_K2113  L_L14  L_L86  0.0011
K_K2114  L_L14  L_L87  0.0010
K_K2115  L_L14  L_L88  0.0010
K_K2116  L_L14  L_L89  0.0010
K_K2117  L_L14  L_L139  0.0058
K_K2118  L_L14  L_L140  0.0063
K_K2119  L_L14  L_L141  0.0069
K_K2120  L_L14  L_L142  0.0076
K_K2121  L_L14  L_L143  0.0084
K_K2122  L_L14  L_L144  0.0095
K_K2123  L_L14  L_L145  0.0109
K_K2124  L_L14  L_L146  0.0127
K_K2125  L_L14  L_L147  0.0152
K_K2126  L_L14  L_L148  0.0191
K_K2127  L_L14  L_L149  0.0256
K_K2128  L_L14  L_L150  0.0389
K_K2129  L_L14  L_L151  0.0812
K_K2130  L_L14  L_L152  0.1569
K_K2131  L_L14  L_L153  0.0812
K_K2132  L_L14  L_L154  0.0389
K_K2133  L_L14  L_L155  0.0256
K_K2134  L_L14  L_L156  0.0191
K_K2135  L_L14  L_L157  0.0152
K_K2136  L_L14  L_L158  0.0127
K_K2137  L_L14  L_L159  0.0109
K_K2138  L_L14  L_L160  0.0095
K_K2139  L_L14  L_L161  0.0084
K_K2140  L_L14  L_L162  0.0076
K_K2141  L_L14  L_L163  0.0069
K_K2142  L_L14  L_L164  0.0063
K_K2143  L_L14  L_L165  0.0058
K_K2144  L_L14  L_L166  0.0054
K_K2145  L_L14  L_L167  0.0051
K_K2146  L_L14  L_L168  0.0047
K_K2147  L_L14  L_L169  0.0045
K_K2148  L_L14  L_L170  0.0042
K_K2149  L_L14  L_L171  0.0040
K_K2150  L_L14  L_L172  0.0038
K_K2151  L_L14  L_L173  0.0036
K_K2152  L_L14  L_L174  0.0034
K_K2153  L_L14  L_L175  0.0033
K_K2154  L_L14  L_L176  0.0032
K_K2155  L_L14  L_L177  0.0030
K_K2156  L_L14  L_L178  0.0029
K_K2157  L_L14  L_L179  0.0028
K_K2158  L_L14  L_L180  0.0027
K_K2159  L_L14  L_L181  0.0026
K_K2160  L_L14  L_L182  0.0025
K_K2161  L_L14  L_L183  0.0024
K_K2162  L_L14  L_L184  0.0024
K_K2163  L_L14  L_L185  0.0023
K_K2164  L_L14  L_L186  0.0022
K_K2165  L_L14  L_L187  0.0022
K_K2166  L_L14  L_L188  0.0021
K_K2167  L_L14  L_L189  0.0020
K_K2168  L_L14  L_L190  0.0020
K_K2169  L_L14  L_L191  0.0019
K_K2170  L_L14  L_L192  0.0019
K_K2171  L_L14  L_L193  0.0018
K_K2172  L_L14  L_L194  0.0018
K_K2173  L_L14  L_L195  0.0018
K_K2174  L_L14  L_L196  0.0017
K_K2175  L_L14  L_L197  0.0017
K_K2176  L_L14  L_L198  0.0016
K_K2177  L_L14  L_L199  0.0016
K_K2178  L_L14  L_L200  0.0016
K_K2179  L_L14  L_L201  0.0015
K_K2180  L_L14  L_L202  0.0015
K_K2181  L_L14  L_L203  0.0015
K_K2182  L_L14  L_L204  0.0015
K_K2183  L_L14  L_L205  0.0014
K_K2184  L_L14  L_L206  0.0014
K_K2185  L_L14  L_L207  0.0014
K_K2186  L_L14  L_L208  0.0014
K_K2187  L_L14  L_L209  0.0013
K_K2188  L_L14  L_L210  0.0013
K_K2189  L_L14  L_L211  0.0013
K_K2190  L_L14  L_L212  0.0013
K_K2191  L_L14  L_L213  0.0012
K_K2192  L_L14  L_L214  0.0012
K_K2193  L_L14  L_L215  0.0012
K_K2194  L_L14  L_L216  0.0012
K_K2195  L_L14  L_L217  0.0012
K_K2196  L_L14  L_L218  0.0011
K_K2197  L_L14  L_L219  0.0011
K_K2198  L_L14  L_L220  0.0011
K_K2199  L_L14  L_L221  0.0011
K_K2200  L_L14  L_L222  0.0011
K_K2201  L_L14  L_L223  0.0011
K_K2202  L_L14  L_L224  0.0011
K_K2203  L_L14  L_L225  0.0010
K_K2204  L_L14  L_L226  0.0010
K_K2205  L_L14  L_L227  0.0010
* *  Branch  NTMP0000000014 - NTMP0000000015
R_R15  NTMP0000000014  nU_15  32.914993m  TC=0,0
V_Ui15  nU_15  nR_15  STIMULUS=U_IND_0000000015
R_V29  nR_15  nV_29  23.280268m  TC=0,0
L_V29  nR_15  nV_29  0.014646uH
R_V30  nV_29  nV_30  7.852787m  TC=0,0
L_V30  nV_29  nV_30  0.073723uH
L_L15  nV_30  NTMP0000000015  6.519695uH
K_K2206  L_L15  L_L16  0.1050
K_K2207  L_L15  L_L17  0.0397
K_K2208  L_L15  L_L18  0.0258
K_K2209  L_L15  L_L19  0.0192
K_K2210  L_L15  L_L20  0.0153
K_K2211  L_L15  L_L21  0.0127
K_K2212  L_L15  L_L22  0.0109
K_K2213  L_L15  L_L23  0.0095
K_K2214  L_L15  L_L24  0.0084
K_K2215  L_L15  L_L25  0.0076
K_K2216  L_L15  L_L26  0.0069
K_K2217  L_L15  L_L27  0.0063
K_K2218  L_L15  L_L28  0.0058
K_K2219  L_L15  L_L29  0.0054
K_K2220  L_L15  L_L30  0.0051
K_K2221  L_L15  L_L31  0.0047
K_K2222  L_L15  L_L32  0.0045
K_K2223  L_L15  L_L33  0.0042
K_K2224  L_L15  L_L34  0.0040
K_K2225  L_L15  L_L35  0.0038
K_K2226  L_L15  L_L36  0.0036
K_K2227  L_L15  L_L37  0.0034
K_K2228  L_L15  L_L38  0.0033
K_K2229  L_L15  L_L39  0.0032
K_K2230  L_L15  L_L40  0.0030
K_K2231  L_L15  L_L41  0.0029
K_K2232  L_L15  L_L42  0.0028
K_K2233  L_L15  L_L43  0.0027
K_K2234  L_L15  L_L44  0.0026
K_K2235  L_L15  L_L45  0.0025
K_K2236  L_L15  L_L46  0.0024
K_K2237  L_L15  L_L47  0.0024
K_K2238  L_L15  L_L48  0.0023
K_K2239  L_L15  L_L49  0.0022
K_K2240  L_L15  L_L50  0.0022
K_K2241  L_L15  L_L51  0.0021
K_K2242  L_L15  L_L52  0.0020
K_K2243  L_L15  L_L53  0.0020
K_K2244  L_L15  L_L54  0.0019
K_K2245  L_L15  L_L55  0.0019
K_K2246  L_L15  L_L56  0.0019
K_K2247  L_L15  L_L57  0.0018
K_K2248  L_L15  L_L58  0.0018
K_K2249  L_L15  L_L59  0.0017
K_K2250  L_L15  L_L60  0.0017
K_K2251  L_L15  L_L61  0.0017
K_K2252  L_L15  L_L62  0.0016
K_K2253  L_L15  L_L63  0.0016
K_K2254  L_L15  L_L64  0.0015
K_K2255  L_L15  L_L65  0.0015
K_K2256  L_L15  L_L66  0.0015
K_K2257  L_L15  L_L67  0.0015
K_K2258  L_L15  L_L68  0.0014
K_K2259  L_L15  L_L69  0.0014
K_K2260  L_L15  L_L70  0.0014
K_K2261  L_L15  L_L71  0.0014
K_K2262  L_L15  L_L72  0.0013
K_K2263  L_L15  L_L73  0.0013
K_K2264  L_L15  L_L74  0.0013
K_K2265  L_L15  L_L75  0.0013
K_K2266  L_L15  L_L76  0.0013
K_K2267  L_L15  L_L77  0.0012
K_K2268  L_L15  L_L78  0.0012
K_K2269  L_L15  L_L79  0.0012
K_K2270  L_L15  L_L80  0.0012
K_K2271  L_L15  L_L81  0.0011
K_K2272  L_L15  L_L82  0.0011
K_K2273  L_L15  L_L83  0.0011
K_K2274  L_L15  L_L84  0.0011
K_K2275  L_L15  L_L85  0.0011
K_K2276  L_L15  L_L86  0.0011
K_K2277  L_L15  L_L87  0.0011
K_K2278  L_L15  L_L88  0.0010
K_K2279  L_L15  L_L89  0.0010
K_K2280  L_L15  L_L90  0.0010
K_K2281  L_L15  L_L139  0.0054
K_K2282  L_L15  L_L140  0.0058
K_K2283  L_L15  L_L141  0.0063
K_K2284  L_L15  L_L142  0.0069
K_K2285  L_L15  L_L143  0.0076
K_K2286  L_L15  L_L144  0.0084
K_K2287  L_L15  L_L145  0.0095
K_K2288  L_L15  L_L146  0.0109
K_K2289  L_L15  L_L147  0.0127
K_K2290  L_L15  L_L148  0.0152
K_K2291  L_L15  L_L149  0.0191
K_K2292  L_L15  L_L150  0.0256
K_K2293  L_L15  L_L151  0.0389
K_K2294  L_L15  L_L152  0.0812
K_K2295  L_L15  L_L153  0.1569
K_K2296  L_L15  L_L154  0.0812
K_K2297  L_L15  L_L155  0.0389
K_K2298  L_L15  L_L156  0.0256
K_K2299  L_L15  L_L157  0.0191
K_K2300  L_L15  L_L158  0.0152
K_K2301  L_L15  L_L159  0.0127
K_K2302  L_L15  L_L160  0.0109
K_K2303  L_L15  L_L161  0.0095
K_K2304  L_L15  L_L162  0.0084
K_K2305  L_L15  L_L163  0.0076
K_K2306  L_L15  L_L164  0.0069
K_K2307  L_L15  L_L165  0.0063
K_K2308  L_L15  L_L166  0.0058
K_K2309  L_L15  L_L167  0.0054
K_K2310  L_L15  L_L168  0.0051
K_K2311  L_L15  L_L169  0.0047
K_K2312  L_L15  L_L170  0.0045
K_K2313  L_L15  L_L171  0.0042
K_K2314  L_L15  L_L172  0.0040
K_K2315  L_L15  L_L173  0.0038
K_K2316  L_L15  L_L174  0.0036
K_K2317  L_L15  L_L175  0.0034
K_K2318  L_L15  L_L176  0.0033
K_K2319  L_L15  L_L177  0.0032
K_K2320  L_L15  L_L178  0.0030
K_K2321  L_L15  L_L179  0.0029
K_K2322  L_L15  L_L180  0.0028
K_K2323  L_L15  L_L181  0.0027
K_K2324  L_L15  L_L182  0.0026
K_K2325  L_L15  L_L183  0.0025
K_K2326  L_L15  L_L184  0.0024
K_K2327  L_L15  L_L185  0.0024
K_K2328  L_L15  L_L186  0.0023
K_K2329  L_L15  L_L187  0.0022
K_K2330  L_L15  L_L188  0.0022
K_K2331  L_L15  L_L189  0.0021
K_K2332  L_L15  L_L190  0.0020
K_K2333  L_L15  L_L191  0.0020
K_K2334  L_L15  L_L192  0.0019
K_K2335  L_L15  L_L193  0.0019
K_K2336  L_L15  L_L194  0.0018
K_K2337  L_L15  L_L195  0.0018
K_K2338  L_L15  L_L196  0.0018
K_K2339  L_L15  L_L197  0.0017
K_K2340  L_L15  L_L198  0.0017
K_K2341  L_L15  L_L199  0.0016
K_K2342  L_L15  L_L200  0.0016
K_K2343  L_L15  L_L201  0.0016
K_K2344  L_L15  L_L202  0.0015
K_K2345  L_L15  L_L203  0.0015
K_K2346  L_L15  L_L204  0.0015
K_K2347  L_L15  L_L205  0.0015
K_K2348  L_L15  L_L206  0.0014
K_K2349  L_L15  L_L207  0.0014
K_K2350  L_L15  L_L208  0.0014
K_K2351  L_L15  L_L209  0.0014
K_K2352  L_L15  L_L210  0.0013
K_K2353  L_L15  L_L211  0.0013
K_K2354  L_L15  L_L212  0.0013
K_K2355  L_L15  L_L213  0.0013
K_K2356  L_L15  L_L214  0.0012
K_K2357  L_L15  L_L215  0.0012
K_K2358  L_L15  L_L216  0.0012
K_K2359  L_L15  L_L217  0.0012
K_K2360  L_L15  L_L218  0.0012
K_K2361  L_L15  L_L219  0.0011
K_K2362  L_L15  L_L220  0.0011
K_K2363  L_L15  L_L221  0.0011
K_K2364  L_L15  L_L222  0.0011
K_K2365  L_L15  L_L223  0.0011
K_K2366  L_L15  L_L224  0.0011
K_K2367  L_L15  L_L225  0.0011
K_K2368  L_L15  L_L226  0.0010
K_K2369  L_L15  L_L227  0.0010
K_K2370  L_L15  L_L228  0.0010
* *  Branch  NTMP0000000015 - NTMP0000000016
R_R16  NTMP0000000015  nU_16  32.914993m  TC=0,0
V_Ui16  nU_16  nR_16  STIMULUS=U_IND_0000000016
R_V31  nR_16  nV_31  23.280268m  TC=0,0
L_V31  nR_16  nV_31  0.014646uH
R_V32  nV_31  nV_32  7.852787m  TC=0,0
L_V32  nV_31  nV_32  0.073723uH
L_L16  nV_32  NTMP0000000016  6.519695uH
K_K2371  L_L16  L_L17  0.1050
K_K2372  L_L16  L_L18  0.0397
K_K2373  L_L16  L_L19  0.0258
K_K2374  L_L16  L_L20  0.0192
K_K2375  L_L16  L_L21  0.0153
K_K2376  L_L16  L_L22  0.0127
K_K2377  L_L16  L_L23  0.0109
K_K2378  L_L16  L_L24  0.0095
K_K2379  L_L16  L_L25  0.0084
K_K2380  L_L16  L_L26  0.0076
K_K2381  L_L16  L_L27  0.0069
K_K2382  L_L16  L_L28  0.0063
K_K2383  L_L16  L_L29  0.0058
K_K2384  L_L16  L_L30  0.0054
K_K2385  L_L16  L_L31  0.0051
K_K2386  L_L16  L_L32  0.0047
K_K2387  L_L16  L_L33  0.0045
K_K2388  L_L16  L_L34  0.0042
K_K2389  L_L16  L_L35  0.0040
K_K2390  L_L16  L_L36  0.0038
K_K2391  L_L16  L_L37  0.0036
K_K2392  L_L16  L_L38  0.0034
K_K2393  L_L16  L_L39  0.0033
K_K2394  L_L16  L_L40  0.0032
K_K2395  L_L16  L_L41  0.0030
K_K2396  L_L16  L_L42  0.0029
K_K2397  L_L16  L_L43  0.0028
K_K2398  L_L16  L_L44  0.0027
K_K2399  L_L16  L_L45  0.0026
K_K2400  L_L16  L_L46  0.0025
K_K2401  L_L16  L_L47  0.0024
K_K2402  L_L16  L_L48  0.0024
K_K2403  L_L16  L_L49  0.0023
K_K2404  L_L16  L_L50  0.0022
K_K2405  L_L16  L_L51  0.0022
K_K2406  L_L16  L_L52  0.0021
K_K2407  L_L16  L_L53  0.0020
K_K2408  L_L16  L_L54  0.0020
K_K2409  L_L16  L_L55  0.0019
K_K2410  L_L16  L_L56  0.0019
K_K2411  L_L16  L_L57  0.0019
K_K2412  L_L16  L_L58  0.0018
K_K2413  L_L16  L_L59  0.0018
K_K2414  L_L16  L_L60  0.0017
K_K2415  L_L16  L_L61  0.0017
K_K2416  L_L16  L_L62  0.0017
K_K2417  L_L16  L_L63  0.0016
K_K2418  L_L16  L_L64  0.0016
K_K2419  L_L16  L_L65  0.0015
K_K2420  L_L16  L_L66  0.0015
K_K2421  L_L16  L_L67  0.0015
K_K2422  L_L16  L_L68  0.0015
K_K2423  L_L16  L_L69  0.0014
K_K2424  L_L16  L_L70  0.0014
K_K2425  L_L16  L_L71  0.0014
K_K2426  L_L16  L_L72  0.0014
K_K2427  L_L16  L_L73  0.0013
K_K2428  L_L16  L_L74  0.0013
K_K2429  L_L16  L_L75  0.0013
K_K2430  L_L16  L_L76  0.0013
K_K2431  L_L16  L_L77  0.0013
K_K2432  L_L16  L_L78  0.0012
K_K2433  L_L16  L_L79  0.0012
K_K2434  L_L16  L_L80  0.0012
K_K2435  L_L16  L_L81  0.0012
K_K2436  L_L16  L_L82  0.0011
K_K2437  L_L16  L_L83  0.0011
K_K2438  L_L16  L_L84  0.0011
K_K2439  L_L16  L_L85  0.0011
K_K2440  L_L16  L_L86  0.0011
K_K2441  L_L16  L_L87  0.0011
K_K2442  L_L16  L_L88  0.0011
K_K2443  L_L16  L_L89  0.0010
K_K2444  L_L16  L_L90  0.0010
K_K2445  L_L16  L_L91  0.0010
K_K2446  L_L16  L_L139  0.0051
K_K2447  L_L16  L_L140  0.0054
K_K2448  L_L16  L_L141  0.0058
K_K2449  L_L16  L_L142  0.0063
K_K2450  L_L16  L_L143  0.0069
K_K2451  L_L16  L_L144  0.0076
K_K2452  L_L16  L_L145  0.0084
K_K2453  L_L16  L_L146  0.0095
K_K2454  L_L16  L_L147  0.0109
K_K2455  L_L16  L_L148  0.0127
K_K2456  L_L16  L_L149  0.0152
K_K2457  L_L16  L_L150  0.0191
K_K2458  L_L16  L_L151  0.0256
K_K2459  L_L16  L_L152  0.0389
K_K2460  L_L16  L_L153  0.0812
K_K2461  L_L16  L_L154  0.1569
K_K2462  L_L16  L_L155  0.0812
K_K2463  L_L16  L_L156  0.0389
K_K2464  L_L16  L_L157  0.0256
K_K2465  L_L16  L_L158  0.0191
K_K2466  L_L16  L_L159  0.0152
K_K2467  L_L16  L_L160  0.0127
K_K2468  L_L16  L_L161  0.0109
K_K2469  L_L16  L_L162  0.0095
K_K2470  L_L16  L_L163  0.0084
K_K2471  L_L16  L_L164  0.0076
K_K2472  L_L16  L_L165  0.0069
K_K2473  L_L16  L_L166  0.0063
K_K2474  L_L16  L_L167  0.0058
K_K2475  L_L16  L_L168  0.0054
K_K2476  L_L16  L_L169  0.0051
K_K2477  L_L16  L_L170  0.0047
K_K2478  L_L16  L_L171  0.0045
K_K2479  L_L16  L_L172  0.0042
K_K2480  L_L16  L_L173  0.0040
K_K2481  L_L16  L_L174  0.0038
K_K2482  L_L16  L_L175  0.0036
K_K2483  L_L16  L_L176  0.0034
K_K2484  L_L16  L_L177  0.0033
K_K2485  L_L16  L_L178  0.0032
K_K2486  L_L16  L_L179  0.0030
K_K2487  L_L16  L_L180  0.0029
K_K2488  L_L16  L_L181  0.0028
K_K2489  L_L16  L_L182  0.0027
K_K2490  L_L16  L_L183  0.0026
K_K2491  L_L16  L_L184  0.0025
K_K2492  L_L16  L_L185  0.0024
K_K2493  L_L16  L_L186  0.0024
K_K2494  L_L16  L_L187  0.0023
K_K2495  L_L16  L_L188  0.0022
K_K2496  L_L16  L_L189  0.0022
K_K2497  L_L16  L_L190  0.0021
K_K2498  L_L16  L_L191  0.0020
K_K2499  L_L16  L_L192  0.0020
K_K2500  L_L16  L_L193  0.0019
K_K2501  L_L16  L_L194  0.0019
K_K2502  L_L16  L_L195  0.0018
K_K2503  L_L16  L_L196  0.0018
K_K2504  L_L16  L_L197  0.0018
K_K2505  L_L16  L_L198  0.0017
K_K2506  L_L16  L_L199  0.0017
K_K2507  L_L16  L_L200  0.0016
K_K2508  L_L16  L_L201  0.0016
K_K2509  L_L16  L_L202  0.0016
K_K2510  L_L16  L_L203  0.0015
K_K2511  L_L16  L_L204  0.0015
K_K2512  L_L16  L_L205  0.0015
K_K2513  L_L16  L_L206  0.0015
K_K2514  L_L16  L_L207  0.0014
K_K2515  L_L16  L_L208  0.0014
K_K2516  L_L16  L_L209  0.0014
K_K2517  L_L16  L_L210  0.0014
K_K2518  L_L16  L_L211  0.0013
K_K2519  L_L16  L_L212  0.0013
K_K2520  L_L16  L_L213  0.0013
K_K2521  L_L16  L_L214  0.0013
K_K2522  L_L16  L_L215  0.0012
K_K2523  L_L16  L_L216  0.0012
K_K2524  L_L16  L_L217  0.0012
K_K2525  L_L16  L_L218  0.0012
K_K2526  L_L16  L_L219  0.0012
K_K2527  L_L16  L_L220  0.0011
K_K2528  L_L16  L_L221  0.0011
K_K2529  L_L16  L_L222  0.0011
K_K2530  L_L16  L_L223  0.0011
K_K2531  L_L16  L_L224  0.0011
K_K2532  L_L16  L_L225  0.0011
K_K2533  L_L16  L_L226  0.0011
K_K2534  L_L16  L_L227  0.0010
K_K2535  L_L16  L_L228  0.0010
K_K2536  L_L16  L_L229  0.0010
* *  Branch  NTMP0000000016 - NTMP0000000017
R_R17  NTMP0000000016  nU_17  32.914993m  TC=0,0
V_Ui17  nU_17  nR_17  STIMULUS=U_IND_0000000017
R_V33  nR_17  nV_33  23.280268m  TC=0,0
L_V33  nR_17  nV_33  0.014646uH
R_V34  nV_33  nV_34  7.852787m  TC=0,0
L_V34  nV_33  nV_34  0.073723uH
L_L17  nV_34  NTMP0000000017  6.519695uH
K_K2537  L_L17  L_L18  0.1050
K_K2538  L_L17  L_L19  0.0397
K_K2539  L_L17  L_L20  0.0258
K_K2540  L_L17  L_L21  0.0192
K_K2541  L_L17  L_L22  0.0153
K_K2542  L_L17  L_L23  0.0127
K_K2543  L_L17  L_L24  0.0109
K_K2544  L_L17  L_L25  0.0095
K_K2545  L_L17  L_L26  0.0084
K_K2546  L_L17  L_L27  0.0076
K_K2547  L_L17  L_L28  0.0069
K_K2548  L_L17  L_L29  0.0063
K_K2549  L_L17  L_L30  0.0058
K_K2550  L_L17  L_L31  0.0054
K_K2551  L_L17  L_L32  0.0051
K_K2552  L_L17  L_L33  0.0047
K_K2553  L_L17  L_L34  0.0045
K_K2554  L_L17  L_L35  0.0042
K_K2555  L_L17  L_L36  0.0040
K_K2556  L_L17  L_L37  0.0038
K_K2557  L_L17  L_L38  0.0036
K_K2558  L_L17  L_L39  0.0034
K_K2559  L_L17  L_L40  0.0033
K_K2560  L_L17  L_L41  0.0032
K_K2561  L_L17  L_L42  0.0030
K_K2562  L_L17  L_L43  0.0029
K_K2563  L_L17  L_L44  0.0028
K_K2564  L_L17  L_L45  0.0027
K_K2565  L_L17  L_L46  0.0026
K_K2566  L_L17  L_L47  0.0025
K_K2567  L_L17  L_L48  0.0024
K_K2568  L_L17  L_L49  0.0024
K_K2569  L_L17  L_L50  0.0023
K_K2570  L_L17  L_L51  0.0022
K_K2571  L_L17  L_L52  0.0022
K_K2572  L_L17  L_L53  0.0021
K_K2573  L_L17  L_L54  0.0020
K_K2574  L_L17  L_L55  0.0020
K_K2575  L_L17  L_L56  0.0019
K_K2576  L_L17  L_L57  0.0019
K_K2577  L_L17  L_L58  0.0019
K_K2578  L_L17  L_L59  0.0018
K_K2579  L_L17  L_L60  0.0018
K_K2580  L_L17  L_L61  0.0017
K_K2581  L_L17  L_L62  0.0017
K_K2582  L_L17  L_L63  0.0017
K_K2583  L_L17  L_L64  0.0016
K_K2584  L_L17  L_L65  0.0016
K_K2585  L_L17  L_L66  0.0015
K_K2586  L_L17  L_L67  0.0015
K_K2587  L_L17  L_L68  0.0015
K_K2588  L_L17  L_L69  0.0015
K_K2589  L_L17  L_L70  0.0014
K_K2590  L_L17  L_L71  0.0014
K_K2591  L_L17  L_L72  0.0014
K_K2592  L_L17  L_L73  0.0014
K_K2593  L_L17  L_L74  0.0013
K_K2594  L_L17  L_L75  0.0013
K_K2595  L_L17  L_L76  0.0013
K_K2596  L_L17  L_L77  0.0013
K_K2597  L_L17  L_L78  0.0013
K_K2598  L_L17  L_L79  0.0012
K_K2599  L_L17  L_L80  0.0012
K_K2600  L_L17  L_L81  0.0012
K_K2601  L_L17  L_L82  0.0012
K_K2602  L_L17  L_L83  0.0011
K_K2603  L_L17  L_L84  0.0011
K_K2604  L_L17  L_L85  0.0011
K_K2605  L_L17  L_L86  0.0011
K_K2606  L_L17  L_L87  0.0011
K_K2607  L_L17  L_L88  0.0011
K_K2608  L_L17  L_L89  0.0011
K_K2609  L_L17  L_L90  0.0010
K_K2610  L_L17  L_L91  0.0010
K_K2611  L_L17  L_L92  0.0010
K_K2612  L_L17  L_L139  0.0047
K_K2613  L_L17  L_L140  0.0051
K_K2614  L_L17  L_L141  0.0054
K_K2615  L_L17  L_L142  0.0058
K_K2616  L_L17  L_L143  0.0063
K_K2617  L_L17  L_L144  0.0069
K_K2618  L_L17  L_L145  0.0076
K_K2619  L_L17  L_L146  0.0084
K_K2620  L_L17  L_L147  0.0095
K_K2621  L_L17  L_L148  0.0109
K_K2622  L_L17  L_L149  0.0127
K_K2623  L_L17  L_L150  0.0152
K_K2624  L_L17  L_L151  0.0191
K_K2625  L_L17  L_L152  0.0256
K_K2626  L_L17  L_L153  0.0389
K_K2627  L_L17  L_L154  0.0812
K_K2628  L_L17  L_L155  0.1569
K_K2629  L_L17  L_L156  0.0812
K_K2630  L_L17  L_L157  0.0389
K_K2631  L_L17  L_L158  0.0256
K_K2632  L_L17  L_L159  0.0191
K_K2633  L_L17  L_L160  0.0152
K_K2634  L_L17  L_L161  0.0127
K_K2635  L_L17  L_L162  0.0109
K_K2636  L_L17  L_L163  0.0095
K_K2637  L_L17  L_L164  0.0084
K_K2638  L_L17  L_L165  0.0076
K_K2639  L_L17  L_L166  0.0069
K_K2640  L_L17  L_L167  0.0063
K_K2641  L_L17  L_L168  0.0058
K_K2642  L_L17  L_L169  0.0054
K_K2643  L_L17  L_L170  0.0051
K_K2644  L_L17  L_L171  0.0047
K_K2645  L_L17  L_L172  0.0045
K_K2646  L_L17  L_L173  0.0042
K_K2647  L_L17  L_L174  0.0040
K_K2648  L_L17  L_L175  0.0038
K_K2649  L_L17  L_L176  0.0036
K_K2650  L_L17  L_L177  0.0034
K_K2651  L_L17  L_L178  0.0033
K_K2652  L_L17  L_L179  0.0032
K_K2653  L_L17  L_L180  0.0030
K_K2654  L_L17  L_L181  0.0029
K_K2655  L_L17  L_L182  0.0028
K_K2656  L_L17  L_L183  0.0027
K_K2657  L_L17  L_L184  0.0026
K_K2658  L_L17  L_L185  0.0025
K_K2659  L_L17  L_L186  0.0024
K_K2660  L_L17  L_L187  0.0024
K_K2661  L_L17  L_L188  0.0023
K_K2662  L_L17  L_L189  0.0022
K_K2663  L_L17  L_L190  0.0022
K_K2664  L_L17  L_L191  0.0021
K_K2665  L_L17  L_L192  0.0020
K_K2666  L_L17  L_L193  0.0020
K_K2667  L_L17  L_L194  0.0019
K_K2668  L_L17  L_L195  0.0019
K_K2669  L_L17  L_L196  0.0018
K_K2670  L_L17  L_L197  0.0018
K_K2671  L_L17  L_L198  0.0018
K_K2672  L_L17  L_L199  0.0017
K_K2673  L_L17  L_L200  0.0017
K_K2674  L_L17  L_L201  0.0016
K_K2675  L_L17  L_L202  0.0016
K_K2676  L_L17  L_L203  0.0016
K_K2677  L_L17  L_L204  0.0015
K_K2678  L_L17  L_L205  0.0015
K_K2679  L_L17  L_L206  0.0015
K_K2680  L_L17  L_L207  0.0015
K_K2681  L_L17  L_L208  0.0014
K_K2682  L_L17  L_L209  0.0014
K_K2683  L_L17  L_L210  0.0014
K_K2684  L_L17  L_L211  0.0014
K_K2685  L_L17  L_L212  0.0013
K_K2686  L_L17  L_L213  0.0013
K_K2687  L_L17  L_L214  0.0013
K_K2688  L_L17  L_L215  0.0013
K_K2689  L_L17  L_L216  0.0012
K_K2690  L_L17  L_L217  0.0012
K_K2691  L_L17  L_L218  0.0012
K_K2692  L_L17  L_L219  0.0012
K_K2693  L_L17  L_L220  0.0012
K_K2694  L_L17  L_L221  0.0011
K_K2695  L_L17  L_L222  0.0011
K_K2696  L_L17  L_L223  0.0011
K_K2697  L_L17  L_L224  0.0011
K_K2698  L_L17  L_L225  0.0011
K_K2699  L_L17  L_L226  0.0011
K_K2700  L_L17  L_L227  0.0011
K_K2701  L_L17  L_L228  0.0010
K_K2702  L_L17  L_L229  0.0010
K_K2703  L_L17  L_L230  0.0010
* *  Branch  NTMP0000000017 - NTMP0000000018
R_R18  NTMP0000000017  nU_18  32.914993m  TC=0,0
V_Ui18  nU_18  nR_18  STIMULUS=U_IND_0000000018
R_V35  nR_18  nV_35  23.280268m  TC=0,0
L_V35  nR_18  nV_35  0.014646uH
R_V36  nV_35  nV_36  7.852787m  TC=0,0
L_V36  nV_35  nV_36  0.073723uH
L_L18  nV_36  NTMP0000000018  6.519695uH
K_K2704  L_L18  L_L19  0.1050
K_K2705  L_L18  L_L20  0.0397
K_K2706  L_L18  L_L21  0.0258
K_K2707  L_L18  L_L22  0.0192
K_K2708  L_L18  L_L23  0.0153
K_K2709  L_L18  L_L24  0.0127
K_K2710  L_L18  L_L25  0.0109
K_K2711  L_L18  L_L26  0.0095
K_K2712  L_L18  L_L27  0.0084
K_K2713  L_L18  L_L28  0.0076
K_K2714  L_L18  L_L29  0.0069
K_K2715  L_L18  L_L30  0.0063
K_K2716  L_L18  L_L31  0.0058
K_K2717  L_L18  L_L32  0.0054
K_K2718  L_L18  L_L33  0.0051
K_K2719  L_L18  L_L34  0.0047
K_K2720  L_L18  L_L35  0.0045
K_K2721  L_L18  L_L36  0.0042
K_K2722  L_L18  L_L37  0.0040
K_K2723  L_L18  L_L38  0.0038
K_K2724  L_L18  L_L39  0.0036
K_K2725  L_L18  L_L40  0.0034
K_K2726  L_L18  L_L41  0.0033
K_K2727  L_L18  L_L42  0.0032
K_K2728  L_L18  L_L43  0.0030
K_K2729  L_L18  L_L44  0.0029
K_K2730  L_L18  L_L45  0.0028
K_K2731  L_L18  L_L46  0.0027
K_K2732  L_L18  L_L47  0.0026
K_K2733  L_L18  L_L48  0.0025
K_K2734  L_L18  L_L49  0.0024
K_K2735  L_L18  L_L50  0.0024
K_K2736  L_L18  L_L51  0.0023
K_K2737  L_L18  L_L52  0.0022
K_K2738  L_L18  L_L53  0.0022
K_K2739  L_L18  L_L54  0.0021
K_K2740  L_L18  L_L55  0.0020
K_K2741  L_L18  L_L56  0.0020
K_K2742  L_L18  L_L57  0.0019
K_K2743  L_L18  L_L58  0.0019
K_K2744  L_L18  L_L59  0.0019
K_K2745  L_L18  L_L60  0.0018
K_K2746  L_L18  L_L61  0.0018
K_K2747  L_L18  L_L62  0.0017
K_K2748  L_L18  L_L63  0.0017
K_K2749  L_L18  L_L64  0.0017
K_K2750  L_L18  L_L65  0.0016
K_K2751  L_L18  L_L66  0.0016
K_K2752  L_L18  L_L67  0.0015
K_K2753  L_L18  L_L68  0.0015
K_K2754  L_L18  L_L69  0.0015
K_K2755  L_L18  L_L70  0.0015
K_K2756  L_L18  L_L71  0.0014
K_K2757  L_L18  L_L72  0.0014
K_K2758  L_L18  L_L73  0.0014
K_K2759  L_L18  L_L74  0.0014
K_K2760  L_L18  L_L75  0.0013
K_K2761  L_L18  L_L76  0.0013
K_K2762  L_L18  L_L77  0.0013
K_K2763  L_L18  L_L78  0.0013
K_K2764  L_L18  L_L79  0.0013
K_K2765  L_L18  L_L80  0.0012
K_K2766  L_L18  L_L81  0.0012
K_K2767  L_L18  L_L82  0.0012
K_K2768  L_L18  L_L83  0.0012
K_K2769  L_L18  L_L84  0.0011
K_K2770  L_L18  L_L85  0.0011
K_K2771  L_L18  L_L86  0.0011
K_K2772  L_L18  L_L87  0.0011
K_K2773  L_L18  L_L88  0.0011
K_K2774  L_L18  L_L89  0.0011
K_K2775  L_L18  L_L90  0.0011
K_K2776  L_L18  L_L91  0.0010
K_K2777  L_L18  L_L92  0.0010
K_K2778  L_L18  L_L93  0.0010
K_K2779  L_L18  L_L139  0.0045
K_K2780  L_L18  L_L140  0.0047
K_K2781  L_L18  L_L141  0.0051
K_K2782  L_L18  L_L142  0.0054
K_K2783  L_L18  L_L143  0.0058
K_K2784  L_L18  L_L144  0.0063
K_K2785  L_L18  L_L145  0.0069
K_K2786  L_L18  L_L146  0.0076
K_K2787  L_L18  L_L147  0.0084
K_K2788  L_L18  L_L148  0.0095
K_K2789  L_L18  L_L149  0.0109
K_K2790  L_L18  L_L150  0.0127
K_K2791  L_L18  L_L151  0.0152
K_K2792  L_L18  L_L152  0.0191
K_K2793  L_L18  L_L153  0.0256
K_K2794  L_L18  L_L154  0.0389
K_K2795  L_L18  L_L155  0.0812
K_K2796  L_L18  L_L156  0.1569
K_K2797  L_L18  L_L157  0.0812
K_K2798  L_L18  L_L158  0.0389
K_K2799  L_L18  L_L159  0.0256
K_K2800  L_L18  L_L160  0.0191
K_K2801  L_L18  L_L161  0.0152
K_K2802  L_L18  L_L162  0.0127
K_K2803  L_L18  L_L163  0.0109
K_K2804  L_L18  L_L164  0.0095
K_K2805  L_L18  L_L165  0.0084
K_K2806  L_L18  L_L166  0.0076
K_K2807  L_L18  L_L167  0.0069
K_K2808  L_L18  L_L168  0.0063
K_K2809  L_L18  L_L169  0.0058
K_K2810  L_L18  L_L170  0.0054
K_K2811  L_L18  L_L171  0.0051
K_K2812  L_L18  L_L172  0.0047
K_K2813  L_L18  L_L173  0.0045
K_K2814  L_L18  L_L174  0.0042
K_K2815  L_L18  L_L175  0.0040
K_K2816  L_L18  L_L176  0.0038
K_K2817  L_L18  L_L177  0.0036
K_K2818  L_L18  L_L178  0.0034
K_K2819  L_L18  L_L179  0.0033
K_K2820  L_L18  L_L180  0.0032
K_K2821  L_L18  L_L181  0.0030
K_K2822  L_L18  L_L182  0.0029
K_K2823  L_L18  L_L183  0.0028
K_K2824  L_L18  L_L184  0.0027
K_K2825  L_L18  L_L185  0.0026
K_K2826  L_L18  L_L186  0.0025
K_K2827  L_L18  L_L187  0.0024
K_K2828  L_L18  L_L188  0.0024
K_K2829  L_L18  L_L189  0.0023
K_K2830  L_L18  L_L190  0.0022
K_K2831  L_L18  L_L191  0.0022
K_K2832  L_L18  L_L192  0.0021
K_K2833  L_L18  L_L193  0.0020
K_K2834  L_L18  L_L194  0.0020
K_K2835  L_L18  L_L195  0.0019
K_K2836  L_L18  L_L196  0.0019
K_K2837  L_L18  L_L197  0.0018
K_K2838  L_L18  L_L198  0.0018
K_K2839  L_L18  L_L199  0.0018
K_K2840  L_L18  L_L200  0.0017
K_K2841  L_L18  L_L201  0.0017
K_K2842  L_L18  L_L202  0.0016
K_K2843  L_L18  L_L203  0.0016
K_K2844  L_L18  L_L204  0.0016
K_K2845  L_L18  L_L205  0.0015
K_K2846  L_L18  L_L206  0.0015
K_K2847  L_L18  L_L207  0.0015
K_K2848  L_L18  L_L208  0.0015
K_K2849  L_L18  L_L209  0.0014
K_K2850  L_L18  L_L210  0.0014
K_K2851  L_L18  L_L211  0.0014
K_K2852  L_L18  L_L212  0.0014
K_K2853  L_L18  L_L213  0.0013
K_K2854  L_L18  L_L214  0.0013
K_K2855  L_L18  L_L215  0.0013
K_K2856  L_L18  L_L216  0.0013
K_K2857  L_L18  L_L217  0.0012
K_K2858  L_L18  L_L218  0.0012
K_K2859  L_L18  L_L219  0.0012
K_K2860  L_L18  L_L220  0.0012
K_K2861  L_L18  L_L221  0.0012
K_K2862  L_L18  L_L222  0.0011
K_K2863  L_L18  L_L223  0.0011
K_K2864  L_L18  L_L224  0.0011
K_K2865  L_L18  L_L225  0.0011
K_K2866  L_L18  L_L226  0.0011
K_K2867  L_L18  L_L227  0.0011
K_K2868  L_L18  L_L228  0.0011
K_K2869  L_L18  L_L229  0.0010
K_K2870  L_L18  L_L230  0.0010
K_K2871  L_L18  L_L231  0.0010
* *  Branch  NTMP0000000018 - NTMP0000000019
R_R19  NTMP0000000018  nU_19  32.914993m  TC=0,0
V_Ui19  nU_19  nR_19  STIMULUS=U_IND_0000000019
R_V37  nR_19  nV_37  23.280268m  TC=0,0
L_V37  nR_19  nV_37  0.014646uH
R_V38  nV_37  nV_38  7.852787m  TC=0,0
L_V38  nV_37  nV_38  0.073723uH
L_L19  nV_38  NTMP0000000019  6.519695uH
K_K2872  L_L19  L_L20  0.1050
K_K2873  L_L19  L_L21  0.0397
K_K2874  L_L19  L_L22  0.0258
K_K2875  L_L19  L_L23  0.0192
K_K2876  L_L19  L_L24  0.0153
K_K2877  L_L19  L_L25  0.0127
K_K2878  L_L19  L_L26  0.0109
K_K2879  L_L19  L_L27  0.0095
K_K2880  L_L19  L_L28  0.0084
K_K2881  L_L19  L_L29  0.0076
K_K2882  L_L19  L_L30  0.0069
K_K2883  L_L19  L_L31  0.0063
K_K2884  L_L19  L_L32  0.0058
K_K2885  L_L19  L_L33  0.0054
K_K2886  L_L19  L_L34  0.0051
K_K2887  L_L19  L_L35  0.0047
K_K2888  L_L19  L_L36  0.0045
K_K2889  L_L19  L_L37  0.0042
K_K2890  L_L19  L_L38  0.0040
K_K2891  L_L19  L_L39  0.0038
K_K2892  L_L19  L_L40  0.0036
K_K2893  L_L19  L_L41  0.0034
K_K2894  L_L19  L_L42  0.0033
K_K2895  L_L19  L_L43  0.0032
K_K2896  L_L19  L_L44  0.0030
K_K2897  L_L19  L_L45  0.0029
K_K2898  L_L19  L_L46  0.0028
K_K2899  L_L19  L_L47  0.0027
K_K2900  L_L19  L_L48  0.0026
K_K2901  L_L19  L_L49  0.0025
K_K2902  L_L19  L_L50  0.0024
K_K2903  L_L19  L_L51  0.0024
K_K2904  L_L19  L_L52  0.0023
K_K2905  L_L19  L_L53  0.0022
K_K2906  L_L19  L_L54  0.0022
K_K2907  L_L19  L_L55  0.0021
K_K2908  L_L19  L_L56  0.0020
K_K2909  L_L19  L_L57  0.0020
K_K2910  L_L19  L_L58  0.0019
K_K2911  L_L19  L_L59  0.0019
K_K2912  L_L19  L_L60  0.0019
K_K2913  L_L19  L_L61  0.0018
K_K2914  L_L19  L_L62  0.0018
K_K2915  L_L19  L_L63  0.0017
K_K2916  L_L19  L_L64  0.0017
K_K2917  L_L19  L_L65  0.0017
K_K2918  L_L19  L_L66  0.0016
K_K2919  L_L19  L_L67  0.0016
K_K2920  L_L19  L_L68  0.0015
K_K2921  L_L19  L_L69  0.0015
K_K2922  L_L19  L_L70  0.0015
K_K2923  L_L19  L_L71  0.0015
K_K2924  L_L19  L_L72  0.0014
K_K2925  L_L19  L_L73  0.0014
K_K2926  L_L19  L_L74  0.0014
K_K2927  L_L19  L_L75  0.0014
K_K2928  L_L19  L_L76  0.0013
K_K2929  L_L19  L_L77  0.0013
K_K2930  L_L19  L_L78  0.0013
K_K2931  L_L19  L_L79  0.0013
K_K2932  L_L19  L_L80  0.0013
K_K2933  L_L19  L_L81  0.0012
K_K2934  L_L19  L_L82  0.0012
K_K2935  L_L19  L_L83  0.0012
K_K2936  L_L19  L_L84  0.0012
K_K2937  L_L19  L_L85  0.0011
K_K2938  L_L19  L_L86  0.0011
K_K2939  L_L19  L_L87  0.0011
K_K2940  L_L19  L_L88  0.0011
K_K2941  L_L19  L_L89  0.0011
K_K2942  L_L19  L_L90  0.0011
K_K2943  L_L19  L_L91  0.0011
K_K2944  L_L19  L_L92  0.0010
K_K2945  L_L19  L_L93  0.0010
K_K2946  L_L19  L_L94  0.0010
K_K2947  L_L19  L_L139  0.0042
K_K2948  L_L19  L_L140  0.0045
K_K2949  L_L19  L_L141  0.0047
K_K2950  L_L19  L_L142  0.0051
K_K2951  L_L19  L_L143  0.0054
K_K2952  L_L19  L_L144  0.0058
K_K2953  L_L19  L_L145  0.0063
K_K2954  L_L19  L_L146  0.0069
K_K2955  L_L19  L_L147  0.0076
K_K2956  L_L19  L_L148  0.0084
K_K2957  L_L19  L_L149  0.0095
K_K2958  L_L19  L_L150  0.0109
K_K2959  L_L19  L_L151  0.0127
K_K2960  L_L19  L_L152  0.0152
K_K2961  L_L19  L_L153  0.0191
K_K2962  L_L19  L_L154  0.0256
K_K2963  L_L19  L_L155  0.0389
K_K2964  L_L19  L_L156  0.0812
K_K2965  L_L19  L_L157  0.1569
K_K2966  L_L19  L_L158  0.0812
K_K2967  L_L19  L_L159  0.0389
K_K2968  L_L19  L_L160  0.0256
K_K2969  L_L19  L_L161  0.0191
K_K2970  L_L19  L_L162  0.0152
K_K2971  L_L19  L_L163  0.0127
K_K2972  L_L19  L_L164  0.0109
K_K2973  L_L19  L_L165  0.0095
K_K2974  L_L19  L_L166  0.0084
K_K2975  L_L19  L_L167  0.0076
K_K2976  L_L19  L_L168  0.0069
K_K2977  L_L19  L_L169  0.0063
K_K2978  L_L19  L_L170  0.0058
K_K2979  L_L19  L_L171  0.0054
K_K2980  L_L19  L_L172  0.0051
K_K2981  L_L19  L_L173  0.0047
K_K2982  L_L19  L_L174  0.0045
K_K2983  L_L19  L_L175  0.0042
K_K2984  L_L19  L_L176  0.0040
K_K2985  L_L19  L_L177  0.0038
K_K2986  L_L19  L_L178  0.0036
K_K2987  L_L19  L_L179  0.0034
K_K2988  L_L19  L_L180  0.0033
K_K2989  L_L19  L_L181  0.0032
K_K2990  L_L19  L_L182  0.0030
K_K2991  L_L19  L_L183  0.0029
K_K2992  L_L19  L_L184  0.0028
K_K2993  L_L19  L_L185  0.0027
K_K2994  L_L19  L_L186  0.0026
K_K2995  L_L19  L_L187  0.0025
K_K2996  L_L19  L_L188  0.0024
K_K2997  L_L19  L_L189  0.0024
K_K2998  L_L19  L_L190  0.0023
K_K2999  L_L19  L_L191  0.0022
K_K3000  L_L19  L_L192  0.0022
K_K3001  L_L19  L_L193  0.0021
K_K3002  L_L19  L_L194  0.0020
K_K3003  L_L19  L_L195  0.0020
K_K3004  L_L19  L_L196  0.0019
K_K3005  L_L19  L_L197  0.0019
K_K3006  L_L19  L_L198  0.0018
K_K3007  L_L19  L_L199  0.0018
K_K3008  L_L19  L_L200  0.0018
K_K3009  L_L19  L_L201  0.0017
K_K3010  L_L19  L_L202  0.0017
K_K3011  L_L19  L_L203  0.0016
K_K3012  L_L19  L_L204  0.0016
K_K3013  L_L19  L_L205  0.0016
K_K3014  L_L19  L_L206  0.0015
K_K3015  L_L19  L_L207  0.0015
K_K3016  L_L19  L_L208  0.0015
K_K3017  L_L19  L_L209  0.0015
K_K3018  L_L19  L_L210  0.0014
K_K3019  L_L19  L_L211  0.0014
K_K3020  L_L19  L_L212  0.0014
K_K3021  L_L19  L_L213  0.0014
K_K3022  L_L19  L_L214  0.0013
K_K3023  L_L19  L_L215  0.0013
K_K3024  L_L19  L_L216  0.0013
K_K3025  L_L19  L_L217  0.0013
K_K3026  L_L19  L_L218  0.0012
K_K3027  L_L19  L_L219  0.0012
K_K3028  L_L19  L_L220  0.0012
K_K3029  L_L19  L_L221  0.0012
K_K3030  L_L19  L_L222  0.0012
K_K3031  L_L19  L_L223  0.0011
K_K3032  L_L19  L_L224  0.0011
K_K3033  L_L19  L_L225  0.0011
K_K3034  L_L19  L_L226  0.0011
K_K3035  L_L19  L_L227  0.0011
K_K3036  L_L19  L_L228  0.0011
K_K3037  L_L19  L_L229  0.0011
K_K3038  L_L19  L_L230  0.0010
K_K3039  L_L19  L_L231  0.0010
K_K3040  L_L19  L_L232  0.0010
* *  Branch  NTMP0000000019 - NTMP0000000020
R_R20  NTMP0000000019  nU_20  32.914993m  TC=0,0
V_Ui20  nU_20  nR_20  STIMULUS=U_IND_0000000020
R_V39  nR_20  nV_39  23.280268m  TC=0,0
L_V39  nR_20  nV_39  0.014646uH
R_V40  nV_39  nV_40  7.852787m  TC=0,0
L_V40  nV_39  nV_40  0.073723uH
L_L20  nV_40  NTMP0000000020  6.519695uH
K_K3041  L_L20  L_L21  0.1050
K_K3042  L_L20  L_L22  0.0397
K_K3043  L_L20  L_L23  0.0258
K_K3044  L_L20  L_L24  0.0192
K_K3045  L_L20  L_L25  0.0153
K_K3046  L_L20  L_L26  0.0127
K_K3047  L_L20  L_L27  0.0109
K_K3048  L_L20  L_L28  0.0095
K_K3049  L_L20  L_L29  0.0084
K_K3050  L_L20  L_L30  0.0076
K_K3051  L_L20  L_L31  0.0069
K_K3052  L_L20  L_L32  0.0063
K_K3053  L_L20  L_L33  0.0058
K_K3054  L_L20  L_L34  0.0054
K_K3055  L_L20  L_L35  0.0051
K_K3056  L_L20  L_L36  0.0047
K_K3057  L_L20  L_L37  0.0045
K_K3058  L_L20  L_L38  0.0042
K_K3059  L_L20  L_L39  0.0040
K_K3060  L_L20  L_L40  0.0038
K_K3061  L_L20  L_L41  0.0036
K_K3062  L_L20  L_L42  0.0034
K_K3063  L_L20  L_L43  0.0033
K_K3064  L_L20  L_L44  0.0032
K_K3065  L_L20  L_L45  0.0030
K_K3066  L_L20  L_L46  0.0029
K_K3067  L_L20  L_L47  0.0028
K_K3068  L_L20  L_L48  0.0027
K_K3069  L_L20  L_L49  0.0026
K_K3070  L_L20  L_L50  0.0025
K_K3071  L_L20  L_L51  0.0024
K_K3072  L_L20  L_L52  0.0024
K_K3073  L_L20  L_L53  0.0023
K_K3074  L_L20  L_L54  0.0022
K_K3075  L_L20  L_L55  0.0022
K_K3076  L_L20  L_L56  0.0021
K_K3077  L_L20  L_L57  0.0020
K_K3078  L_L20  L_L58  0.0020
K_K3079  L_L20  L_L59  0.0019
K_K3080  L_L20  L_L60  0.0019
K_K3081  L_L20  L_L61  0.0019
K_K3082  L_L20  L_L62  0.0018
K_K3083  L_L20  L_L63  0.0018
K_K3084  L_L20  L_L64  0.0017
K_K3085  L_L20  L_L65  0.0017
K_K3086  L_L20  L_L66  0.0017
K_K3087  L_L20  L_L67  0.0016
K_K3088  L_L20  L_L68  0.0016
K_K3089  L_L20  L_L69  0.0015
K_K3090  L_L20  L_L70  0.0015
K_K3091  L_L20  L_L71  0.0015
K_K3092  L_L20  L_L72  0.0015
K_K3093  L_L20  L_L73  0.0014
K_K3094  L_L20  L_L74  0.0014
K_K3095  L_L20  L_L75  0.0014
K_K3096  L_L20  L_L76  0.0014
K_K3097  L_L20  L_L77  0.0013
K_K3098  L_L20  L_L78  0.0013
K_K3099  L_L20  L_L79  0.0013
K_K3100  L_L20  L_L80  0.0013
K_K3101  L_L20  L_L81  0.0013
K_K3102  L_L20  L_L82  0.0012
K_K3103  L_L20  L_L83  0.0012
K_K3104  L_L20  L_L84  0.0012
K_K3105  L_L20  L_L85  0.0012
K_K3106  L_L20  L_L86  0.0011
K_K3107  L_L20  L_L87  0.0011
K_K3108  L_L20  L_L88  0.0011
K_K3109  L_L20  L_L89  0.0011
K_K3110  L_L20  L_L90  0.0011
K_K3111  L_L20  L_L91  0.0011
K_K3112  L_L20  L_L92  0.0011
K_K3113  L_L20  L_L93  0.0010
K_K3114  L_L20  L_L94  0.0010
K_K3115  L_L20  L_L95  0.0010
K_K3116  L_L20  L_L139  0.0040
K_K3117  L_L20  L_L140  0.0042
K_K3118  L_L20  L_L141  0.0045
K_K3119  L_L20  L_L142  0.0047
K_K3120  L_L20  L_L143  0.0051
K_K3121  L_L20  L_L144  0.0054
K_K3122  L_L20  L_L145  0.0058
K_K3123  L_L20  L_L146  0.0063
K_K3124  L_L20  L_L147  0.0069
K_K3125  L_L20  L_L148  0.0076
K_K3126  L_L20  L_L149  0.0084
K_K3127  L_L20  L_L150  0.0095
K_K3128  L_L20  L_L151  0.0109
K_K3129  L_L20  L_L152  0.0127
K_K3130  L_L20  L_L153  0.0152
K_K3131  L_L20  L_L154  0.0191
K_K3132  L_L20  L_L155  0.0256
K_K3133  L_L20  L_L156  0.0389
K_K3134  L_L20  L_L157  0.0812
K_K3135  L_L20  L_L158  0.1569
K_K3136  L_L20  L_L159  0.0812
K_K3137  L_L20  L_L160  0.0389
K_K3138  L_L20  L_L161  0.0256
K_K3139  L_L20  L_L162  0.0191
K_K3140  L_L20  L_L163  0.0152
K_K3141  L_L20  L_L164  0.0127
K_K3142  L_L20  L_L165  0.0109
K_K3143  L_L20  L_L166  0.0095
K_K3144  L_L20  L_L167  0.0084
K_K3145  L_L20  L_L168  0.0076
K_K3146  L_L20  L_L169  0.0069
K_K3147  L_L20  L_L170  0.0063
K_K3148  L_L20  L_L171  0.0058
K_K3149  L_L20  L_L172  0.0054
K_K3150  L_L20  L_L173  0.0051
K_K3151  L_L20  L_L174  0.0047
K_K3152  L_L20  L_L175  0.0045
K_K3153  L_L20  L_L176  0.0042
K_K3154  L_L20  L_L177  0.0040
K_K3155  L_L20  L_L178  0.0038
K_K3156  L_L20  L_L179  0.0036
K_K3157  L_L20  L_L180  0.0034
K_K3158  L_L20  L_L181  0.0033
K_K3159  L_L20  L_L182  0.0032
K_K3160  L_L20  L_L183  0.0030
K_K3161  L_L20  L_L184  0.0029
K_K3162  L_L20  L_L185  0.0028
K_K3163  L_L20  L_L186  0.0027
K_K3164  L_L20  L_L187  0.0026
K_K3165  L_L20  L_L188  0.0025
K_K3166  L_L20  L_L189  0.0024
K_K3167  L_L20  L_L190  0.0024
K_K3168  L_L20  L_L191  0.0023
K_K3169  L_L20  L_L192  0.0022
K_K3170  L_L20  L_L193  0.0022
K_K3171  L_L20  L_L194  0.0021
K_K3172  L_L20  L_L195  0.0020
K_K3173  L_L20  L_L196  0.0020
K_K3174  L_L20  L_L197  0.0019
K_K3175  L_L20  L_L198  0.0019
K_K3176  L_L20  L_L199  0.0018
K_K3177  L_L20  L_L200  0.0018
K_K3178  L_L20  L_L201  0.0018
K_K3179  L_L20  L_L202  0.0017
K_K3180  L_L20  L_L203  0.0017
K_K3181  L_L20  L_L204  0.0016
K_K3182  L_L20  L_L205  0.0016
K_K3183  L_L20  L_L206  0.0016
K_K3184  L_L20  L_L207  0.0015
K_K3185  L_L20  L_L208  0.0015
K_K3186  L_L20  L_L209  0.0015
K_K3187  L_L20  L_L210  0.0015
K_K3188  L_L20  L_L211  0.0014
K_K3189  L_L20  L_L212  0.0014
K_K3190  L_L20  L_L213  0.0014
K_K3191  L_L20  L_L214  0.0014
K_K3192  L_L20  L_L215  0.0013
K_K3193  L_L20  L_L216  0.0013
K_K3194  L_L20  L_L217  0.0013
K_K3195  L_L20  L_L218  0.0013
K_K3196  L_L20  L_L219  0.0012
K_K3197  L_L20  L_L220  0.0012
K_K3198  L_L20  L_L221  0.0012
K_K3199  L_L20  L_L222  0.0012
K_K3200  L_L20  L_L223  0.0012
K_K3201  L_L20  L_L224  0.0011
K_K3202  L_L20  L_L225  0.0011
K_K3203  L_L20  L_L226  0.0011
K_K3204  L_L20  L_L227  0.0011
K_K3205  L_L20  L_L228  0.0011
K_K3206  L_L20  L_L229  0.0011
K_K3207  L_L20  L_L230  0.0011
K_K3208  L_L20  L_L231  0.0010
K_K3209  L_L20  L_L232  0.0010
K_K3210  L_L20  L_L233  0.0010
* *  Branch  NTMP0000000020 - NTMP0000000021
R_R21  NTMP0000000020  nU_21  32.914993m  TC=0,0
V_Ui21  nU_21  nR_21  STIMULUS=U_IND_0000000021
R_V41  nR_21  nV_41  23.280268m  TC=0,0
L_V41  nR_21  nV_41  0.014646uH
R_V42  nV_41  nV_42  7.852787m  TC=0,0
L_V42  nV_41  nV_42  0.073723uH
L_L21  nV_42  NTMP0000000021  6.519695uH
K_K3211  L_L21  L_L22  0.1050
K_K3212  L_L21  L_L23  0.0397
K_K3213  L_L21  L_L24  0.0258
K_K3214  L_L21  L_L25  0.0192
K_K3215  L_L21  L_L26  0.0153
K_K3216  L_L21  L_L27  0.0127
K_K3217  L_L21  L_L28  0.0109
K_K3218  L_L21  L_L29  0.0095
K_K3219  L_L21  L_L30  0.0084
K_K3220  L_L21  L_L31  0.0076
K_K3221  L_L21  L_L32  0.0069
K_K3222  L_L21  L_L33  0.0063
K_K3223  L_L21  L_L34  0.0058
K_K3224  L_L21  L_L35  0.0054
K_K3225  L_L21  L_L36  0.0051
K_K3226  L_L21  L_L37  0.0047
K_K3227  L_L21  L_L38  0.0045
K_K3228  L_L21  L_L39  0.0042
K_K3229  L_L21  L_L40  0.0040
K_K3230  L_L21  L_L41  0.0038
K_K3231  L_L21  L_L42  0.0036
K_K3232  L_L21  L_L43  0.0034
K_K3233  L_L21  L_L44  0.0033
K_K3234  L_L21  L_L45  0.0032
K_K3235  L_L21  L_L46  0.0030
K_K3236  L_L21  L_L47  0.0029
K_K3237  L_L21  L_L48  0.0028
K_K3238  L_L21  L_L49  0.0027
K_K3239  L_L21  L_L50  0.0026
K_K3240  L_L21  L_L51  0.0025
K_K3241  L_L21  L_L52  0.0024
K_K3242  L_L21  L_L53  0.0024
K_K3243  L_L21  L_L54  0.0023
K_K3244  L_L21  L_L55  0.0022
K_K3245  L_L21  L_L56  0.0022
K_K3246  L_L21  L_L57  0.0021
K_K3247  L_L21  L_L58  0.0020
K_K3248  L_L21  L_L59  0.0020
K_K3249  L_L21  L_L60  0.0019
K_K3250  L_L21  L_L61  0.0019
K_K3251  L_L21  L_L62  0.0019
K_K3252  L_L21  L_L63  0.0018
K_K3253  L_L21  L_L64  0.0018
K_K3254  L_L21  L_L65  0.0017
K_K3255  L_L21  L_L66  0.0017
K_K3256  L_L21  L_L67  0.0017
K_K3257  L_L21  L_L68  0.0016
K_K3258  L_L21  L_L69  0.0016
K_K3259  L_L21  L_L70  0.0015
K_K3260  L_L21  L_L71  0.0015
K_K3261  L_L21  L_L72  0.0015
K_K3262  L_L21  L_L73  0.0015
K_K3263  L_L21  L_L74  0.0014
K_K3264  L_L21  L_L75  0.0014
K_K3265  L_L21  L_L76  0.0014
K_K3266  L_L21  L_L77  0.0014
K_K3267  L_L21  L_L78  0.0013
K_K3268  L_L21  L_L79  0.0013
K_K3269  L_L21  L_L80  0.0013
K_K3270  L_L21  L_L81  0.0013
K_K3271  L_L21  L_L82  0.0013
K_K3272  L_L21  L_L83  0.0012
K_K3273  L_L21  L_L84  0.0012
K_K3274  L_L21  L_L85  0.0012
K_K3275  L_L21  L_L86  0.0012
K_K3276  L_L21  L_L87  0.0011
K_K3277  L_L21  L_L88  0.0011
K_K3278  L_L21  L_L89  0.0011
K_K3279  L_L21  L_L90  0.0011
K_K3280  L_L21  L_L91  0.0011
K_K3281  L_L21  L_L92  0.0011
K_K3282  L_L21  L_L93  0.0011
K_K3283  L_L21  L_L94  0.0010
K_K3284  L_L21  L_L95  0.0010
K_K3285  L_L21  L_L96  0.0010
K_K3286  L_L21  L_L139  0.0038
K_K3287  L_L21  L_L140  0.0040
K_K3288  L_L21  L_L141  0.0042
K_K3289  L_L21  L_L142  0.0045
K_K3290  L_L21  L_L143  0.0047
K_K3291  L_L21  L_L144  0.0051
K_K3292  L_L21  L_L145  0.0054
K_K3293  L_L21  L_L146  0.0058
K_K3294  L_L21  L_L147  0.0063
K_K3295  L_L21  L_L148  0.0069
K_K3296  L_L21  L_L149  0.0076
K_K3297  L_L21  L_L150  0.0084
K_K3298  L_L21  L_L151  0.0095
K_K3299  L_L21  L_L152  0.0109
K_K3300  L_L21  L_L153  0.0127
K_K3301  L_L21  L_L154  0.0152
K_K3302  L_L21  L_L155  0.0191
K_K3303  L_L21  L_L156  0.0256
K_K3304  L_L21  L_L157  0.0389
K_K3305  L_L21  L_L158  0.0812
K_K3306  L_L21  L_L159  0.1569
K_K3307  L_L21  L_L160  0.0812
K_K3308  L_L21  L_L161  0.0389
K_K3309  L_L21  L_L162  0.0256
K_K3310  L_L21  L_L163  0.0191
K_K3311  L_L21  L_L164  0.0152
K_K3312  L_L21  L_L165  0.0127
K_K3313  L_L21  L_L166  0.0109
K_K3314  L_L21  L_L167  0.0095
K_K3315  L_L21  L_L168  0.0084
K_K3316  L_L21  L_L169  0.0076
K_K3317  L_L21  L_L170  0.0069
K_K3318  L_L21  L_L171  0.0063
K_K3319  L_L21  L_L172  0.0058
K_K3320  L_L21  L_L173  0.0054
K_K3321  L_L21  L_L174  0.0051
K_K3322  L_L21  L_L175  0.0047
K_K3323  L_L21  L_L176  0.0045
K_K3324  L_L21  L_L177  0.0042
K_K3325  L_L21  L_L178  0.0040
K_K3326  L_L21  L_L179  0.0038
K_K3327  L_L21  L_L180  0.0036
K_K3328  L_L21  L_L181  0.0034
K_K3329  L_L21  L_L182  0.0033
K_K3330  L_L21  L_L183  0.0032
K_K3331  L_L21  L_L184  0.0030
K_K3332  L_L21  L_L185  0.0029
K_K3333  L_L21  L_L186  0.0028
K_K3334  L_L21  L_L187  0.0027
K_K3335  L_L21  L_L188  0.0026
K_K3336  L_L21  L_L189  0.0025
K_K3337  L_L21  L_L190  0.0024
K_K3338  L_L21  L_L191  0.0024
K_K3339  L_L21  L_L192  0.0023
K_K3340  L_L21  L_L193  0.0022
K_K3341  L_L21  L_L194  0.0022
K_K3342  L_L21  L_L195  0.0021
K_K3343  L_L21  L_L196  0.0020
K_K3344  L_L21  L_L197  0.0020
K_K3345  L_L21  L_L198  0.0019
K_K3346  L_L21  L_L199  0.0019
K_K3347  L_L21  L_L200  0.0018
K_K3348  L_L21  L_L201  0.0018
K_K3349  L_L21  L_L202  0.0018
K_K3350  L_L21  L_L203  0.0017
K_K3351  L_L21  L_L204  0.0017
K_K3352  L_L21  L_L205  0.0016
K_K3353  L_L21  L_L206  0.0016
K_K3354  L_L21  L_L207  0.0016
K_K3355  L_L21  L_L208  0.0015
K_K3356  L_L21  L_L209  0.0015
K_K3357  L_L21  L_L210  0.0015
K_K3358  L_L21  L_L211  0.0015
K_K3359  L_L21  L_L212  0.0014
K_K3360  L_L21  L_L213  0.0014
K_K3361  L_L21  L_L214  0.0014
K_K3362  L_L21  L_L215  0.0014
K_K3363  L_L21  L_L216  0.0013
K_K3364  L_L21  L_L217  0.0013
K_K3365  L_L21  L_L218  0.0013
K_K3366  L_L21  L_L219  0.0013
K_K3367  L_L21  L_L220  0.0012
K_K3368  L_L21  L_L221  0.0012
K_K3369  L_L21  L_L222  0.0012
K_K3370  L_L21  L_L223  0.0012
K_K3371  L_L21  L_L224  0.0012
K_K3372  L_L21  L_L225  0.0011
K_K3373  L_L21  L_L226  0.0011
K_K3374  L_L21  L_L227  0.0011
K_K3375  L_L21  L_L228  0.0011
K_K3376  L_L21  L_L229  0.0011
K_K3377  L_L21  L_L230  0.0011
K_K3378  L_L21  L_L231  0.0011
K_K3379  L_L21  L_L232  0.0010
K_K3380  L_L21  L_L233  0.0010
K_K3381  L_L21  L_L234  0.0010
* *  Branch  NTMP0000000021 - NTMP0000000022
R_R22  NTMP0000000021  nU_22  32.914993m  TC=0,0
V_Ui22  nU_22  nR_22  STIMULUS=U_IND_0000000022
R_V43  nR_22  nV_43  23.280268m  TC=0,0
L_V43  nR_22  nV_43  0.014646uH
R_V44  nV_43  nV_44  7.852787m  TC=0,0
L_V44  nV_43  nV_44  0.073723uH
L_L22  nV_44  NTMP0000000022  6.519695uH
K_K3382  L_L22  L_L23  0.1050
K_K3383  L_L22  L_L24  0.0397
K_K3384  L_L22  L_L25  0.0258
K_K3385  L_L22  L_L26  0.0192
K_K3386  L_L22  L_L27  0.0153
K_K3387  L_L22  L_L28  0.0127
K_K3388  L_L22  L_L29  0.0109
K_K3389  L_L22  L_L30  0.0095
K_K3390  L_L22  L_L31  0.0084
K_K3391  L_L22  L_L32  0.0076
K_K3392  L_L22  L_L33  0.0069
K_K3393  L_L22  L_L34  0.0063
K_K3394  L_L22  L_L35  0.0058
K_K3395  L_L22  L_L36  0.0054
K_K3396  L_L22  L_L37  0.0051
K_K3397  L_L22  L_L38  0.0047
K_K3398  L_L22  L_L39  0.0045
K_K3399  L_L22  L_L40  0.0042
K_K3400  L_L22  L_L41  0.0040
K_K3401  L_L22  L_L42  0.0038
K_K3402  L_L22  L_L43  0.0036
K_K3403  L_L22  L_L44  0.0034
K_K3404  L_L22  L_L45  0.0033
K_K3405  L_L22  L_L46  0.0032
K_K3406  L_L22  L_L47  0.0030
K_K3407  L_L22  L_L48  0.0029
K_K3408  L_L22  L_L49  0.0028
K_K3409  L_L22  L_L50  0.0027
K_K3410  L_L22  L_L51  0.0026
K_K3411  L_L22  L_L52  0.0025
K_K3412  L_L22  L_L53  0.0024
K_K3413  L_L22  L_L54  0.0024
K_K3414  L_L22  L_L55  0.0023
K_K3415  L_L22  L_L56  0.0022
K_K3416  L_L22  L_L57  0.0022
K_K3417  L_L22  L_L58  0.0021
K_K3418  L_L22  L_L59  0.0020
K_K3419  L_L22  L_L60  0.0020
K_K3420  L_L22  L_L61  0.0019
K_K3421  L_L22  L_L62  0.0019
K_K3422  L_L22  L_L63  0.0018
K_K3423  L_L22  L_L64  0.0018
K_K3424  L_L22  L_L65  0.0018
K_K3425  L_L22  L_L66  0.0017
K_K3426  L_L22  L_L67  0.0017
K_K3427  L_L22  L_L68  0.0016
K_K3428  L_L22  L_L69  0.0016
K_K3429  L_L22  L_L70  0.0016
K_K3430  L_L22  L_L71  0.0015
K_K3431  L_L22  L_L72  0.0015
K_K3432  L_L22  L_L73  0.0015
K_K3433  L_L22  L_L74  0.0015
K_K3434  L_L22  L_L75  0.0014
K_K3435  L_L22  L_L76  0.0014
K_K3436  L_L22  L_L77  0.0014
K_K3437  L_L22  L_L78  0.0014
K_K3438  L_L22  L_L79  0.0013
K_K3439  L_L22  L_L80  0.0013
K_K3440  L_L22  L_L81  0.0013
K_K3441  L_L22  L_L82  0.0013
K_K3442  L_L22  L_L83  0.0013
K_K3443  L_L22  L_L84  0.0012
K_K3444  L_L22  L_L85  0.0012
K_K3445  L_L22  L_L86  0.0012
K_K3446  L_L22  L_L87  0.0012
K_K3447  L_L22  L_L88  0.0011
K_K3448  L_L22  L_L89  0.0011
K_K3449  L_L22  L_L90  0.0011
K_K3450  L_L22  L_L91  0.0011
K_K3451  L_L22  L_L92  0.0011
K_K3452  L_L22  L_L93  0.0011
K_K3453  L_L22  L_L94  0.0011
K_K3454  L_L22  L_L95  0.0010
K_K3455  L_L22  L_L96  0.0010
K_K3456  L_L22  L_L97  0.0010
K_K3457  L_L22  L_L139  0.0036
K_K3458  L_L22  L_L140  0.0038
K_K3459  L_L22  L_L141  0.0040
K_K3460  L_L22  L_L142  0.0042
K_K3461  L_L22  L_L143  0.0045
K_K3462  L_L22  L_L144  0.0047
K_K3463  L_L22  L_L145  0.0051
K_K3464  L_L22  L_L146  0.0054
K_K3465  L_L22  L_L147  0.0058
K_K3466  L_L22  L_L148  0.0063
K_K3467  L_L22  L_L149  0.0069
K_K3468  L_L22  L_L150  0.0076
K_K3469  L_L22  L_L151  0.0084
K_K3470  L_L22  L_L152  0.0095
K_K3471  L_L22  L_L153  0.0109
K_K3472  L_L22  L_L154  0.0127
K_K3473  L_L22  L_L155  0.0152
K_K3474  L_L22  L_L156  0.0191
K_K3475  L_L22  L_L157  0.0256
K_K3476  L_L22  L_L158  0.0389
K_K3477  L_L22  L_L159  0.0812
K_K3478  L_L22  L_L160  0.1569
K_K3479  L_L22  L_L161  0.0812
K_K3480  L_L22  L_L162  0.0389
K_K3481  L_L22  L_L163  0.0256
K_K3482  L_L22  L_L164  0.0191
K_K3483  L_L22  L_L165  0.0152
K_K3484  L_L22  L_L166  0.0127
K_K3485  L_L22  L_L167  0.0109
K_K3486  L_L22  L_L168  0.0095
K_K3487  L_L22  L_L169  0.0084
K_K3488  L_L22  L_L170  0.0076
K_K3489  L_L22  L_L171  0.0069
K_K3490  L_L22  L_L172  0.0063
K_K3491  L_L22  L_L173  0.0058
K_K3492  L_L22  L_L174  0.0054
K_K3493  L_L22  L_L175  0.0051
K_K3494  L_L22  L_L176  0.0047
K_K3495  L_L22  L_L177  0.0045
K_K3496  L_L22  L_L178  0.0042
K_K3497  L_L22  L_L179  0.0040
K_K3498  L_L22  L_L180  0.0038
K_K3499  L_L22  L_L181  0.0036
K_K3500  L_L22  L_L182  0.0034
K_K3501  L_L22  L_L183  0.0033
K_K3502  L_L22  L_L184  0.0032
K_K3503  L_L22  L_L185  0.0030
K_K3504  L_L22  L_L186  0.0029
K_K3505  L_L22  L_L187  0.0028
K_K3506  L_L22  L_L188  0.0027
K_K3507  L_L22  L_L189  0.0026
K_K3508  L_L22  L_L190  0.0025
K_K3509  L_L22  L_L191  0.0024
K_K3510  L_L22  L_L192  0.0024
K_K3511  L_L22  L_L193  0.0023
K_K3512  L_L22  L_L194  0.0022
K_K3513  L_L22  L_L195  0.0022
K_K3514  L_L22  L_L196  0.0021
K_K3515  L_L22  L_L197  0.0020
K_K3516  L_L22  L_L198  0.0020
K_K3517  L_L22  L_L199  0.0019
K_K3518  L_L22  L_L200  0.0019
K_K3519  L_L22  L_L201  0.0018
K_K3520  L_L22  L_L202  0.0018
K_K3521  L_L22  L_L203  0.0018
K_K3522  L_L22  L_L204  0.0017
K_K3523  L_L22  L_L205  0.0017
K_K3524  L_L22  L_L206  0.0016
K_K3525  L_L22  L_L207  0.0016
K_K3526  L_L22  L_L208  0.0016
K_K3527  L_L22  L_L209  0.0015
K_K3528  L_L22  L_L210  0.0015
K_K3529  L_L22  L_L211  0.0015
K_K3530  L_L22  L_L212  0.0015
K_K3531  L_L22  L_L213  0.0014
K_K3532  L_L22  L_L214  0.0014
K_K3533  L_L22  L_L215  0.0014
K_K3534  L_L22  L_L216  0.0014
K_K3535  L_L22  L_L217  0.0013
K_K3536  L_L22  L_L218  0.0013
K_K3537  L_L22  L_L219  0.0013
K_K3538  L_L22  L_L220  0.0013
K_K3539  L_L22  L_L221  0.0012
K_K3540  L_L22  L_L222  0.0012
K_K3541  L_L22  L_L223  0.0012
K_K3542  L_L22  L_L224  0.0012
K_K3543  L_L22  L_L225  0.0012
K_K3544  L_L22  L_L226  0.0011
K_K3545  L_L22  L_L227  0.0011
K_K3546  L_L22  L_L228  0.0011
K_K3547  L_L22  L_L229  0.0011
K_K3548  L_L22  L_L230  0.0011
K_K3549  L_L22  L_L231  0.0011
K_K3550  L_L22  L_L232  0.0011
K_K3551  L_L22  L_L233  0.0010
K_K3552  L_L22  L_L234  0.0010
K_K3553  L_L22  L_L235  0.0010
* *  Branch  NTMP0000000022 - NTMP0000000023
R_R23  NTMP0000000022  nU_23  32.914993m  TC=0,0
V_Ui23  nU_23  nR_23  STIMULUS=U_IND_0000000023
R_V45  nR_23  nV_45  23.280268m  TC=0,0
L_V45  nR_23  nV_45  0.014646uH
R_V46  nV_45  nV_46  7.852787m  TC=0,0
L_V46  nV_45  nV_46  0.073723uH
L_L23  nV_46  NTMP0000000023  6.519695uH
K_K3554  L_L23  L_L24  0.1050
K_K3555  L_L23  L_L25  0.0397
K_K3556  L_L23  L_L26  0.0258
K_K3557  L_L23  L_L27  0.0192
K_K3558  L_L23  L_L28  0.0153
K_K3559  L_L23  L_L29  0.0127
K_K3560  L_L23  L_L30  0.0109
K_K3561  L_L23  L_L31  0.0095
K_K3562  L_L23  L_L32  0.0084
K_K3563  L_L23  L_L33  0.0076
K_K3564  L_L23  L_L34  0.0069
K_K3565  L_L23  L_L35  0.0063
K_K3566  L_L23  L_L36  0.0058
K_K3567  L_L23  L_L37  0.0054
K_K3568  L_L23  L_L38  0.0051
K_K3569  L_L23  L_L39  0.0047
K_K3570  L_L23  L_L40  0.0045
K_K3571  L_L23  L_L41  0.0042
K_K3572  L_L23  L_L42  0.0040
K_K3573  L_L23  L_L43  0.0038
K_K3574  L_L23  L_L44  0.0036
K_K3575  L_L23  L_L45  0.0034
K_K3576  L_L23  L_L46  0.0033
K_K3577  L_L23  L_L47  0.0032
K_K3578  L_L23  L_L48  0.0030
K_K3579  L_L23  L_L49  0.0029
K_K3580  L_L23  L_L50  0.0028
K_K3581  L_L23  L_L51  0.0027
K_K3582  L_L23  L_L52  0.0026
K_K3583  L_L23  L_L53  0.0025
K_K3584  L_L23  L_L54  0.0024
K_K3585  L_L23  L_L55  0.0024
K_K3586  L_L23  L_L56  0.0023
K_K3587  L_L23  L_L57  0.0022
K_K3588  L_L23  L_L58  0.0022
K_K3589  L_L23  L_L59  0.0021
K_K3590  L_L23  L_L60  0.0020
K_K3591  L_L23  L_L61  0.0020
K_K3592  L_L23  L_L62  0.0019
K_K3593  L_L23  L_L63  0.0019
K_K3594  L_L23  L_L64  0.0018
K_K3595  L_L23  L_L65  0.0018
K_K3596  L_L23  L_L66  0.0018
K_K3597  L_L23  L_L67  0.0017
K_K3598  L_L23  L_L68  0.0017
K_K3599  L_L23  L_L69  0.0016
K_K3600  L_L23  L_L70  0.0016
K_K3601  L_L23  L_L71  0.0016
K_K3602  L_L23  L_L72  0.0016
K_K3603  L_L23  L_L73  0.0015
K_K3604  L_L23  L_L74  0.0015
K_K3605  L_L23  L_L75  0.0015
K_K3606  L_L23  L_L76  0.0014
K_K3607  L_L23  L_L77  0.0014
K_K3608  L_L23  L_L78  0.0014
K_K3609  L_L23  L_L79  0.0014
K_K3610  L_L23  L_L80  0.0013
K_K3611  L_L23  L_L81  0.0013
K_K3612  L_L23  L_L82  0.0013
K_K3613  L_L23  L_L83  0.0013
K_K3614  L_L23  L_L84  0.0013
K_K3615  L_L23  L_L85  0.0012
K_K3616  L_L23  L_L86  0.0012
K_K3617  L_L23  L_L87  0.0012
K_K3618  L_L23  L_L88  0.0012
K_K3619  L_L23  L_L89  0.0011
K_K3620  L_L23  L_L90  0.0011
K_K3621  L_L23  L_L91  0.0011
K_K3622  L_L23  L_L92  0.0011
K_K3623  L_L23  L_L93  0.0011
K_K3624  L_L23  L_L94  0.0011
K_K3625  L_L23  L_L95  0.0011
K_K3626  L_L23  L_L96  0.0010
K_K3627  L_L23  L_L97  0.0010
K_K3628  L_L23  L_L98  0.0010
K_K3629  L_L23  L_L139  0.0034
K_K3630  L_L23  L_L140  0.0036
K_K3631  L_L23  L_L141  0.0038
K_K3632  L_L23  L_L142  0.0040
K_K3633  L_L23  L_L143  0.0042
K_K3634  L_L23  L_L144  0.0045
K_K3635  L_L23  L_L145  0.0047
K_K3636  L_L23  L_L146  0.0051
K_K3637  L_L23  L_L147  0.0054
K_K3638  L_L23  L_L148  0.0058
K_K3639  L_L23  L_L149  0.0063
K_K3640  L_L23  L_L150  0.0069
K_K3641  L_L23  L_L151  0.0076
K_K3642  L_L23  L_L152  0.0084
K_K3643  L_L23  L_L153  0.0095
K_K3644  L_L23  L_L154  0.0109
K_K3645  L_L23  L_L155  0.0127
K_K3646  L_L23  L_L156  0.0152
K_K3647  L_L23  L_L157  0.0191
K_K3648  L_L23  L_L158  0.0256
K_K3649  L_L23  L_L159  0.0389
K_K3650  L_L23  L_L160  0.0812
K_K3651  L_L23  L_L161  0.1569
K_K3652  L_L23  L_L162  0.0812
K_K3653  L_L23  L_L163  0.0389
K_K3654  L_L23  L_L164  0.0256
K_K3655  L_L23  L_L165  0.0191
K_K3656  L_L23  L_L166  0.0152
K_K3657  L_L23  L_L167  0.0127
K_K3658  L_L23  L_L168  0.0109
K_K3659  L_L23  L_L169  0.0095
K_K3660  L_L23  L_L170  0.0084
K_K3661  L_L23  L_L171  0.0076
K_K3662  L_L23  L_L172  0.0069
K_K3663  L_L23  L_L173  0.0063
K_K3664  L_L23  L_L174  0.0058
K_K3665  L_L23  L_L175  0.0054
K_K3666  L_L23  L_L176  0.0051
K_K3667  L_L23  L_L177  0.0047
K_K3668  L_L23  L_L178  0.0045
K_K3669  L_L23  L_L179  0.0042
K_K3670  L_L23  L_L180  0.0040
K_K3671  L_L23  L_L181  0.0038
K_K3672  L_L23  L_L182  0.0036
K_K3673  L_L23  L_L183  0.0034
K_K3674  L_L23  L_L184  0.0033
K_K3675  L_L23  L_L185  0.0032
K_K3676  L_L23  L_L186  0.0030
K_K3677  L_L23  L_L187  0.0029
K_K3678  L_L23  L_L188  0.0028
K_K3679  L_L23  L_L189  0.0027
K_K3680  L_L23  L_L190  0.0026
K_K3681  L_L23  L_L191  0.0025
K_K3682  L_L23  L_L192  0.0024
K_K3683  L_L23  L_L193  0.0024
K_K3684  L_L23  L_L194  0.0023
K_K3685  L_L23  L_L195  0.0022
K_K3686  L_L23  L_L196  0.0022
K_K3687  L_L23  L_L197  0.0021
K_K3688  L_L23  L_L198  0.0020
K_K3689  L_L23  L_L199  0.0020
K_K3690  L_L23  L_L200  0.0019
K_K3691  L_L23  L_L201  0.0019
K_K3692  L_L23  L_L202  0.0018
K_K3693  L_L23  L_L203  0.0018
K_K3694  L_L23  L_L204  0.0018
K_K3695  L_L23  L_L205  0.0017
K_K3696  L_L23  L_L206  0.0017
K_K3697  L_L23  L_L207  0.0016
K_K3698  L_L23  L_L208  0.0016
K_K3699  L_L23  L_L209  0.0016
K_K3700  L_L23  L_L210  0.0015
K_K3701  L_L23  L_L211  0.0015
K_K3702  L_L23  L_L212  0.0015
K_K3703  L_L23  L_L213  0.0015
K_K3704  L_L23  L_L214  0.0014
K_K3705  L_L23  L_L215  0.0014
K_K3706  L_L23  L_L216  0.0014
K_K3707  L_L23  L_L217  0.0014
K_K3708  L_L23  L_L218  0.0013
K_K3709  L_L23  L_L219  0.0013
K_K3710  L_L23  L_L220  0.0013
K_K3711  L_L23  L_L221  0.0013
K_K3712  L_L23  L_L222  0.0012
K_K3713  L_L23  L_L223  0.0012
K_K3714  L_L23  L_L224  0.0012
K_K3715  L_L23  L_L225  0.0012
K_K3716  L_L23  L_L226  0.0012
K_K3717  L_L23  L_L227  0.0011
K_K3718  L_L23  L_L228  0.0011
K_K3719  L_L23  L_L229  0.0011
K_K3720  L_L23  L_L230  0.0011
K_K3721  L_L23  L_L231  0.0011
K_K3722  L_L23  L_L232  0.0011
K_K3723  L_L23  L_L233  0.0011
K_K3724  L_L23  L_L234  0.0010
K_K3725  L_L23  L_L235  0.0010
K_K3726  L_L23  L_L236  0.0010
* *  Branch  NTMP0000000023 - NTMP0000000024
R_R24  NTMP0000000023  nU_24  32.914993m  TC=0,0
V_Ui24  nU_24  nR_24  STIMULUS=U_IND_0000000024
R_V47  nR_24  nV_47  23.280268m  TC=0,0
L_V47  nR_24  nV_47  0.014646uH
R_V48  nV_47  nV_48  7.852787m  TC=0,0
L_V48  nV_47  nV_48  0.073723uH
L_L24  nV_48  NTMP0000000024  6.519695uH
K_K3727  L_L24  L_L25  0.1050
K_K3728  L_L24  L_L26  0.0397
K_K3729  L_L24  L_L27  0.0258
K_K3730  L_L24  L_L28  0.0192
K_K3731  L_L24  L_L29  0.0153
K_K3732  L_L24  L_L30  0.0127
K_K3733  L_L24  L_L31  0.0109
K_K3734  L_L24  L_L32  0.0095
K_K3735  L_L24  L_L33  0.0084
K_K3736  L_L24  L_L34  0.0076
K_K3737  L_L24  L_L35  0.0069
K_K3738  L_L24  L_L36  0.0063
K_K3739  L_L24  L_L37  0.0058
K_K3740  L_L24  L_L38  0.0054
K_K3741  L_L24  L_L39  0.0051
K_K3742  L_L24  L_L40  0.0047
K_K3743  L_L24  L_L41  0.0045
K_K3744  L_L24  L_L42  0.0042
K_K3745  L_L24  L_L43  0.0040
K_K3746  L_L24  L_L44  0.0038
K_K3747  L_L24  L_L45  0.0036
K_K3748  L_L24  L_L46  0.0034
K_K3749  L_L24  L_L47  0.0033
K_K3750  L_L24  L_L48  0.0032
K_K3751  L_L24  L_L49  0.0030
K_K3752  L_L24  L_L50  0.0029
K_K3753  L_L24  L_L51  0.0028
K_K3754  L_L24  L_L52  0.0027
K_K3755  L_L24  L_L53  0.0026
K_K3756  L_L24  L_L54  0.0025
K_K3757  L_L24  L_L55  0.0024
K_K3758  L_L24  L_L56  0.0024
K_K3759  L_L24  L_L57  0.0023
K_K3760  L_L24  L_L58  0.0022
K_K3761  L_L24  L_L59  0.0022
K_K3762  L_L24  L_L60  0.0021
K_K3763  L_L24  L_L61  0.0020
K_K3764  L_L24  L_L62  0.0020
K_K3765  L_L24  L_L63  0.0019
K_K3766  L_L24  L_L64  0.0019
K_K3767  L_L24  L_L65  0.0018
K_K3768  L_L24  L_L66  0.0018
K_K3769  L_L24  L_L67  0.0018
K_K3770  L_L24  L_L68  0.0017
K_K3771  L_L24  L_L69  0.0017
K_K3772  L_L24  L_L70  0.0016
K_K3773  L_L24  L_L71  0.0016
K_K3774  L_L24  L_L72  0.0016
K_K3775  L_L24  L_L73  0.0016
K_K3776  L_L24  L_L74  0.0015
K_K3777  L_L24  L_L75  0.0015
K_K3778  L_L24  L_L76  0.0015
K_K3779  L_L24  L_L77  0.0014
K_K3780  L_L24  L_L78  0.0014
K_K3781  L_L24  L_L79  0.0014
K_K3782  L_L24  L_L80  0.0014
K_K3783  L_L24  L_L81  0.0013
K_K3784  L_L24  L_L82  0.0013
K_K3785  L_L24  L_L83  0.0013
K_K3786  L_L24  L_L84  0.0013
K_K3787  L_L24  L_L85  0.0013
K_K3788  L_L24  L_L86  0.0012
K_K3789  L_L24  L_L87  0.0012
K_K3790  L_L24  L_L88  0.0012
K_K3791  L_L24  L_L89  0.0012
K_K3792  L_L24  L_L90  0.0011
K_K3793  L_L24  L_L91  0.0011
K_K3794  L_L24  L_L92  0.0011
K_K3795  L_L24  L_L93  0.0011
K_K3796  L_L24  L_L94  0.0011
K_K3797  L_L24  L_L95  0.0011
K_K3798  L_L24  L_L96  0.0011
K_K3799  L_L24  L_L97  0.0010
K_K3800  L_L24  L_L98  0.0010
K_K3801  L_L24  L_L99  0.0010
K_K3802  L_L24  L_L139  0.0033
K_K3803  L_L24  L_L140  0.0034
K_K3804  L_L24  L_L141  0.0036
K_K3805  L_L24  L_L142  0.0038
K_K3806  L_L24  L_L143  0.0040
K_K3807  L_L24  L_L144  0.0042
K_K3808  L_L24  L_L145  0.0045
K_K3809  L_L24  L_L146  0.0047
K_K3810  L_L24  L_L147  0.0051
K_K3811  L_L24  L_L148  0.0054
K_K3812  L_L24  L_L149  0.0058
K_K3813  L_L24  L_L150  0.0063
K_K3814  L_L24  L_L151  0.0069
K_K3815  L_L24  L_L152  0.0076
K_K3816  L_L24  L_L153  0.0084
K_K3817  L_L24  L_L154  0.0095
K_K3818  L_L24  L_L155  0.0109
K_K3819  L_L24  L_L156  0.0127
K_K3820  L_L24  L_L157  0.0152
K_K3821  L_L24  L_L158  0.0191
K_K3822  L_L24  L_L159  0.0256
K_K3823  L_L24  L_L160  0.0389
K_K3824  L_L24  L_L161  0.0812
K_K3825  L_L24  L_L162  0.1569
K_K3826  L_L24  L_L163  0.0812
K_K3827  L_L24  L_L164  0.0389
K_K3828  L_L24  L_L165  0.0256
K_K3829  L_L24  L_L166  0.0191
K_K3830  L_L24  L_L167  0.0152
K_K3831  L_L24  L_L168  0.0127
K_K3832  L_L24  L_L169  0.0109
K_K3833  L_L24  L_L170  0.0095
K_K3834  L_L24  L_L171  0.0084
K_K3835  L_L24  L_L172  0.0076
K_K3836  L_L24  L_L173  0.0069
K_K3837  L_L24  L_L174  0.0063
K_K3838  L_L24  L_L175  0.0058
K_K3839  L_L24  L_L176  0.0054
K_K3840  L_L24  L_L177  0.0051
K_K3841  L_L24  L_L178  0.0047
K_K3842  L_L24  L_L179  0.0045
K_K3843  L_L24  L_L180  0.0042
K_K3844  L_L24  L_L181  0.0040
K_K3845  L_L24  L_L182  0.0038
K_K3846  L_L24  L_L183  0.0036
K_K3847  L_L24  L_L184  0.0034
K_K3848  L_L24  L_L185  0.0033
K_K3849  L_L24  L_L186  0.0032
K_K3850  L_L24  L_L187  0.0030
K_K3851  L_L24  L_L188  0.0029
K_K3852  L_L24  L_L189  0.0028
K_K3853  L_L24  L_L190  0.0027
K_K3854  L_L24  L_L191  0.0026
K_K3855  L_L24  L_L192  0.0025
K_K3856  L_L24  L_L193  0.0024
K_K3857  L_L24  L_L194  0.0024
K_K3858  L_L24  L_L195  0.0023
K_K3859  L_L24  L_L196  0.0022
K_K3860  L_L24  L_L197  0.0022
K_K3861  L_L24  L_L198  0.0021
K_K3862  L_L24  L_L199  0.0020
K_K3863  L_L24  L_L200  0.0020
K_K3864  L_L24  L_L201  0.0019
K_K3865  L_L24  L_L202  0.0019
K_K3866  L_L24  L_L203  0.0018
K_K3867  L_L24  L_L204  0.0018
K_K3868  L_L24  L_L205  0.0018
K_K3869  L_L24  L_L206  0.0017
K_K3870  L_L24  L_L207  0.0017
K_K3871  L_L24  L_L208  0.0016
K_K3872  L_L24  L_L209  0.0016
K_K3873  L_L24  L_L210  0.0016
K_K3874  L_L24  L_L211  0.0015
K_K3875  L_L24  L_L212  0.0015
K_K3876  L_L24  L_L213  0.0015
K_K3877  L_L24  L_L214  0.0015
K_K3878  L_L24  L_L215  0.0014
K_K3879  L_L24  L_L216  0.0014
K_K3880  L_L24  L_L217  0.0014
K_K3881  L_L24  L_L218  0.0014
K_K3882  L_L24  L_L219  0.0013
K_K3883  L_L24  L_L220  0.0013
K_K3884  L_L24  L_L221  0.0013
K_K3885  L_L24  L_L222  0.0013
K_K3886  L_L24  L_L223  0.0012
K_K3887  L_L24  L_L224  0.0012
K_K3888  L_L24  L_L225  0.0012
K_K3889  L_L24  L_L226  0.0012
K_K3890  L_L24  L_L227  0.0012
K_K3891  L_L24  L_L228  0.0011
K_K3892  L_L24  L_L229  0.0011
K_K3893  L_L24  L_L230  0.0011
K_K3894  L_L24  L_L231  0.0011
K_K3895  L_L24  L_L232  0.0011
K_K3896  L_L24  L_L233  0.0011
K_K3897  L_L24  L_L234  0.0011
K_K3898  L_L24  L_L235  0.0010
K_K3899  L_L24  L_L236  0.0010
K_K3900  L_L24  L_L237  0.0010
* *  Branch  NTMP0000000024 - NTMP0000000025
R_R25  NTMP0000000024  nU_25  32.914993m  TC=0,0
V_Ui25  nU_25  nR_25  STIMULUS=U_IND_0000000025
R_V49  nR_25  nV_49  23.280268m  TC=0,0
L_V49  nR_25  nV_49  0.014646uH
R_V50  nV_49  nV_50  7.852787m  TC=0,0
L_V50  nV_49  nV_50  0.073723uH
L_L25  nV_50  NTMP0000000025  6.519695uH
K_K3901  L_L25  L_L26  0.1050
K_K3902  L_L25  L_L27  0.0397
K_K3903  L_L25  L_L28  0.0258
K_K3904  L_L25  L_L29  0.0192
K_K3905  L_L25  L_L30  0.0153
K_K3906  L_L25  L_L31  0.0127
K_K3907  L_L25  L_L32  0.0109
K_K3908  L_L25  L_L33  0.0095
K_K3909  L_L25  L_L34  0.0084
K_K3910  L_L25  L_L35  0.0076
K_K3911  L_L25  L_L36  0.0069
K_K3912  L_L25  L_L37  0.0063
K_K3913  L_L25  L_L38  0.0058
K_K3914  L_L25  L_L39  0.0054
K_K3915  L_L25  L_L40  0.0051
K_K3916  L_L25  L_L41  0.0047
K_K3917  L_L25  L_L42  0.0045
K_K3918  L_L25  L_L43  0.0042
K_K3919  L_L25  L_L44  0.0040
K_K3920  L_L25  L_L45  0.0038
K_K3921  L_L25  L_L46  0.0036
K_K3922  L_L25  L_L47  0.0034
K_K3923  L_L25  L_L48  0.0033
K_K3924  L_L25  L_L49  0.0032
K_K3925  L_L25  L_L50  0.0030
K_K3926  L_L25  L_L51  0.0029
K_K3927  L_L25  L_L52  0.0028
K_K3928  L_L25  L_L53  0.0027
K_K3929  L_L25  L_L54  0.0026
K_K3930  L_L25  L_L55  0.0025
K_K3931  L_L25  L_L56  0.0024
K_K3932  L_L25  L_L57  0.0024
K_K3933  L_L25  L_L58  0.0023
K_K3934  L_L25  L_L59  0.0022
K_K3935  L_L25  L_L60  0.0022
K_K3936  L_L25  L_L61  0.0021
K_K3937  L_L25  L_L62  0.0020
K_K3938  L_L25  L_L63  0.0020
K_K3939  L_L25  L_L64  0.0019
K_K3940  L_L25  L_L65  0.0019
K_K3941  L_L25  L_L66  0.0018
K_K3942  L_L25  L_L67  0.0018
K_K3943  L_L25  L_L68  0.0018
K_K3944  L_L25  L_L69  0.0017
K_K3945  L_L25  L_L70  0.0017
K_K3946  L_L25  L_L71  0.0016
K_K3947  L_L25  L_L72  0.0016
K_K3948  L_L25  L_L73  0.0016
K_K3949  L_L25  L_L74  0.0016
K_K3950  L_L25  L_L75  0.0015
K_K3951  L_L25  L_L76  0.0015
K_K3952  L_L25  L_L77  0.0015
K_K3953  L_L25  L_L78  0.0014
K_K3954  L_L25  L_L79  0.0014
K_K3955  L_L25  L_L80  0.0014
K_K3956  L_L25  L_L81  0.0014
K_K3957  L_L25  L_L82  0.0013
K_K3958  L_L25  L_L83  0.0013
K_K3959  L_L25  L_L84  0.0013
K_K3960  L_L25  L_L85  0.0013
K_K3961  L_L25  L_L86  0.0013
K_K3962  L_L25  L_L87  0.0012
K_K3963  L_L25  L_L88  0.0012
K_K3964  L_L25  L_L89  0.0012
K_K3965  L_L25  L_L90  0.0012
K_K3966  L_L25  L_L91  0.0011
K_K3967  L_L25  L_L92  0.0011
K_K3968  L_L25  L_L93  0.0011
K_K3969  L_L25  L_L94  0.0011
K_K3970  L_L25  L_L95  0.0011
K_K3971  L_L25  L_L96  0.0011
K_K3972  L_L25  L_L97  0.0011
K_K3973  L_L25  L_L98  0.0010
K_K3974  L_L25  L_L99  0.0010
K_K3975  L_L25  L_L100  0.0010
K_K3976  L_L25  L_L139  0.0032
K_K3977  L_L25  L_L140  0.0033
K_K3978  L_L25  L_L141  0.0034
K_K3979  L_L25  L_L142  0.0036
K_K3980  L_L25  L_L143  0.0038
K_K3981  L_L25  L_L144  0.0040
K_K3982  L_L25  L_L145  0.0042
K_K3983  L_L25  L_L146  0.0045
K_K3984  L_L25  L_L147  0.0047
K_K3985  L_L25  L_L148  0.0051
K_K3986  L_L25  L_L149  0.0054
K_K3987  L_L25  L_L150  0.0058
K_K3988  L_L25  L_L151  0.0063
K_K3989  L_L25  L_L152  0.0069
K_K3990  L_L25  L_L153  0.0076
K_K3991  L_L25  L_L154  0.0084
K_K3992  L_L25  L_L155  0.0095
K_K3993  L_L25  L_L156  0.0109
K_K3994  L_L25  L_L157  0.0127
K_K3995  L_L25  L_L158  0.0152
K_K3996  L_L25  L_L159  0.0191
K_K3997  L_L25  L_L160  0.0256
K_K3998  L_L25  L_L161  0.0389
K_K3999  L_L25  L_L162  0.0812
K_K4000  L_L25  L_L163  0.1569
K_K4001  L_L25  L_L164  0.0812
K_K4002  L_L25  L_L165  0.0389
K_K4003  L_L25  L_L166  0.0256
K_K4004  L_L25  L_L167  0.0191
K_K4005  L_L25  L_L168  0.0152
K_K4006  L_L25  L_L169  0.0127
K_K4007  L_L25  L_L170  0.0109
K_K4008  L_L25  L_L171  0.0095
K_K4009  L_L25  L_L172  0.0084
K_K4010  L_L25  L_L173  0.0076
K_K4011  L_L25  L_L174  0.0069
K_K4012  L_L25  L_L175  0.0063
K_K4013  L_L25  L_L176  0.0058
K_K4014  L_L25  L_L177  0.0054
K_K4015  L_L25  L_L178  0.0051
K_K4016  L_L25  L_L179  0.0047
K_K4017  L_L25  L_L180  0.0045
K_K4018  L_L25  L_L181  0.0042
K_K4019  L_L25  L_L182  0.0040
K_K4020  L_L25  L_L183  0.0038
K_K4021  L_L25  L_L184  0.0036
K_K4022  L_L25  L_L185  0.0034
K_K4023  L_L25  L_L186  0.0033
K_K4024  L_L25  L_L187  0.0032
K_K4025  L_L25  L_L188  0.0030
K_K4026  L_L25  L_L189  0.0029
K_K4027  L_L25  L_L190  0.0028
K_K4028  L_L25  L_L191  0.0027
K_K4029  L_L25  L_L192  0.0026
K_K4030  L_L25  L_L193  0.0025
K_K4031  L_L25  L_L194  0.0024
K_K4032  L_L25  L_L195  0.0024
K_K4033  L_L25  L_L196  0.0023
K_K4034  L_L25  L_L197  0.0022
K_K4035  L_L25  L_L198  0.0022
K_K4036  L_L25  L_L199  0.0021
K_K4037  L_L25  L_L200  0.0020
K_K4038  L_L25  L_L201  0.0020
K_K4039  L_L25  L_L202  0.0019
K_K4040  L_L25  L_L203  0.0019
K_K4041  L_L25  L_L204  0.0018
K_K4042  L_L25  L_L205  0.0018
K_K4043  L_L25  L_L206  0.0018
K_K4044  L_L25  L_L207  0.0017
K_K4045  L_L25  L_L208  0.0017
K_K4046  L_L25  L_L209  0.0016
K_K4047  L_L25  L_L210  0.0016
K_K4048  L_L25  L_L211  0.0016
K_K4049  L_L25  L_L212  0.0015
K_K4050  L_L25  L_L213  0.0015
K_K4051  L_L25  L_L214  0.0015
K_K4052  L_L25  L_L215  0.0015
K_K4053  L_L25  L_L216  0.0014
K_K4054  L_L25  L_L217  0.0014
K_K4055  L_L25  L_L218  0.0014
K_K4056  L_L25  L_L219  0.0014
K_K4057  L_L25  L_L220  0.0013
K_K4058  L_L25  L_L221  0.0013
K_K4059  L_L25  L_L222  0.0013
K_K4060  L_L25  L_L223  0.0013
K_K4061  L_L25  L_L224  0.0012
K_K4062  L_L25  L_L225  0.0012
K_K4063  L_L25  L_L226  0.0012
K_K4064  L_L25  L_L227  0.0012
K_K4065  L_L25  L_L228  0.0012
K_K4066  L_L25  L_L229  0.0011
K_K4067  L_L25  L_L230  0.0011
K_K4068  L_L25  L_L231  0.0011
K_K4069  L_L25  L_L232  0.0011
K_K4070  L_L25  L_L233  0.0011
K_K4071  L_L25  L_L234  0.0011
K_K4072  L_L25  L_L235  0.0011
K_K4073  L_L25  L_L236  0.0010
K_K4074  L_L25  L_L237  0.0010
K_K4075  L_L25  L_L238  0.0010
* *  Branch  NTMP0000000025 - NTMP0000000026
R_R26  NTMP0000000025  nU_26  32.914993m  TC=0,0
V_Ui26  nU_26  nR_26  STIMULUS=U_IND_0000000026
R_V51  nR_26  nV_51  23.280268m  TC=0,0
L_V51  nR_26  nV_51  0.014646uH
R_V52  nV_51  nV_52  7.852787m  TC=0,0
L_V52  nV_51  nV_52  0.073723uH
L_L26  nV_52  NTMP0000000026  6.519695uH
K_K4076  L_L26  L_L27  0.1050
K_K4077  L_L26  L_L28  0.0397
K_K4078  L_L26  L_L29  0.0258
K_K4079  L_L26  L_L30  0.0192
K_K4080  L_L26  L_L31  0.0153
K_K4081  L_L26  L_L32  0.0127
K_K4082  L_L26  L_L33  0.0109
K_K4083  L_L26  L_L34  0.0095
K_K4084  L_L26  L_L35  0.0084
K_K4085  L_L26  L_L36  0.0076
K_K4086  L_L26  L_L37  0.0069
K_K4087  L_L26  L_L38  0.0063
K_K4088  L_L26  L_L39  0.0058
K_K4089  L_L26  L_L40  0.0054
K_K4090  L_L26  L_L41  0.0051
K_K4091  L_L26  L_L42  0.0047
K_K4092  L_L26  L_L43  0.0045
K_K4093  L_L26  L_L44  0.0042
K_K4094  L_L26  L_L45  0.0040
K_K4095  L_L26  L_L46  0.0038
K_K4096  L_L26  L_L47  0.0036
K_K4097  L_L26  L_L48  0.0034
K_K4098  L_L26  L_L49  0.0033
K_K4099  L_L26  L_L50  0.0032
K_K4100  L_L26  L_L51  0.0030
K_K4101  L_L26  L_L52  0.0029
K_K4102  L_L26  L_L53  0.0028
K_K4103  L_L26  L_L54  0.0027
K_K4104  L_L26  L_L55  0.0026
K_K4105  L_L26  L_L56  0.0025
K_K4106  L_L26  L_L57  0.0024
K_K4107  L_L26  L_L58  0.0024
K_K4108  L_L26  L_L59  0.0023
K_K4109  L_L26  L_L60  0.0022
K_K4110  L_L26  L_L61  0.0022
K_K4111  L_L26  L_L62  0.0021
K_K4112  L_L26  L_L63  0.0020
K_K4113  L_L26  L_L64  0.0020
K_K4114  L_L26  L_L65  0.0019
K_K4115  L_L26  L_L66  0.0019
K_K4116  L_L26  L_L67  0.0018
K_K4117  L_L26  L_L68  0.0018
K_K4118  L_L26  L_L69  0.0018
K_K4119  L_L26  L_L70  0.0017
K_K4120  L_L26  L_L71  0.0017
K_K4121  L_L26  L_L72  0.0016
K_K4122  L_L26  L_L73  0.0016
K_K4123  L_L26  L_L74  0.0016
K_K4124  L_L26  L_L75  0.0016
K_K4125  L_L26  L_L76  0.0015
K_K4126  L_L26  L_L77  0.0015
K_K4127  L_L26  L_L78  0.0015
K_K4128  L_L26  L_L79  0.0014
K_K4129  L_L26  L_L80  0.0014
K_K4130  L_L26  L_L81  0.0014
K_K4131  L_L26  L_L82  0.0014
K_K4132  L_L26  L_L83  0.0013
K_K4133  L_L26  L_L84  0.0013
K_K4134  L_L26  L_L85  0.0013
K_K4135  L_L26  L_L86  0.0013
K_K4136  L_L26  L_L87  0.0013
K_K4137  L_L26  L_L88  0.0012
K_K4138  L_L26  L_L89  0.0012
K_K4139  L_L26  L_L90  0.0012
K_K4140  L_L26  L_L91  0.0012
K_K4141  L_L26  L_L92  0.0011
K_K4142  L_L26  L_L93  0.0011
K_K4143  L_L26  L_L94  0.0011
K_K4144  L_L26  L_L95  0.0011
K_K4145  L_L26  L_L96  0.0011
K_K4146  L_L26  L_L97  0.0011
K_K4147  L_L26  L_L98  0.0011
K_K4148  L_L26  L_L99  0.0010
K_K4149  L_L26  L_L100  0.0010
K_K4150  L_L26  L_L101  0.0010
K_K4151  L_L26  L_L139  0.0030
K_K4152  L_L26  L_L140  0.0032
K_K4153  L_L26  L_L141  0.0033
K_K4154  L_L26  L_L142  0.0034
K_K4155  L_L26  L_L143  0.0036
K_K4156  L_L26  L_L144  0.0038
K_K4157  L_L26  L_L145  0.0040
K_K4158  L_L26  L_L146  0.0042
K_K4159  L_L26  L_L147  0.0045
K_K4160  L_L26  L_L148  0.0047
K_K4161  L_L26  L_L149  0.0051
K_K4162  L_L26  L_L150  0.0054
K_K4163  L_L26  L_L151  0.0058
K_K4164  L_L26  L_L152  0.0063
K_K4165  L_L26  L_L153  0.0069
K_K4166  L_L26  L_L154  0.0076
K_K4167  L_L26  L_L155  0.0084
K_K4168  L_L26  L_L156  0.0095
K_K4169  L_L26  L_L157  0.0109
K_K4170  L_L26  L_L158  0.0127
K_K4171  L_L26  L_L159  0.0152
K_K4172  L_L26  L_L160  0.0191
K_K4173  L_L26  L_L161  0.0256
K_K4174  L_L26  L_L162  0.0389
K_K4175  L_L26  L_L163  0.0812
K_K4176  L_L26  L_L164  0.1569
K_K4177  L_L26  L_L165  0.0812
K_K4178  L_L26  L_L166  0.0389
K_K4179  L_L26  L_L167  0.0256
K_K4180  L_L26  L_L168  0.0191
K_K4181  L_L26  L_L169  0.0152
K_K4182  L_L26  L_L170  0.0127
K_K4183  L_L26  L_L171  0.0109
K_K4184  L_L26  L_L172  0.0095
K_K4185  L_L26  L_L173  0.0084
K_K4186  L_L26  L_L174  0.0076
K_K4187  L_L26  L_L175  0.0069
K_K4188  L_L26  L_L176  0.0063
K_K4189  L_L26  L_L177  0.0058
K_K4190  L_L26  L_L178  0.0054
K_K4191  L_L26  L_L179  0.0051
K_K4192  L_L26  L_L180  0.0047
K_K4193  L_L26  L_L181  0.0045
K_K4194  L_L26  L_L182  0.0042
K_K4195  L_L26  L_L183  0.0040
K_K4196  L_L26  L_L184  0.0038
K_K4197  L_L26  L_L185  0.0036
K_K4198  L_L26  L_L186  0.0034
K_K4199  L_L26  L_L187  0.0033
K_K4200  L_L26  L_L188  0.0032
K_K4201  L_L26  L_L189  0.0030
K_K4202  L_L26  L_L190  0.0029
K_K4203  L_L26  L_L191  0.0028
K_K4204  L_L26  L_L192  0.0027
K_K4205  L_L26  L_L193  0.0026
K_K4206  L_L26  L_L194  0.0025
K_K4207  L_L26  L_L195  0.0024
K_K4208  L_L26  L_L196  0.0024
K_K4209  L_L26  L_L197  0.0023
K_K4210  L_L26  L_L198  0.0022
K_K4211  L_L26  L_L199  0.0022
K_K4212  L_L26  L_L200  0.0021
K_K4213  L_L26  L_L201  0.0020
K_K4214  L_L26  L_L202  0.0020
K_K4215  L_L26  L_L203  0.0019
K_K4216  L_L26  L_L204  0.0019
K_K4217  L_L26  L_L205  0.0018
K_K4218  L_L26  L_L206  0.0018
K_K4219  L_L26  L_L207  0.0018
K_K4220  L_L26  L_L208  0.0017
K_K4221  L_L26  L_L209  0.0017
K_K4222  L_L26  L_L210  0.0016
K_K4223  L_L26  L_L211  0.0016
K_K4224  L_L26  L_L212  0.0016
K_K4225  L_L26  L_L213  0.0015
K_K4226  L_L26  L_L214  0.0015
K_K4227  L_L26  L_L215  0.0015
K_K4228  L_L26  L_L216  0.0015
K_K4229  L_L26  L_L217  0.0014
K_K4230  L_L26  L_L218  0.0014
K_K4231  L_L26  L_L219  0.0014
K_K4232  L_L26  L_L220  0.0014
K_K4233  L_L26  L_L221  0.0013
K_K4234  L_L26  L_L222  0.0013
K_K4235  L_L26  L_L223  0.0013
K_K4236  L_L26  L_L224  0.0013
K_K4237  L_L26  L_L225  0.0012
K_K4238  L_L26  L_L226  0.0012
K_K4239  L_L26  L_L227  0.0012
K_K4240  L_L26  L_L228  0.0012
K_K4241  L_L26  L_L229  0.0012
K_K4242  L_L26  L_L230  0.0011
K_K4243  L_L26  L_L231  0.0011
K_K4244  L_L26  L_L232  0.0011
K_K4245  L_L26  L_L233  0.0011
K_K4246  L_L26  L_L234  0.0011
K_K4247  L_L26  L_L235  0.0011
K_K4248  L_L26  L_L236  0.0011
K_K4249  L_L26  L_L237  0.0010
K_K4250  L_L26  L_L238  0.0010
K_K4251  L_L26  L_L239  0.0010
* *  Branch  NTMP0000000026 - NTMP0000000027
R_R27  NTMP0000000026  nU_27  32.914993m  TC=0,0
V_Ui27  nU_27  nR_27  STIMULUS=U_IND_0000000027
R_V53  nR_27  nV_53  23.280268m  TC=0,0
L_V53  nR_27  nV_53  0.014646uH
R_V54  nV_53  nV_54  7.852787m  TC=0,0
L_V54  nV_53  nV_54  0.073723uH
L_L27  nV_54  NTMP0000000027  6.519695uH
K_K4252  L_L27  L_L28  0.1050
K_K4253  L_L27  L_L29  0.0397
K_K4254  L_L27  L_L30  0.0258
K_K4255  L_L27  L_L31  0.0192
K_K4256  L_L27  L_L32  0.0153
K_K4257  L_L27  L_L33  0.0127
K_K4258  L_L27  L_L34  0.0109
K_K4259  L_L27  L_L35  0.0095
K_K4260  L_L27  L_L36  0.0084
K_K4261  L_L27  L_L37  0.0076
K_K4262  L_L27  L_L38  0.0069
K_K4263  L_L27  L_L39  0.0063
K_K4264  L_L27  L_L40  0.0058
K_K4265  L_L27  L_L41  0.0054
K_K4266  L_L27  L_L42  0.0051
K_K4267  L_L27  L_L43  0.0047
K_K4268  L_L27  L_L44  0.0045
K_K4269  L_L27  L_L45  0.0042
K_K4270  L_L27  L_L46  0.0040
K_K4271  L_L27  L_L47  0.0038
K_K4272  L_L27  L_L48  0.0036
K_K4273  L_L27  L_L49  0.0034
K_K4274  L_L27  L_L50  0.0033
K_K4275  L_L27  L_L51  0.0032
K_K4276  L_L27  L_L52  0.0030
K_K4277  L_L27  L_L53  0.0029
K_K4278  L_L27  L_L54  0.0028
K_K4279  L_L27  L_L55  0.0027
K_K4280  L_L27  L_L56  0.0026
K_K4281  L_L27  L_L57  0.0025
K_K4282  L_L27  L_L58  0.0024
K_K4283  L_L27  L_L59  0.0024
K_K4284  L_L27  L_L60  0.0023
K_K4285  L_L27  L_L61  0.0022
K_K4286  L_L27  L_L62  0.0022
K_K4287  L_L27  L_L63  0.0021
K_K4288  L_L27  L_L64  0.0020
K_K4289  L_L27  L_L65  0.0020
K_K4290  L_L27  L_L66  0.0019
K_K4291  L_L27  L_L67  0.0019
K_K4292  L_L27  L_L68  0.0018
K_K4293  L_L27  L_L69  0.0018
K_K4294  L_L27  L_L70  0.0018
K_K4295  L_L27  L_L71  0.0017
K_K4296  L_L27  L_L72  0.0017
K_K4297  L_L27  L_L73  0.0016
K_K4298  L_L27  L_L74  0.0016
K_K4299  L_L27  L_L75  0.0016
K_K4300  L_L27  L_L76  0.0016
K_K4301  L_L27  L_L77  0.0015
K_K4302  L_L27  L_L78  0.0015
K_K4303  L_L27  L_L79  0.0015
K_K4304  L_L27  L_L80  0.0014
K_K4305  L_L27  L_L81  0.0014
K_K4306  L_L27  L_L82  0.0014
K_K4307  L_L27  L_L83  0.0014
K_K4308  L_L27  L_L84  0.0013
K_K4309  L_L27  L_L85  0.0013
K_K4310  L_L27  L_L86  0.0013
K_K4311  L_L27  L_L87  0.0013
K_K4312  L_L27  L_L88  0.0013
K_K4313  L_L27  L_L89  0.0012
K_K4314  L_L27  L_L90  0.0012
K_K4315  L_L27  L_L91  0.0012
K_K4316  L_L27  L_L92  0.0012
K_K4317  L_L27  L_L93  0.0011
K_K4318  L_L27  L_L94  0.0011
K_K4319  L_L27  L_L95  0.0011
K_K4320  L_L27  L_L96  0.0011
K_K4321  L_L27  L_L97  0.0011
K_K4322  L_L27  L_L98  0.0011
K_K4323  L_L27  L_L99  0.0011
K_K4324  L_L27  L_L100  0.0010
K_K4325  L_L27  L_L101  0.0010
K_K4326  L_L27  L_L102  0.0010
K_K4327  L_L27  L_L139  0.0029
K_K4328  L_L27  L_L140  0.0030
K_K4329  L_L27  L_L141  0.0032
K_K4330  L_L27  L_L142  0.0033
K_K4331  L_L27  L_L143  0.0034
K_K4332  L_L27  L_L144  0.0036
K_K4333  L_L27  L_L145  0.0038
K_K4334  L_L27  L_L146  0.0040
K_K4335  L_L27  L_L147  0.0042
K_K4336  L_L27  L_L148  0.0045
K_K4337  L_L27  L_L149  0.0047
K_K4338  L_L27  L_L150  0.0051
K_K4339  L_L27  L_L151  0.0054
K_K4340  L_L27  L_L152  0.0058
K_K4341  L_L27  L_L153  0.0063
K_K4342  L_L27  L_L154  0.0069
K_K4343  L_L27  L_L155  0.0076
K_K4344  L_L27  L_L156  0.0084
K_K4345  L_L27  L_L157  0.0095
K_K4346  L_L27  L_L158  0.0109
K_K4347  L_L27  L_L159  0.0127
K_K4348  L_L27  L_L160  0.0152
K_K4349  L_L27  L_L161  0.0191
K_K4350  L_L27  L_L162  0.0256
K_K4351  L_L27  L_L163  0.0389
K_K4352  L_L27  L_L164  0.0812
K_K4353  L_L27  L_L165  0.1569
K_K4354  L_L27  L_L166  0.0812
K_K4355  L_L27  L_L167  0.0389
K_K4356  L_L27  L_L168  0.0256
K_K4357  L_L27  L_L169  0.0191
K_K4358  L_L27  L_L170  0.0152
K_K4359  L_L27  L_L171  0.0127
K_K4360  L_L27  L_L172  0.0109
K_K4361  L_L27  L_L173  0.0095
K_K4362  L_L27  L_L174  0.0084
K_K4363  L_L27  L_L175  0.0076
K_K4364  L_L27  L_L176  0.0069
K_K4365  L_L27  L_L177  0.0063
K_K4366  L_L27  L_L178  0.0058
K_K4367  L_L27  L_L179  0.0054
K_K4368  L_L27  L_L180  0.0051
K_K4369  L_L27  L_L181  0.0047
K_K4370  L_L27  L_L182  0.0045
K_K4371  L_L27  L_L183  0.0042
K_K4372  L_L27  L_L184  0.0040
K_K4373  L_L27  L_L185  0.0038
K_K4374  L_L27  L_L186  0.0036
K_K4375  L_L27  L_L187  0.0034
K_K4376  L_L27  L_L188  0.0033
K_K4377  L_L27  L_L189  0.0032
K_K4378  L_L27  L_L190  0.0030
K_K4379  L_L27  L_L191  0.0029
K_K4380  L_L27  L_L192  0.0028
K_K4381  L_L27  L_L193  0.0027
K_K4382  L_L27  L_L194  0.0026
K_K4383  L_L27  L_L195  0.0025
K_K4384  L_L27  L_L196  0.0024
K_K4385  L_L27  L_L197  0.0024
K_K4386  L_L27  L_L198  0.0023
K_K4387  L_L27  L_L199  0.0022
K_K4388  L_L27  L_L200  0.0022
K_K4389  L_L27  L_L201  0.0021
K_K4390  L_L27  L_L202  0.0020
K_K4391  L_L27  L_L203  0.0020
K_K4392  L_L27  L_L204  0.0019
K_K4393  L_L27  L_L205  0.0019
K_K4394  L_L27  L_L206  0.0018
K_K4395  L_L27  L_L207  0.0018
K_K4396  L_L27  L_L208  0.0018
K_K4397  L_L27  L_L209  0.0017
K_K4398  L_L27  L_L210  0.0017
K_K4399  L_L27  L_L211  0.0016
K_K4400  L_L27  L_L212  0.0016
K_K4401  L_L27  L_L213  0.0016
K_K4402  L_L27  L_L214  0.0015
K_K4403  L_L27  L_L215  0.0015
K_K4404  L_L27  L_L216  0.0015
K_K4405  L_L27  L_L217  0.0015
K_K4406  L_L27  L_L218  0.0014
K_K4407  L_L27  L_L219  0.0014
K_K4408  L_L27  L_L220  0.0014
K_K4409  L_L27  L_L221  0.0014
K_K4410  L_L27  L_L222  0.0013
K_K4411  L_L27  L_L223  0.0013
K_K4412  L_L27  L_L224  0.0013
K_K4413  L_L27  L_L225  0.0013
K_K4414  L_L27  L_L226  0.0012
K_K4415  L_L27  L_L227  0.0012
K_K4416  L_L27  L_L228  0.0012
K_K4417  L_L27  L_L229  0.0012
K_K4418  L_L27  L_L230  0.0012
K_K4419  L_L27  L_L231  0.0011
K_K4420  L_L27  L_L232  0.0011
K_K4421  L_L27  L_L233  0.0011
K_K4422  L_L27  L_L234  0.0011
K_K4423  L_L27  L_L235  0.0011
K_K4424  L_L27  L_L236  0.0011
K_K4425  L_L27  L_L237  0.0011
K_K4426  L_L27  L_L238  0.0010
K_K4427  L_L27  L_L239  0.0010
K_K4428  L_L27  L_L240  0.0010
* *  Branch  NTMP0000000027 - NTMP0000000028
R_R28  NTMP0000000027  nU_28  32.914993m  TC=0,0
V_Ui28  nU_28  nR_28  STIMULUS=U_IND_0000000028
R_V55  nR_28  nV_55  23.280268m  TC=0,0
L_V55  nR_28  nV_55  0.014646uH
R_V56  nV_55  nV_56  7.852787m  TC=0,0
L_V56  nV_55  nV_56  0.073723uH
L_L28  nV_56  NTMP0000000028  6.519695uH
K_K4429  L_L28  L_L29  0.1050
K_K4430  L_L28  L_L30  0.0397
K_K4431  L_L28  L_L31  0.0258
K_K4432  L_L28  L_L32  0.0192
K_K4433  L_L28  L_L33  0.0153
K_K4434  L_L28  L_L34  0.0127
K_K4435  L_L28  L_L35  0.0109
K_K4436  L_L28  L_L36  0.0095
K_K4437  L_L28  L_L37  0.0084
K_K4438  L_L28  L_L38  0.0076
K_K4439  L_L28  L_L39  0.0069
K_K4440  L_L28  L_L40  0.0063
K_K4441  L_L28  L_L41  0.0058
K_K4442  L_L28  L_L42  0.0054
K_K4443  L_L28  L_L43  0.0051
K_K4444  L_L28  L_L44  0.0047
K_K4445  L_L28  L_L45  0.0045
K_K4446  L_L28  L_L46  0.0042
K_K4447  L_L28  L_L47  0.0040
K_K4448  L_L28  L_L48  0.0038
K_K4449  L_L28  L_L49  0.0036
K_K4450  L_L28  L_L50  0.0034
K_K4451  L_L28  L_L51  0.0033
K_K4452  L_L28  L_L52  0.0032
K_K4453  L_L28  L_L53  0.0030
K_K4454  L_L28  L_L54  0.0029
K_K4455  L_L28  L_L55  0.0028
K_K4456  L_L28  L_L56  0.0027
K_K4457  L_L28  L_L57  0.0026
K_K4458  L_L28  L_L58  0.0025
K_K4459  L_L28  L_L59  0.0024
K_K4460  L_L28  L_L60  0.0024
K_K4461  L_L28  L_L61  0.0023
K_K4462  L_L28  L_L62  0.0022
K_K4463  L_L28  L_L63  0.0022
K_K4464  L_L28  L_L64  0.0021
K_K4465  L_L28  L_L65  0.0020
K_K4466  L_L28  L_L66  0.0020
K_K4467  L_L28  L_L67  0.0019
K_K4468  L_L28  L_L68  0.0019
K_K4469  L_L28  L_L69  0.0018
K_K4470  L_L28  L_L70  0.0018
K_K4471  L_L28  L_L71  0.0018
K_K4472  L_L28  L_L72  0.0017
K_K4473  L_L28  L_L73  0.0017
K_K4474  L_L28  L_L74  0.0016
K_K4475  L_L28  L_L75  0.0016
K_K4476  L_L28  L_L76  0.0016
K_K4477  L_L28  L_L77  0.0015
K_K4478  L_L28  L_L78  0.0015
K_K4479  L_L28  L_L79  0.0015
K_K4480  L_L28  L_L80  0.0015
K_K4481  L_L28  L_L81  0.0014
K_K4482  L_L28  L_L82  0.0014
K_K4483  L_L28  L_L83  0.0014
K_K4484  L_L28  L_L84  0.0014
K_K4485  L_L28  L_L85  0.0013
K_K4486  L_L28  L_L86  0.0013
K_K4487  L_L28  L_L87  0.0013
K_K4488  L_L28  L_L88  0.0013
K_K4489  L_L28  L_L89  0.0013
K_K4490  L_L28  L_L90  0.0012
K_K4491  L_L28  L_L91  0.0012
K_K4492  L_L28  L_L92  0.0012
K_K4493  L_L28  L_L93  0.0012
K_K4494  L_L28  L_L94  0.0011
K_K4495  L_L28  L_L95  0.0011
K_K4496  L_L28  L_L96  0.0011
K_K4497  L_L28  L_L97  0.0011
K_K4498  L_L28  L_L98  0.0011
K_K4499  L_L28  L_L99  0.0011
K_K4500  L_L28  L_L100  0.0011
K_K4501  L_L28  L_L101  0.0010
K_K4502  L_L28  L_L102  0.0010
K_K4503  L_L28  L_L103  0.0010
K_K4504  L_L28  L_L139  0.0028
K_K4505  L_L28  L_L140  0.0029
K_K4506  L_L28  L_L141  0.0030
K_K4507  L_L28  L_L142  0.0032
K_K4508  L_L28  L_L143  0.0033
K_K4509  L_L28  L_L144  0.0034
K_K4510  L_L28  L_L145  0.0036
K_K4511  L_L28  L_L146  0.0038
K_K4512  L_L28  L_L147  0.0040
K_K4513  L_L28  L_L148  0.0042
K_K4514  L_L28  L_L149  0.0045
K_K4515  L_L28  L_L150  0.0047
K_K4516  L_L28  L_L151  0.0051
K_K4517  L_L28  L_L152  0.0054
K_K4518  L_L28  L_L153  0.0058
K_K4519  L_L28  L_L154  0.0063
K_K4520  L_L28  L_L155  0.0069
K_K4521  L_L28  L_L156  0.0076
K_K4522  L_L28  L_L157  0.0084
K_K4523  L_L28  L_L158  0.0095
K_K4524  L_L28  L_L159  0.0109
K_K4525  L_L28  L_L160  0.0127
K_K4526  L_L28  L_L161  0.0152
K_K4527  L_L28  L_L162  0.0191
K_K4528  L_L28  L_L163  0.0256
K_K4529  L_L28  L_L164  0.0389
K_K4530  L_L28  L_L165  0.0812
K_K4531  L_L28  L_L166  0.1569
K_K4532  L_L28  L_L167  0.0812
K_K4533  L_L28  L_L168  0.0389
K_K4534  L_L28  L_L169  0.0256
K_K4535  L_L28  L_L170  0.0191
K_K4536  L_L28  L_L171  0.0152
K_K4537  L_L28  L_L172  0.0127
K_K4538  L_L28  L_L173  0.0109
K_K4539  L_L28  L_L174  0.0095
K_K4540  L_L28  L_L175  0.0084
K_K4541  L_L28  L_L176  0.0076
K_K4542  L_L28  L_L177  0.0069
K_K4543  L_L28  L_L178  0.0063
K_K4544  L_L28  L_L179  0.0058
K_K4545  L_L28  L_L180  0.0054
K_K4546  L_L28  L_L181  0.0051
K_K4547  L_L28  L_L182  0.0047
K_K4548  L_L28  L_L183  0.0045
K_K4549  L_L28  L_L184  0.0042
K_K4550  L_L28  L_L185  0.0040
K_K4551  L_L28  L_L186  0.0038
K_K4552  L_L28  L_L187  0.0036
K_K4553  L_L28  L_L188  0.0034
K_K4554  L_L28  L_L189  0.0033
K_K4555  L_L28  L_L190  0.0032
K_K4556  L_L28  L_L191  0.0030
K_K4557  L_L28  L_L192  0.0029
K_K4558  L_L28  L_L193  0.0028
K_K4559  L_L28  L_L194  0.0027
K_K4560  L_L28  L_L195  0.0026
K_K4561  L_L28  L_L196  0.0025
K_K4562  L_L28  L_L197  0.0024
K_K4563  L_L28  L_L198  0.0024
K_K4564  L_L28  L_L199  0.0023
K_K4565  L_L28  L_L200  0.0022
K_K4566  L_L28  L_L201  0.0022
K_K4567  L_L28  L_L202  0.0021
K_K4568  L_L28  L_L203  0.0020
K_K4569  L_L28  L_L204  0.0020
K_K4570  L_L28  L_L205  0.0019
K_K4571  L_L28  L_L206  0.0019
K_K4572  L_L28  L_L207  0.0018
K_K4573  L_L28  L_L208  0.0018
K_K4574  L_L28  L_L209  0.0018
K_K4575  L_L28  L_L210  0.0017
K_K4576  L_L28  L_L211  0.0017
K_K4577  L_L28  L_L212  0.0016
K_K4578  L_L28  L_L213  0.0016
K_K4579  L_L28  L_L214  0.0016
K_K4580  L_L28  L_L215  0.0015
K_K4581  L_L28  L_L216  0.0015
K_K4582  L_L28  L_L217  0.0015
K_K4583  L_L28  L_L218  0.0015
K_K4584  L_L28  L_L219  0.0014
K_K4585  L_L28  L_L220  0.0014
K_K4586  L_L28  L_L221  0.0014
K_K4587  L_L28  L_L222  0.0014
K_K4588  L_L28  L_L223  0.0013
K_K4589  L_L28  L_L224  0.0013
K_K4590  L_L28  L_L225  0.0013
K_K4591  L_L28  L_L226  0.0013
K_K4592  L_L28  L_L227  0.0012
K_K4593  L_L28  L_L228  0.0012
K_K4594  L_L28  L_L229  0.0012
K_K4595  L_L28  L_L230  0.0012
K_K4596  L_L28  L_L231  0.0012
K_K4597  L_L28  L_L232  0.0011
K_K4598  L_L28  L_L233  0.0011
K_K4599  L_L28  L_L234  0.0011
K_K4600  L_L28  L_L235  0.0011
K_K4601  L_L28  L_L236  0.0011
K_K4602  L_L28  L_L237  0.0011
K_K4603  L_L28  L_L238  0.0011
K_K4604  L_L28  L_L239  0.0010
K_K4605  L_L28  L_L240  0.0010
K_K4606  L_L28  L_L241  0.0010
* *  Branch  NTMP0000000028 - NTMP0000000029
R_R29  NTMP0000000028  nU_29  32.914993m  TC=0,0
V_Ui29  nU_29  nR_29  STIMULUS=U_IND_0000000029
R_V57  nR_29  nV_57  23.280268m  TC=0,0
L_V57  nR_29  nV_57  0.014646uH
R_V58  nV_57  nV_58  7.852787m  TC=0,0
L_V58  nV_57  nV_58  0.073723uH
L_L29  nV_58  NTMP0000000029  6.519695uH
K_K4607  L_L29  L_L30  0.1050
K_K4608  L_L29  L_L31  0.0397
K_K4609  L_L29  L_L32  0.0258
K_K4610  L_L29  L_L33  0.0192
K_K4611  L_L29  L_L34  0.0153
K_K4612  L_L29  L_L35  0.0127
K_K4613  L_L29  L_L36  0.0109
K_K4614  L_L29  L_L37  0.0095
K_K4615  L_L29  L_L38  0.0084
K_K4616  L_L29  L_L39  0.0076
K_K4617  L_L29  L_L40  0.0069
K_K4618  L_L29  L_L41  0.0063
K_K4619  L_L29  L_L42  0.0058
K_K4620  L_L29  L_L43  0.0054
K_K4621  L_L29  L_L44  0.0051
K_K4622  L_L29  L_L45  0.0047
K_K4623  L_L29  L_L46  0.0045
K_K4624  L_L29  L_L47  0.0042
K_K4625  L_L29  L_L48  0.0040
K_K4626  L_L29  L_L49  0.0038
K_K4627  L_L29  L_L50  0.0036
K_K4628  L_L29  L_L51  0.0034
K_K4629  L_L29  L_L52  0.0033
K_K4630  L_L29  L_L53  0.0032
K_K4631  L_L29  L_L54  0.0030
K_K4632  L_L29  L_L55  0.0029
K_K4633  L_L29  L_L56  0.0028
K_K4634  L_L29  L_L57  0.0027
K_K4635  L_L29  L_L58  0.0026
K_K4636  L_L29  L_L59  0.0025
K_K4637  L_L29  L_L60  0.0024
K_K4638  L_L29  L_L61  0.0024
K_K4639  L_L29  L_L62  0.0023
K_K4640  L_L29  L_L63  0.0022
K_K4641  L_L29  L_L64  0.0022
K_K4642  L_L29  L_L65  0.0021
K_K4643  L_L29  L_L66  0.0020
K_K4644  L_L29  L_L67  0.0020
K_K4645  L_L29  L_L68  0.0019
K_K4646  L_L29  L_L69  0.0019
K_K4647  L_L29  L_L70  0.0019
K_K4648  L_L29  L_L71  0.0018
K_K4649  L_L29  L_L72  0.0018
K_K4650  L_L29  L_L73  0.0017
K_K4651  L_L29  L_L74  0.0017
K_K4652  L_L29  L_L75  0.0017
K_K4653  L_L29  L_L76  0.0016
K_K4654  L_L29  L_L77  0.0016
K_K4655  L_L29  L_L78  0.0015
K_K4656  L_L29  L_L79  0.0015
K_K4657  L_L29  L_L80  0.0015
K_K4658  L_L29  L_L81  0.0015
K_K4659  L_L29  L_L82  0.0014
K_K4660  L_L29  L_L83  0.0014
K_K4661  L_L29  L_L84  0.0014
K_K4662  L_L29  L_L85  0.0014
K_K4663  L_L29  L_L86  0.0013
K_K4664  L_L29  L_L87  0.0013
K_K4665  L_L29  L_L88  0.0013
K_K4666  L_L29  L_L89  0.0013
K_K4667  L_L29  L_L90  0.0013
K_K4668  L_L29  L_L91  0.0012
K_K4669  L_L29  L_L92  0.0012
K_K4670  L_L29  L_L93  0.0012
K_K4671  L_L29  L_L94  0.0012
K_K4672  L_L29  L_L95  0.0011
K_K4673  L_L29  L_L96  0.0011
K_K4674  L_L29  L_L97  0.0011
K_K4675  L_L29  L_L98  0.0011
K_K4676  L_L29  L_L99  0.0011
K_K4677  L_L29  L_L100  0.0011
K_K4678  L_L29  L_L101  0.0011
K_K4679  L_L29  L_L102  0.0010
K_K4680  L_L29  L_L103  0.0010
K_K4681  L_L29  L_L104  0.0010
K_K4682  L_L29  L_L139  0.0027
K_K4683  L_L29  L_L140  0.0028
K_K4684  L_L29  L_L141  0.0029
K_K4685  L_L29  L_L142  0.0030
K_K4686  L_L29  L_L143  0.0032
K_K4687  L_L29  L_L144  0.0033
K_K4688  L_L29  L_L145  0.0034
K_K4689  L_L29  L_L146  0.0036
K_K4690  L_L29  L_L147  0.0038
K_K4691  L_L29  L_L148  0.0040
K_K4692  L_L29  L_L149  0.0042
K_K4693  L_L29  L_L150  0.0045
K_K4694  L_L29  L_L151  0.0047
K_K4695  L_L29  L_L152  0.0051
K_K4696  L_L29  L_L153  0.0054
K_K4697  L_L29  L_L154  0.0058
K_K4698  L_L29  L_L155  0.0063
K_K4699  L_L29  L_L156  0.0069
K_K4700  L_L29  L_L157  0.0076
K_K4701  L_L29  L_L158  0.0084
K_K4702  L_L29  L_L159  0.0095
K_K4703  L_L29  L_L160  0.0109
K_K4704  L_L29  L_L161  0.0127
K_K4705  L_L29  L_L162  0.0152
K_K4706  L_L29  L_L163  0.0191
K_K4707  L_L29  L_L164  0.0256
K_K4708  L_L29  L_L165  0.0389
K_K4709  L_L29  L_L166  0.0812
K_K4710  L_L29  L_L167  0.1569
K_K4711  L_L29  L_L168  0.0812
K_K4712  L_L29  L_L169  0.0389
K_K4713  L_L29  L_L170  0.0256
K_K4714  L_L29  L_L171  0.0191
K_K4715  L_L29  L_L172  0.0152
K_K4716  L_L29  L_L173  0.0127
K_K4717  L_L29  L_L174  0.0109
K_K4718  L_L29  L_L175  0.0095
K_K4719  L_L29  L_L176  0.0084
K_K4720  L_L29  L_L177  0.0076
K_K4721  L_L29  L_L178  0.0069
K_K4722  L_L29  L_L179  0.0063
K_K4723  L_L29  L_L180  0.0058
K_K4724  L_L29  L_L181  0.0054
K_K4725  L_L29  L_L182  0.0051
K_K4726  L_L29  L_L183  0.0047
K_K4727  L_L29  L_L184  0.0045
K_K4728  L_L29  L_L185  0.0042
K_K4729  L_L29  L_L186  0.0040
K_K4730  L_L29  L_L187  0.0038
K_K4731  L_L29  L_L188  0.0036
K_K4732  L_L29  L_L189  0.0034
K_K4733  L_L29  L_L190  0.0033
K_K4734  L_L29  L_L191  0.0032
K_K4735  L_L29  L_L192  0.0030
K_K4736  L_L29  L_L193  0.0029
K_K4737  L_L29  L_L194  0.0028
K_K4738  L_L29  L_L195  0.0027
K_K4739  L_L29  L_L196  0.0026
K_K4740  L_L29  L_L197  0.0025
K_K4741  L_L29  L_L198  0.0024
K_K4742  L_L29  L_L199  0.0024
K_K4743  L_L29  L_L200  0.0023
K_K4744  L_L29  L_L201  0.0022
K_K4745  L_L29  L_L202  0.0022
K_K4746  L_L29  L_L203  0.0021
K_K4747  L_L29  L_L204  0.0020
K_K4748  L_L29  L_L205  0.0020
K_K4749  L_L29  L_L206  0.0019
K_K4750  L_L29  L_L207  0.0019
K_K4751  L_L29  L_L208  0.0018
K_K4752  L_L29  L_L209  0.0018
K_K4753  L_L29  L_L210  0.0018
K_K4754  L_L29  L_L211  0.0017
K_K4755  L_L29  L_L212  0.0017
K_K4756  L_L29  L_L213  0.0016
K_K4757  L_L29  L_L214  0.0016
K_K4758  L_L29  L_L215  0.0016
K_K4759  L_L29  L_L216  0.0015
K_K4760  L_L29  L_L217  0.0015
K_K4761  L_L29  L_L218  0.0015
K_K4762  L_L29  L_L219  0.0015
K_K4763  L_L29  L_L220  0.0014
K_K4764  L_L29  L_L221  0.0014
K_K4765  L_L29  L_L222  0.0014
K_K4766  L_L29  L_L223  0.0014
K_K4767  L_L29  L_L224  0.0013
K_K4768  L_L29  L_L225  0.0013
K_K4769  L_L29  L_L226  0.0013
K_K4770  L_L29  L_L227  0.0013
K_K4771  L_L29  L_L228  0.0012
K_K4772  L_L29  L_L229  0.0012
K_K4773  L_L29  L_L230  0.0012
K_K4774  L_L29  L_L231  0.0012
K_K4775  L_L29  L_L232  0.0012
K_K4776  L_L29  L_L233  0.0011
K_K4777  L_L29  L_L234  0.0011
K_K4778  L_L29  L_L235  0.0011
K_K4779  L_L29  L_L236  0.0011
K_K4780  L_L29  L_L237  0.0011
K_K4781  L_L29  L_L238  0.0011
K_K4782  L_L29  L_L239  0.0011
K_K4783  L_L29  L_L240  0.0010
K_K4784  L_L29  L_L241  0.0010
K_K4785  L_L29  L_L242  0.0010
* *  Branch  NTMP0000000029 - NTMP0000000030
R_R30  NTMP0000000029  nU_30  32.914993m  TC=0,0
V_Ui30  nU_30  nR_30  STIMULUS=U_IND_0000000030
R_V59  nR_30  nV_59  23.280268m  TC=0,0
L_V59  nR_30  nV_59  0.014646uH
R_V60  nV_59  nV_60  7.852787m  TC=0,0
L_V60  nV_59  nV_60  0.073723uH
L_L30  nV_60  NTMP0000000030  6.519695uH
K_K4786  L_L30  L_L31  0.1050
K_K4787  L_L30  L_L32  0.0397
K_K4788  L_L30  L_L33  0.0258
K_K4789  L_L30  L_L34  0.0192
K_K4790  L_L30  L_L35  0.0153
K_K4791  L_L30  L_L36  0.0127
K_K4792  L_L30  L_L37  0.0109
K_K4793  L_L30  L_L38  0.0095
K_K4794  L_L30  L_L39  0.0084
K_K4795  L_L30  L_L40  0.0076
K_K4796  L_L30  L_L41  0.0069
K_K4797  L_L30  L_L42  0.0063
K_K4798  L_L30  L_L43  0.0058
K_K4799  L_L30  L_L44  0.0054
K_K4800  L_L30  L_L45  0.0051
K_K4801  L_L30  L_L46  0.0047
K_K4802  L_L30  L_L47  0.0045
K_K4803  L_L30  L_L48  0.0042
K_K4804  L_L30  L_L49  0.0040
K_K4805  L_L30  L_L50  0.0038
K_K4806  L_L30  L_L51  0.0036
K_K4807  L_L30  L_L52  0.0034
K_K4808  L_L30  L_L53  0.0033
K_K4809  L_L30  L_L54  0.0032
K_K4810  L_L30  L_L55  0.0030
K_K4811  L_L30  L_L56  0.0029
K_K4812  L_L30  L_L57  0.0028
K_K4813  L_L30  L_L58  0.0027
K_K4814  L_L30  L_L59  0.0026
K_K4815  L_L30  L_L60  0.0025
K_K4816  L_L30  L_L61  0.0024
K_K4817  L_L30  L_L62  0.0024
K_K4818  L_L30  L_L63  0.0023
K_K4819  L_L30  L_L64  0.0022
K_K4820  L_L30  L_L65  0.0022
K_K4821  L_L30  L_L66  0.0021
K_K4822  L_L30  L_L67  0.0020
K_K4823  L_L30  L_L68  0.0020
K_K4824  L_L30  L_L69  0.0019
K_K4825  L_L30  L_L70  0.0019
K_K4826  L_L30  L_L71  0.0019
K_K4827  L_L30  L_L72  0.0018
K_K4828  L_L30  L_L73  0.0018
K_K4829  L_L30  L_L74  0.0017
K_K4830  L_L30  L_L75  0.0017
K_K4831  L_L30  L_L76  0.0017
K_K4832  L_L30  L_L77  0.0016
K_K4833  L_L30  L_L78  0.0016
K_K4834  L_L30  L_L79  0.0015
K_K4835  L_L30  L_L80  0.0015
K_K4836  L_L30  L_L81  0.0015
K_K4837  L_L30  L_L82  0.0015
K_K4838  L_L30  L_L83  0.0014
K_K4839  L_L30  L_L84  0.0014
K_K4840  L_L30  L_L85  0.0014
K_K4841  L_L30  L_L86  0.0014
K_K4842  L_L30  L_L87  0.0013
K_K4843  L_L30  L_L88  0.0013
K_K4844  L_L30  L_L89  0.0013
K_K4845  L_L30  L_L90  0.0013
K_K4846  L_L30  L_L91  0.0013
K_K4847  L_L30  L_L92  0.0012
K_K4848  L_L30  L_L93  0.0012
K_K4849  L_L30  L_L94  0.0012
K_K4850  L_L30  L_L95  0.0012
K_K4851  L_L30  L_L96  0.0011
K_K4852  L_L30  L_L97  0.0011
K_K4853  L_L30  L_L98  0.0011
K_K4854  L_L30  L_L99  0.0011
K_K4855  L_L30  L_L100  0.0011
K_K4856  L_L30  L_L101  0.0011
K_K4857  L_L30  L_L102  0.0011
K_K4858  L_L30  L_L103  0.0010
K_K4859  L_L30  L_L104  0.0010
K_K4860  L_L30  L_L105  0.0010
K_K4861  L_L30  L_L139  0.0026
K_K4862  L_L30  L_L140  0.0027
K_K4863  L_L30  L_L141  0.0028
K_K4864  L_L30  L_L142  0.0029
K_K4865  L_L30  L_L143  0.0030
K_K4866  L_L30  L_L144  0.0032
K_K4867  L_L30  L_L145  0.0033
K_K4868  L_L30  L_L146  0.0034
K_K4869  L_L30  L_L147  0.0036
K_K4870  L_L30  L_L148  0.0038
K_K4871  L_L30  L_L149  0.0040
K_K4872  L_L30  L_L150  0.0042
K_K4873  L_L30  L_L151  0.0045
K_K4874  L_L30  L_L152  0.0047
K_K4875  L_L30  L_L153  0.0051
K_K4876  L_L30  L_L154  0.0054
K_K4877  L_L30  L_L155  0.0058
K_K4878  L_L30  L_L156  0.0063
K_K4879  L_L30  L_L157  0.0069
K_K4880  L_L30  L_L158  0.0076
K_K4881  L_L30  L_L159  0.0084
K_K4882  L_L30  L_L160  0.0095
K_K4883  L_L30  L_L161  0.0109
K_K4884  L_L30  L_L162  0.0127
K_K4885  L_L30  L_L163  0.0152
K_K4886  L_L30  L_L164  0.0191
K_K4887  L_L30  L_L165  0.0256
K_K4888  L_L30  L_L166  0.0389
K_K4889  L_L30  L_L167  0.0812
K_K4890  L_L30  L_L168  0.1569
K_K4891  L_L30  L_L169  0.0812
K_K4892  L_L30  L_L170  0.0389
K_K4893  L_L30  L_L171  0.0256
K_K4894  L_L30  L_L172  0.0191
K_K4895  L_L30  L_L173  0.0152
K_K4896  L_L30  L_L174  0.0127
K_K4897  L_L30  L_L175  0.0109
K_K4898  L_L30  L_L176  0.0095
K_K4899  L_L30  L_L177  0.0084
K_K4900  L_L30  L_L178  0.0076
K_K4901  L_L30  L_L179  0.0069
K_K4902  L_L30  L_L180  0.0063
K_K4903  L_L30  L_L181  0.0058
K_K4904  L_L30  L_L182  0.0054
K_K4905  L_L30  L_L183  0.0051
K_K4906  L_L30  L_L184  0.0047
K_K4907  L_L30  L_L185  0.0045
K_K4908  L_L30  L_L186  0.0042
K_K4909  L_L30  L_L187  0.0040
K_K4910  L_L30  L_L188  0.0038
K_K4911  L_L30  L_L189  0.0036
K_K4912  L_L30  L_L190  0.0034
K_K4913  L_L30  L_L191  0.0033
K_K4914  L_L30  L_L192  0.0032
K_K4915  L_L30  L_L193  0.0030
K_K4916  L_L30  L_L194  0.0029
K_K4917  L_L30  L_L195  0.0028
K_K4918  L_L30  L_L196  0.0027
K_K4919  L_L30  L_L197  0.0026
K_K4920  L_L30  L_L198  0.0025
K_K4921  L_L30  L_L199  0.0024
K_K4922  L_L30  L_L200  0.0024
K_K4923  L_L30  L_L201  0.0023
K_K4924  L_L30  L_L202  0.0022
K_K4925  L_L30  L_L203  0.0022
K_K4926  L_L30  L_L204  0.0021
K_K4927  L_L30  L_L205  0.0020
K_K4928  L_L30  L_L206  0.0020
K_K4929  L_L30  L_L207  0.0019
K_K4930  L_L30  L_L208  0.0019
K_K4931  L_L30  L_L209  0.0018
K_K4932  L_L30  L_L210  0.0018
K_K4933  L_L30  L_L211  0.0018
K_K4934  L_L30  L_L212  0.0017
K_K4935  L_L30  L_L213  0.0017
K_K4936  L_L30  L_L214  0.0016
K_K4937  L_L30  L_L215  0.0016
K_K4938  L_L30  L_L216  0.0016
K_K4939  L_L30  L_L217  0.0015
K_K4940  L_L30  L_L218  0.0015
K_K4941  L_L30  L_L219  0.0015
K_K4942  L_L30  L_L220  0.0015
K_K4943  L_L30  L_L221  0.0014
K_K4944  L_L30  L_L222  0.0014
K_K4945  L_L30  L_L223  0.0014
K_K4946  L_L30  L_L224  0.0014
K_K4947  L_L30  L_L225  0.0013
K_K4948  L_L30  L_L226  0.0013
K_K4949  L_L30  L_L227  0.0013
K_K4950  L_L30  L_L228  0.0013
K_K4951  L_L30  L_L229  0.0012
K_K4952  L_L30  L_L230  0.0012
K_K4953  L_L30  L_L231  0.0012
K_K4954  L_L30  L_L232  0.0012
K_K4955  L_L30  L_L233  0.0012
K_K4956  L_L30  L_L234  0.0011
K_K4957  L_L30  L_L235  0.0011
K_K4958  L_L30  L_L236  0.0011
K_K4959  L_L30  L_L237  0.0011
K_K4960  L_L30  L_L238  0.0011
K_K4961  L_L30  L_L239  0.0011
K_K4962  L_L30  L_L240  0.0011
K_K4963  L_L30  L_L241  0.0010
K_K4964  L_L30  L_L242  0.0010
K_K4965  L_L30  L_L243  0.0010
* *  Branch  NTMP0000000030 - NTMP0000000031
R_R31  NTMP0000000030  nU_31  32.914993m  TC=0,0
V_Ui31  nU_31  nR_31  STIMULUS=U_IND_0000000031
R_V61  nR_31  nV_61  23.280268m  TC=0,0
L_V61  nR_31  nV_61  0.014646uH
R_V62  nV_61  nV_62  7.852787m  TC=0,0
L_V62  nV_61  nV_62  0.073723uH
L_L31  nV_62  NTMP0000000031  6.519695uH
K_K4966  L_L31  L_L32  0.1050
K_K4967  L_L31  L_L33  0.0397
K_K4968  L_L31  L_L34  0.0258
K_K4969  L_L31  L_L35  0.0192
K_K4970  L_L31  L_L36  0.0153
K_K4971  L_L31  L_L37  0.0127
K_K4972  L_L31  L_L38  0.0109
K_K4973  L_L31  L_L39  0.0095
K_K4974  L_L31  L_L40  0.0084
K_K4975  L_L31  L_L41  0.0076
K_K4976  L_L31  L_L42  0.0069
K_K4977  L_L31  L_L43  0.0063
K_K4978  L_L31  L_L44  0.0058
K_K4979  L_L31  L_L45  0.0054
K_K4980  L_L31  L_L46  0.0051
K_K4981  L_L31  L_L47  0.0047
K_K4982  L_L31  L_L48  0.0045
K_K4983  L_L31  L_L49  0.0042
K_K4984  L_L31  L_L50  0.0040
K_K4985  L_L31  L_L51  0.0038
K_K4986  L_L31  L_L52  0.0036
K_K4987  L_L31  L_L53  0.0034
K_K4988  L_L31  L_L54  0.0033
K_K4989  L_L31  L_L55  0.0032
K_K4990  L_L31  L_L56  0.0030
K_K4991  L_L31  L_L57  0.0029
K_K4992  L_L31  L_L58  0.0028
K_K4993  L_L31  L_L59  0.0027
K_K4994  L_L31  L_L60  0.0026
K_K4995  L_L31  L_L61  0.0025
K_K4996  L_L31  L_L62  0.0024
K_K4997  L_L31  L_L63  0.0024
K_K4998  L_L31  L_L64  0.0023
K_K4999  L_L31  L_L65  0.0022
K_K5000  L_L31  L_L66  0.0022
K_K5001  L_L31  L_L67  0.0021
K_K5002  L_L31  L_L68  0.0020
K_K5003  L_L31  L_L69  0.0020
K_K5004  L_L31  L_L70  0.0019
K_K5005  L_L31  L_L71  0.0019
K_K5006  L_L31  L_L72  0.0019
K_K5007  L_L31  L_L73  0.0018
K_K5008  L_L31  L_L74  0.0018
K_K5009  L_L31  L_L75  0.0017
K_K5010  L_L31  L_L76  0.0017
K_K5011  L_L31  L_L77  0.0017
K_K5012  L_L31  L_L78  0.0016
K_K5013  L_L31  L_L79  0.0016
K_K5014  L_L31  L_L80  0.0015
K_K5015  L_L31  L_L81  0.0015
K_K5016  L_L31  L_L82  0.0015
K_K5017  L_L31  L_L83  0.0015
K_K5018  L_L31  L_L84  0.0014
K_K5019  L_L31  L_L85  0.0014
K_K5020  L_L31  L_L86  0.0014
K_K5021  L_L31  L_L87  0.0014
K_K5022  L_L31  L_L88  0.0013
K_K5023  L_L31  L_L89  0.0013
K_K5024  L_L31  L_L90  0.0013
K_K5025  L_L31  L_L91  0.0013
K_K5026  L_L31  L_L92  0.0013
K_K5027  L_L31  L_L93  0.0012
K_K5028  L_L31  L_L94  0.0012
K_K5029  L_L31  L_L95  0.0012
K_K5030  L_L31  L_L96  0.0012
K_K5031  L_L31  L_L97  0.0011
K_K5032  L_L31  L_L98  0.0011
K_K5033  L_L31  L_L99  0.0011
K_K5034  L_L31  L_L100  0.0011
K_K5035  L_L31  L_L101  0.0011
K_K5036  L_L31  L_L102  0.0011
K_K5037  L_L31  L_L103  0.0011
K_K5038  L_L31  L_L104  0.0010
K_K5039  L_L31  L_L105  0.0010
K_K5040  L_L31  L_L106  0.0010
K_K5041  L_L31  L_L139  0.0025
K_K5042  L_L31  L_L140  0.0026
K_K5043  L_L31  L_L141  0.0027
K_K5044  L_L31  L_L142  0.0028
K_K5045  L_L31  L_L143  0.0029
K_K5046  L_L31  L_L144  0.0030
K_K5047  L_L31  L_L145  0.0032
K_K5048  L_L31  L_L146  0.0033
K_K5049  L_L31  L_L147  0.0034
K_K5050  L_L31  L_L148  0.0036
K_K5051  L_L31  L_L149  0.0038
K_K5052  L_L31  L_L150  0.0040
K_K5053  L_L31  L_L151  0.0042
K_K5054  L_L31  L_L152  0.0045
K_K5055  L_L31  L_L153  0.0047
K_K5056  L_L31  L_L154  0.0051
K_K5057  L_L31  L_L155  0.0054
K_K5058  L_L31  L_L156  0.0058
K_K5059  L_L31  L_L157  0.0063
K_K5060  L_L31  L_L158  0.0069
K_K5061  L_L31  L_L159  0.0076
K_K5062  L_L31  L_L160  0.0084
K_K5063  L_L31  L_L161  0.0095
K_K5064  L_L31  L_L162  0.0109
K_K5065  L_L31  L_L163  0.0127
K_K5066  L_L31  L_L164  0.0152
K_K5067  L_L31  L_L165  0.0191
K_K5068  L_L31  L_L166  0.0256
K_K5069  L_L31  L_L167  0.0389
K_K5070  L_L31  L_L168  0.0812
K_K5071  L_L31  L_L169  0.1569
K_K5072  L_L31  L_L170  0.0812
K_K5073  L_L31  L_L171  0.0389
K_K5074  L_L31  L_L172  0.0256
K_K5075  L_L31  L_L173  0.0191
K_K5076  L_L31  L_L174  0.0152
K_K5077  L_L31  L_L175  0.0127
K_K5078  L_L31  L_L176  0.0109
K_K5079  L_L31  L_L177  0.0095
K_K5080  L_L31  L_L178  0.0084
K_K5081  L_L31  L_L179  0.0076
K_K5082  L_L31  L_L180  0.0069
K_K5083  L_L31  L_L181  0.0063
K_K5084  L_L31  L_L182  0.0058
K_K5085  L_L31  L_L183  0.0054
K_K5086  L_L31  L_L184  0.0051
K_K5087  L_L31  L_L185  0.0047
K_K5088  L_L31  L_L186  0.0045
K_K5089  L_L31  L_L187  0.0042
K_K5090  L_L31  L_L188  0.0040
K_K5091  L_L31  L_L189  0.0038
K_K5092  L_L31  L_L190  0.0036
K_K5093  L_L31  L_L191  0.0034
K_K5094  L_L31  L_L192  0.0033
K_K5095  L_L31  L_L193  0.0032
K_K5096  L_L31  L_L194  0.0030
K_K5097  L_L31  L_L195  0.0029
K_K5098  L_L31  L_L196  0.0028
K_K5099  L_L31  L_L197  0.0027
K_K5100  L_L31  L_L198  0.0026
K_K5101  L_L31  L_L199  0.0025
K_K5102  L_L31  L_L200  0.0024
K_K5103  L_L31  L_L201  0.0024
K_K5104  L_L31  L_L202  0.0023
K_K5105  L_L31  L_L203  0.0022
K_K5106  L_L31  L_L204  0.0022
K_K5107  L_L31  L_L205  0.0021
K_K5108  L_L31  L_L206  0.0020
K_K5109  L_L31  L_L207  0.0020
K_K5110  L_L31  L_L208  0.0019
K_K5111  L_L31  L_L209  0.0019
K_K5112  L_L31  L_L210  0.0018
K_K5113  L_L31  L_L211  0.0018
K_K5114  L_L31  L_L212  0.0018
K_K5115  L_L31  L_L213  0.0017
K_K5116  L_L31  L_L214  0.0017
K_K5117  L_L31  L_L215  0.0016
K_K5118  L_L31  L_L216  0.0016
K_K5119  L_L31  L_L217  0.0016
K_K5120  L_L31  L_L218  0.0015
K_K5121  L_L31  L_L219  0.0015
K_K5122  L_L31  L_L220  0.0015
K_K5123  L_L31  L_L221  0.0015
K_K5124  L_L31  L_L222  0.0014
K_K5125  L_L31  L_L223  0.0014
K_K5126  L_L31  L_L224  0.0014
K_K5127  L_L31  L_L225  0.0014
K_K5128  L_L31  L_L226  0.0013
K_K5129  L_L31  L_L227  0.0013
K_K5130  L_L31  L_L228  0.0013
K_K5131  L_L31  L_L229  0.0013
K_K5132  L_L31  L_L230  0.0012
K_K5133  L_L31  L_L231  0.0012
K_K5134  L_L31  L_L232  0.0012
K_K5135  L_L31  L_L233  0.0012
K_K5136  L_L31  L_L234  0.0012
K_K5137  L_L31  L_L235  0.0011
K_K5138  L_L31  L_L236  0.0011
K_K5139  L_L31  L_L237  0.0011
K_K5140  L_L31  L_L238  0.0011
K_K5141  L_L31  L_L239  0.0011
K_K5142  L_L31  L_L240  0.0011
K_K5143  L_L31  L_L241  0.0011
K_K5144  L_L31  L_L242  0.0010
K_K5145  L_L31  L_L243  0.0010
K_K5146  L_L31  L_L244  0.0010
* *  Branch  NTMP0000000031 - NTMP0000000032
R_R32  NTMP0000000031  nU_32  32.914993m  TC=0,0
V_Ui32  nU_32  nR_32  STIMULUS=U_IND_0000000032
R_V63  nR_32  nV_63  23.280268m  TC=0,0
L_V63  nR_32  nV_63  0.014646uH
R_V64  nV_63  nV_64  7.852787m  TC=0,0
L_V64  nV_63  nV_64  0.073723uH
L_L32  nV_64  NTMP0000000032  6.519695uH
K_K5147  L_L32  L_L33  0.1050
K_K5148  L_L32  L_L34  0.0397
K_K5149  L_L32  L_L35  0.0258
K_K5150  L_L32  L_L36  0.0192
K_K5151  L_L32  L_L37  0.0153
K_K5152  L_L32  L_L38  0.0127
K_K5153  L_L32  L_L39  0.0109
K_K5154  L_L32  L_L40  0.0095
K_K5155  L_L32  L_L41  0.0084
K_K5156  L_L32  L_L42  0.0076
K_K5157  L_L32  L_L43  0.0069
K_K5158  L_L32  L_L44  0.0063
K_K5159  L_L32  L_L45  0.0058
K_K5160  L_L32  L_L46  0.0054
K_K5161  L_L32  L_L47  0.0051
K_K5162  L_L32  L_L48  0.0047
K_K5163  L_L32  L_L49  0.0045
K_K5164  L_L32  L_L50  0.0042
K_K5165  L_L32  L_L51  0.0040
K_K5166  L_L32  L_L52  0.0038
K_K5167  L_L32  L_L53  0.0036
K_K5168  L_L32  L_L54  0.0034
K_K5169  L_L32  L_L55  0.0033
K_K5170  L_L32  L_L56  0.0032
K_K5171  L_L32  L_L57  0.0030
K_K5172  L_L32  L_L58  0.0029
K_K5173  L_L32  L_L59  0.0028
K_K5174  L_L32  L_L60  0.0027
K_K5175  L_L32  L_L61  0.0026
K_K5176  L_L32  L_L62  0.0025
K_K5177  L_L32  L_L63  0.0024
K_K5178  L_L32  L_L64  0.0024
K_K5179  L_L32  L_L65  0.0023
K_K5180  L_L32  L_L66  0.0022
K_K5181  L_L32  L_L67  0.0022
K_K5182  L_L32  L_L68  0.0021
K_K5183  L_L32  L_L69  0.0020
K_K5184  L_L32  L_L70  0.0020
K_K5185  L_L32  L_L71  0.0019
K_K5186  L_L32  L_L72  0.0019
K_K5187  L_L32  L_L73  0.0019
K_K5188  L_L32  L_L74  0.0018
K_K5189  L_L32  L_L75  0.0018
K_K5190  L_L32  L_L76  0.0017
K_K5191  L_L32  L_L77  0.0017
K_K5192  L_L32  L_L78  0.0017
K_K5193  L_L32  L_L79  0.0016
K_K5194  L_L32  L_L80  0.0016
K_K5195  L_L32  L_L81  0.0015
K_K5196  L_L32  L_L82  0.0015
K_K5197  L_L32  L_L83  0.0015
K_K5198  L_L32  L_L84  0.0015
K_K5199  L_L32  L_L85  0.0014
K_K5200  L_L32  L_L86  0.0014
K_K5201  L_L32  L_L87  0.0014
K_K5202  L_L32  L_L88  0.0014
K_K5203  L_L32  L_L89  0.0013
K_K5204  L_L32  L_L90  0.0013
K_K5205  L_L32  L_L91  0.0013
K_K5206  L_L32  L_L92  0.0013
K_K5207  L_L32  L_L93  0.0013
K_K5208  L_L32  L_L94  0.0012
K_K5209  L_L32  L_L95  0.0012
K_K5210  L_L32  L_L96  0.0012
K_K5211  L_L32  L_L97  0.0012
K_K5212  L_L32  L_L98  0.0011
K_K5213  L_L32  L_L99  0.0011
K_K5214  L_L32  L_L100  0.0011
K_K5215  L_L32  L_L101  0.0011
K_K5216  L_L32  L_L102  0.0011
K_K5217  L_L32  L_L103  0.0011
K_K5218  L_L32  L_L104  0.0011
K_K5219  L_L32  L_L105  0.0010
K_K5220  L_L32  L_L106  0.0010
K_K5221  L_L32  L_L107  0.0010
K_K5222  L_L32  L_L139  0.0024
K_K5223  L_L32  L_L140  0.0025
K_K5224  L_L32  L_L141  0.0026
K_K5225  L_L32  L_L142  0.0027
K_K5226  L_L32  L_L143  0.0028
K_K5227  L_L32  L_L144  0.0029
K_K5228  L_L32  L_L145  0.0030
K_K5229  L_L32  L_L146  0.0032
K_K5230  L_L32  L_L147  0.0033
K_K5231  L_L32  L_L148  0.0034
K_K5232  L_L32  L_L149  0.0036
K_K5233  L_L32  L_L150  0.0038
K_K5234  L_L32  L_L151  0.0040
K_K5235  L_L32  L_L152  0.0042
K_K5236  L_L32  L_L153  0.0045
K_K5237  L_L32  L_L154  0.0047
K_K5238  L_L32  L_L155  0.0051
K_K5239  L_L32  L_L156  0.0054
K_K5240  L_L32  L_L157  0.0058
K_K5241  L_L32  L_L158  0.0063
K_K5242  L_L32  L_L159  0.0069
K_K5243  L_L32  L_L160  0.0076
K_K5244  L_L32  L_L161  0.0084
K_K5245  L_L32  L_L162  0.0095
K_K5246  L_L32  L_L163  0.0109
K_K5247  L_L32  L_L164  0.0127
K_K5248  L_L32  L_L165  0.0152
K_K5249  L_L32  L_L166  0.0191
K_K5250  L_L32  L_L167  0.0256
K_K5251  L_L32  L_L168  0.0389
K_K5252  L_L32  L_L169  0.0812
K_K5253  L_L32  L_L170  0.1569
K_K5254  L_L32  L_L171  0.0812
K_K5255  L_L32  L_L172  0.0389
K_K5256  L_L32  L_L173  0.0256
K_K5257  L_L32  L_L174  0.0191
K_K5258  L_L32  L_L175  0.0152
K_K5259  L_L32  L_L176  0.0127
K_K5260  L_L32  L_L177  0.0109
K_K5261  L_L32  L_L178  0.0095
K_K5262  L_L32  L_L179  0.0084
K_K5263  L_L32  L_L180  0.0076
K_K5264  L_L32  L_L181  0.0069
K_K5265  L_L32  L_L182  0.0063
K_K5266  L_L32  L_L183  0.0058
K_K5267  L_L32  L_L184  0.0054
K_K5268  L_L32  L_L185  0.0051
K_K5269  L_L32  L_L186  0.0047
K_K5270  L_L32  L_L187  0.0045
K_K5271  L_L32  L_L188  0.0042
K_K5272  L_L32  L_L189  0.0040
K_K5273  L_L32  L_L190  0.0038
K_K5274  L_L32  L_L191  0.0036
K_K5275  L_L32  L_L192  0.0034
K_K5276  L_L32  L_L193  0.0033
K_K5277  L_L32  L_L194  0.0032
K_K5278  L_L32  L_L195  0.0030
K_K5279  L_L32  L_L196  0.0029
K_K5280  L_L32  L_L197  0.0028
K_K5281  L_L32  L_L198  0.0027
K_K5282  L_L32  L_L199  0.0026
K_K5283  L_L32  L_L200  0.0025
K_K5284  L_L32  L_L201  0.0024
K_K5285  L_L32  L_L202  0.0024
K_K5286  L_L32  L_L203  0.0023
K_K5287  L_L32  L_L204  0.0022
K_K5288  L_L32  L_L205  0.0022
K_K5289  L_L32  L_L206  0.0021
K_K5290  L_L32  L_L207  0.0020
K_K5291  L_L32  L_L208  0.0020
K_K5292  L_L32  L_L209  0.0019
K_K5293  L_L32  L_L210  0.0019
K_K5294  L_L32  L_L211  0.0018
K_K5295  L_L32  L_L212  0.0018
K_K5296  L_L32  L_L213  0.0018
K_K5297  L_L32  L_L214  0.0017
K_K5298  L_L32  L_L215  0.0017
K_K5299  L_L32  L_L216  0.0016
K_K5300  L_L32  L_L217  0.0016
K_K5301  L_L32  L_L218  0.0016
K_K5302  L_L32  L_L219  0.0015
K_K5303  L_L32  L_L220  0.0015
K_K5304  L_L32  L_L221  0.0015
K_K5305  L_L32  L_L222  0.0015
K_K5306  L_L32  L_L223  0.0014
K_K5307  L_L32  L_L224  0.0014
K_K5308  L_L32  L_L225  0.0014
K_K5309  L_L32  L_L226  0.0014
K_K5310  L_L32  L_L227  0.0013
K_K5311  L_L32  L_L228  0.0013
K_K5312  L_L32  L_L229  0.0013
K_K5313  L_L32  L_L230  0.0013
K_K5314  L_L32  L_L231  0.0012
K_K5315  L_L32  L_L232  0.0012
K_K5316  L_L32  L_L233  0.0012
K_K5317  L_L32  L_L234  0.0012
K_K5318  L_L32  L_L235  0.0012
K_K5319  L_L32  L_L236  0.0011
K_K5320  L_L32  L_L237  0.0011
K_K5321  L_L32  L_L238  0.0011
K_K5322  L_L32  L_L239  0.0011
K_K5323  L_L32  L_L240  0.0011
K_K5324  L_L32  L_L241  0.0011
K_K5325  L_L32  L_L242  0.0011
K_K5326  L_L32  L_L243  0.0010
K_K5327  L_L32  L_L244  0.0010
K_K5328  L_L32  L_L245  0.0010
* *  Branch  NTMP0000000032 - NTMP0000000033
R_R33  NTMP0000000032  nU_33  32.914993m  TC=0,0
V_Ui33  nU_33  nR_33  STIMULUS=U_IND_0000000033
R_V65  nR_33  nV_65  23.280268m  TC=0,0
L_V65  nR_33  nV_65  0.014646uH
R_V66  nV_65  nV_66  7.852787m  TC=0,0
L_V66  nV_65  nV_66  0.073723uH
L_L33  nV_66  NTMP0000000033  6.519695uH
K_K5329  L_L33  L_L34  0.1050
K_K5330  L_L33  L_L35  0.0397
K_K5331  L_L33  L_L36  0.0258
K_K5332  L_L33  L_L37  0.0192
K_K5333  L_L33  L_L38  0.0153
K_K5334  L_L33  L_L39  0.0127
K_K5335  L_L33  L_L40  0.0109
K_K5336  L_L33  L_L41  0.0095
K_K5337  L_L33  L_L42  0.0084
K_K5338  L_L33  L_L43  0.0076
K_K5339  L_L33  L_L44  0.0069
K_K5340  L_L33  L_L45  0.0063
K_K5341  L_L33  L_L46  0.0058
K_K5342  L_L33  L_L47  0.0054
K_K5343  L_L33  L_L48  0.0051
K_K5344  L_L33  L_L49  0.0047
K_K5345  L_L33  L_L50  0.0045
K_K5346  L_L33  L_L51  0.0042
K_K5347  L_L33  L_L52  0.0040
K_K5348  L_L33  L_L53  0.0038
K_K5349  L_L33  L_L54  0.0036
K_K5350  L_L33  L_L55  0.0034
K_K5351  L_L33  L_L56  0.0033
K_K5352  L_L33  L_L57  0.0032
K_K5353  L_L33  L_L58  0.0030
K_K5354  L_L33  L_L59  0.0029
K_K5355  L_L33  L_L60  0.0028
K_K5356  L_L33  L_L61  0.0027
K_K5357  L_L33  L_L62  0.0026
K_K5358  L_L33  L_L63  0.0025
K_K5359  L_L33  L_L64  0.0024
K_K5360  L_L33  L_L65  0.0024
K_K5361  L_L33  L_L66  0.0023
K_K5362  L_L33  L_L67  0.0022
K_K5363  L_L33  L_L68  0.0022
K_K5364  L_L33  L_L69  0.0021
K_K5365  L_L33  L_L70  0.0020
K_K5366  L_L33  L_L71  0.0020
K_K5367  L_L33  L_L72  0.0019
K_K5368  L_L33  L_L73  0.0019
K_K5369  L_L33  L_L74  0.0019
K_K5370  L_L33  L_L75  0.0018
K_K5371  L_L33  L_L76  0.0018
K_K5372  L_L33  L_L77  0.0017
K_K5373  L_L33  L_L78  0.0017
K_K5374  L_L33  L_L79  0.0017
K_K5375  L_L33  L_L80  0.0016
K_K5376  L_L33  L_L81  0.0016
K_K5377  L_L33  L_L82  0.0015
K_K5378  L_L33  L_L83  0.0015
K_K5379  L_L33  L_L84  0.0015
K_K5380  L_L33  L_L85  0.0015
K_K5381  L_L33  L_L86  0.0014
K_K5382  L_L33  L_L87  0.0014
K_K5383  L_L33  L_L88  0.0014
K_K5384  L_L33  L_L89  0.0014
K_K5385  L_L33  L_L90  0.0013
K_K5386  L_L33  L_L91  0.0013
K_K5387  L_L33  L_L92  0.0013
K_K5388  L_L33  L_L93  0.0013
K_K5389  L_L33  L_L94  0.0013
K_K5390  L_L33  L_L95  0.0012
K_K5391  L_L33  L_L96  0.0012
K_K5392  L_L33  L_L97  0.0012
K_K5393  L_L33  L_L98  0.0012
K_K5394  L_L33  L_L99  0.0011
K_K5395  L_L33  L_L100  0.0011
K_K5396  L_L33  L_L101  0.0011
K_K5397  L_L33  L_L102  0.0011
K_K5398  L_L33  L_L103  0.0011
K_K5399  L_L33  L_L104  0.0011
K_K5400  L_L33  L_L105  0.0011
K_K5401  L_L33  L_L106  0.0010
K_K5402  L_L33  L_L107  0.0010
K_K5403  L_L33  L_L108  0.0010
K_K5404  L_L33  L_L139  0.0024
K_K5405  L_L33  L_L140  0.0024
K_K5406  L_L33  L_L141  0.0025
K_K5407  L_L33  L_L142  0.0026
K_K5408  L_L33  L_L143  0.0027
K_K5409  L_L33  L_L144  0.0028
K_K5410  L_L33  L_L145  0.0029
K_K5411  L_L33  L_L146  0.0030
K_K5412  L_L33  L_L147  0.0032
K_K5413  L_L33  L_L148  0.0033
K_K5414  L_L33  L_L149  0.0034
K_K5415  L_L33  L_L150  0.0036
K_K5416  L_L33  L_L151  0.0038
K_K5417  L_L33  L_L152  0.0040
K_K5418  L_L33  L_L153  0.0042
K_K5419  L_L33  L_L154  0.0045
K_K5420  L_L33  L_L155  0.0047
K_K5421  L_L33  L_L156  0.0051
K_K5422  L_L33  L_L157  0.0054
K_K5423  L_L33  L_L158  0.0058
K_K5424  L_L33  L_L159  0.0063
K_K5425  L_L33  L_L160  0.0069
K_K5426  L_L33  L_L161  0.0076
K_K5427  L_L33  L_L162  0.0084
K_K5428  L_L33  L_L163  0.0095
K_K5429  L_L33  L_L164  0.0109
K_K5430  L_L33  L_L165  0.0127
K_K5431  L_L33  L_L166  0.0152
K_K5432  L_L33  L_L167  0.0191
K_K5433  L_L33  L_L168  0.0256
K_K5434  L_L33  L_L169  0.0389
K_K5435  L_L33  L_L170  0.0812
K_K5436  L_L33  L_L171  0.1569
K_K5437  L_L33  L_L172  0.0812
K_K5438  L_L33  L_L173  0.0389
K_K5439  L_L33  L_L174  0.0256
K_K5440  L_L33  L_L175  0.0191
K_K5441  L_L33  L_L176  0.0152
K_K5442  L_L33  L_L177  0.0127
K_K5443  L_L33  L_L178  0.0109
K_K5444  L_L33  L_L179  0.0095
K_K5445  L_L33  L_L180  0.0084
K_K5446  L_L33  L_L181  0.0076
K_K5447  L_L33  L_L182  0.0069
K_K5448  L_L33  L_L183  0.0063
K_K5449  L_L33  L_L184  0.0058
K_K5450  L_L33  L_L185  0.0054
K_K5451  L_L33  L_L186  0.0051
K_K5452  L_L33  L_L187  0.0047
K_K5453  L_L33  L_L188  0.0045
K_K5454  L_L33  L_L189  0.0042
K_K5455  L_L33  L_L190  0.0040
K_K5456  L_L33  L_L191  0.0038
K_K5457  L_L33  L_L192  0.0036
K_K5458  L_L33  L_L193  0.0034
K_K5459  L_L33  L_L194  0.0033
K_K5460  L_L33  L_L195  0.0032
K_K5461  L_L33  L_L196  0.0030
K_K5462  L_L33  L_L197  0.0029
K_K5463  L_L33  L_L198  0.0028
K_K5464  L_L33  L_L199  0.0027
K_K5465  L_L33  L_L200  0.0026
K_K5466  L_L33  L_L201  0.0025
K_K5467  L_L33  L_L202  0.0024
K_K5468  L_L33  L_L203  0.0024
K_K5469  L_L33  L_L204  0.0023
K_K5470  L_L33  L_L205  0.0022
K_K5471  L_L33  L_L206  0.0022
K_K5472  L_L33  L_L207  0.0021
K_K5473  L_L33  L_L208  0.0020
K_K5474  L_L33  L_L209  0.0020
K_K5475  L_L33  L_L210  0.0019
K_K5476  L_L33  L_L211  0.0019
K_K5477  L_L33  L_L212  0.0018
K_K5478  L_L33  L_L213  0.0018
K_K5479  L_L33  L_L214  0.0018
K_K5480  L_L33  L_L215  0.0017
K_K5481  L_L33  L_L216  0.0017
K_K5482  L_L33  L_L217  0.0016
K_K5483  L_L33  L_L218  0.0016
K_K5484  L_L33  L_L219  0.0016
K_K5485  L_L33  L_L220  0.0015
K_K5486  L_L33  L_L221  0.0015
K_K5487  L_L33  L_L222  0.0015
K_K5488  L_L33  L_L223  0.0015
K_K5489  L_L33  L_L224  0.0014
K_K5490  L_L33  L_L225  0.0014
K_K5491  L_L33  L_L226  0.0014
K_K5492  L_L33  L_L227  0.0014
K_K5493  L_L33  L_L228  0.0013
K_K5494  L_L33  L_L229  0.0013
K_K5495  L_L33  L_L230  0.0013
K_K5496  L_L33  L_L231  0.0013
K_K5497  L_L33  L_L232  0.0012
K_K5498  L_L33  L_L233  0.0012
K_K5499  L_L33  L_L234  0.0012
K_K5500  L_L33  L_L235  0.0012
K_K5501  L_L33  L_L236  0.0012
K_K5502  L_L33  L_L237  0.0011
K_K5503  L_L33  L_L238  0.0011
K_K5504  L_L33  L_L239  0.0011
K_K5505  L_L33  L_L240  0.0011
K_K5506  L_L33  L_L241  0.0011
K_K5507  L_L33  L_L242  0.0011
K_K5508  L_L33  L_L243  0.0011
K_K5509  L_L33  L_L244  0.0010
K_K5510  L_L33  L_L245  0.0010
K_K5511  L_L33  L_L246  0.0010
* *  Branch  NTMP0000000033 - NTMP0000000034
R_R34  NTMP0000000033  nU_34  32.914993m  TC=0,0
V_Ui34  nU_34  nR_34  STIMULUS=U_IND_0000000034
R_V67  nR_34  nV_67  23.280268m  TC=0,0
L_V67  nR_34  nV_67  0.014646uH
R_V68  nV_67  nV_68  7.852787m  TC=0,0
L_V68  nV_67  nV_68  0.073723uH
L_L34  nV_68  NTMP0000000034  6.519695uH
K_K5512  L_L34  L_L35  0.1050
K_K5513  L_L34  L_L36  0.0397
K_K5514  L_L34  L_L37  0.0258
K_K5515  L_L34  L_L38  0.0192
K_K5516  L_L34  L_L39  0.0153
K_K5517  L_L34  L_L40  0.0127
K_K5518  L_L34  L_L41  0.0109
K_K5519  L_L34  L_L42  0.0095
K_K5520  L_L34  L_L43  0.0084
K_K5521  L_L34  L_L44  0.0076
K_K5522  L_L34  L_L45  0.0069
K_K5523  L_L34  L_L46  0.0063
K_K5524  L_L34  L_L47  0.0058
K_K5525  L_L34  L_L48  0.0054
K_K5526  L_L34  L_L49  0.0051
K_K5527  L_L34  L_L50  0.0047
K_K5528  L_L34  L_L51  0.0045
K_K5529  L_L34  L_L52  0.0042
K_K5530  L_L34  L_L53  0.0040
K_K5531  L_L34  L_L54  0.0038
K_K5532  L_L34  L_L55  0.0036
K_K5533  L_L34  L_L56  0.0034
K_K5534  L_L34  L_L57  0.0033
K_K5535  L_L34  L_L58  0.0032
K_K5536  L_L34  L_L59  0.0030
K_K5537  L_L34  L_L60  0.0029
K_K5538  L_L34  L_L61  0.0028
K_K5539  L_L34  L_L62  0.0027
K_K5540  L_L34  L_L63  0.0026
K_K5541  L_L34  L_L64  0.0025
K_K5542  L_L34  L_L65  0.0024
K_K5543  L_L34  L_L66  0.0024
K_K5544  L_L34  L_L67  0.0023
K_K5545  L_L34  L_L68  0.0022
K_K5546  L_L34  L_L69  0.0022
K_K5547  L_L34  L_L70  0.0021
K_K5548  L_L34  L_L71  0.0020
K_K5549  L_L34  L_L72  0.0020
K_K5550  L_L34  L_L73  0.0019
K_K5551  L_L34  L_L74  0.0019
K_K5552  L_L34  L_L75  0.0019
K_K5553  L_L34  L_L76  0.0018
K_K5554  L_L34  L_L77  0.0018
K_K5555  L_L34  L_L78  0.0017
K_K5556  L_L34  L_L79  0.0017
K_K5557  L_L34  L_L80  0.0017
K_K5558  L_L34  L_L81  0.0016
K_K5559  L_L34  L_L82  0.0016
K_K5560  L_L34  L_L83  0.0015
K_K5561  L_L34  L_L84  0.0015
K_K5562  L_L34  L_L85  0.0015
K_K5563  L_L34  L_L86  0.0015
K_K5564  L_L34  L_L87  0.0014
K_K5565  L_L34  L_L88  0.0014
K_K5566  L_L34  L_L89  0.0014
K_K5567  L_L34  L_L90  0.0014
K_K5568  L_L34  L_L91  0.0013
K_K5569  L_L34  L_L92  0.0013
K_K5570  L_L34  L_L93  0.0013
K_K5571  L_L34  L_L94  0.0013
K_K5572  L_L34  L_L95  0.0013
K_K5573  L_L34  L_L96  0.0012
K_K5574  L_L34  L_L97  0.0012
K_K5575  L_L34  L_L98  0.0012
K_K5576  L_L34  L_L99  0.0012
K_K5577  L_L34  L_L100  0.0011
K_K5578  L_L34  L_L101  0.0011
K_K5579  L_L34  L_L102  0.0011
K_K5580  L_L34  L_L103  0.0011
K_K5581  L_L34  L_L104  0.0011
K_K5582  L_L34  L_L105  0.0011
K_K5583  L_L34  L_L106  0.0011
K_K5584  L_L34  L_L107  0.0010
K_K5585  L_L34  L_L108  0.0010
K_K5586  L_L34  L_L109  0.0010
K_K5587  L_L34  L_L139  0.0023
K_K5588  L_L34  L_L140  0.0024
K_K5589  L_L34  L_L141  0.0024
K_K5590  L_L34  L_L142  0.0025
K_K5591  L_L34  L_L143  0.0026
K_K5592  L_L34  L_L144  0.0027
K_K5593  L_L34  L_L145  0.0028
K_K5594  L_L34  L_L146  0.0029
K_K5595  L_L34  L_L147  0.0030
K_K5596  L_L34  L_L148  0.0032
K_K5597  L_L34  L_L149  0.0033
K_K5598  L_L34  L_L150  0.0034
K_K5599  L_L34  L_L151  0.0036
K_K5600  L_L34  L_L152  0.0038
K_K5601  L_L34  L_L153  0.0040
K_K5602  L_L34  L_L154  0.0042
K_K5603  L_L34  L_L155  0.0045
K_K5604  L_L34  L_L156  0.0047
K_K5605  L_L34  L_L157  0.0051
K_K5606  L_L34  L_L158  0.0054
K_K5607  L_L34  L_L159  0.0058
K_K5608  L_L34  L_L160  0.0063
K_K5609  L_L34  L_L161  0.0069
K_K5610  L_L34  L_L162  0.0076
K_K5611  L_L34  L_L163  0.0084
K_K5612  L_L34  L_L164  0.0095
K_K5613  L_L34  L_L165  0.0109
K_K5614  L_L34  L_L166  0.0127
K_K5615  L_L34  L_L167  0.0152
K_K5616  L_L34  L_L168  0.0191
K_K5617  L_L34  L_L169  0.0256
K_K5618  L_L34  L_L170  0.0389
K_K5619  L_L34  L_L171  0.0812
K_K5620  L_L34  L_L172  0.1569
K_K5621  L_L34  L_L173  0.0812
K_K5622  L_L34  L_L174  0.0389
K_K5623  L_L34  L_L175  0.0256
K_K5624  L_L34  L_L176  0.0191
K_K5625  L_L34  L_L177  0.0152
K_K5626  L_L34  L_L178  0.0127
K_K5627  L_L34  L_L179  0.0109
K_K5628  L_L34  L_L180  0.0095
K_K5629  L_L34  L_L181  0.0084
K_K5630  L_L34  L_L182  0.0076
K_K5631  L_L34  L_L183  0.0069
K_K5632  L_L34  L_L184  0.0063
K_K5633  L_L34  L_L185  0.0058
K_K5634  L_L34  L_L186  0.0054
K_K5635  L_L34  L_L187  0.0051
K_K5636  L_L34  L_L188  0.0047
K_K5637  L_L34  L_L189  0.0045
K_K5638  L_L34  L_L190  0.0042
K_K5639  L_L34  L_L191  0.0040
K_K5640  L_L34  L_L192  0.0038
K_K5641  L_L34  L_L193  0.0036
K_K5642  L_L34  L_L194  0.0034
K_K5643  L_L34  L_L195  0.0033
K_K5644  L_L34  L_L196  0.0032
K_K5645  L_L34  L_L197  0.0030
K_K5646  L_L34  L_L198  0.0029
K_K5647  L_L34  L_L199  0.0028
K_K5648  L_L34  L_L200  0.0027
K_K5649  L_L34  L_L201  0.0026
K_K5650  L_L34  L_L202  0.0025
K_K5651  L_L34  L_L203  0.0024
K_K5652  L_L34  L_L204  0.0024
K_K5653  L_L34  L_L205  0.0023
K_K5654  L_L34  L_L206  0.0022
K_K5655  L_L34  L_L207  0.0022
K_K5656  L_L34  L_L208  0.0021
K_K5657  L_L34  L_L209  0.0020
K_K5658  L_L34  L_L210  0.0020
K_K5659  L_L34  L_L211  0.0019
K_K5660  L_L34  L_L212  0.0019
K_K5661  L_L34  L_L213  0.0018
K_K5662  L_L34  L_L214  0.0018
K_K5663  L_L34  L_L215  0.0018
K_K5664  L_L34  L_L216  0.0017
K_K5665  L_L34  L_L217  0.0017
K_K5666  L_L34  L_L218  0.0016
K_K5667  L_L34  L_L219  0.0016
K_K5668  L_L34  L_L220  0.0016
K_K5669  L_L34  L_L221  0.0015
K_K5670  L_L34  L_L222  0.0015
K_K5671  L_L34  L_L223  0.0015
K_K5672  L_L34  L_L224  0.0015
K_K5673  L_L34  L_L225  0.0014
K_K5674  L_L34  L_L226  0.0014
K_K5675  L_L34  L_L227  0.0014
K_K5676  L_L34  L_L228  0.0014
K_K5677  L_L34  L_L229  0.0013
K_K5678  L_L34  L_L230  0.0013
K_K5679  L_L34  L_L231  0.0013
K_K5680  L_L34  L_L232  0.0013
K_K5681  L_L34  L_L233  0.0012
K_K5682  L_L34  L_L234  0.0012
K_K5683  L_L34  L_L235  0.0012
K_K5684  L_L34  L_L236  0.0012
K_K5685  L_L34  L_L237  0.0012
K_K5686  L_L34  L_L238  0.0011
K_K5687  L_L34  L_L239  0.0011
K_K5688  L_L34  L_L240  0.0011
K_K5689  L_L34  L_L241  0.0011
K_K5690  L_L34  L_L242  0.0011
K_K5691  L_L34  L_L243  0.0011
K_K5692  L_L34  L_L244  0.0011
K_K5693  L_L34  L_L245  0.0010
K_K5694  L_L34  L_L246  0.0010
K_K5695  L_L34  L_L247  0.0010
* *  Branch  NTMP0000000034 - NTMP0000000035
R_R35  NTMP0000000034  nU_35  32.914993m  TC=0,0
V_Ui35  nU_35  nR_35  STIMULUS=U_IND_0000000035
R_V69  nR_35  nV_69  23.280268m  TC=0,0
L_V69  nR_35  nV_69  0.014646uH
R_V70  nV_69  nV_70  7.852787m  TC=0,0
L_V70  nV_69  nV_70  0.073723uH
L_L35  nV_70  NTMP0000000035  6.519695uH
K_K5696  L_L35  L_L36  0.1050
K_K5697  L_L35  L_L37  0.0397
K_K5698  L_L35  L_L38  0.0258
K_K5699  L_L35  L_L39  0.0192
K_K5700  L_L35  L_L40  0.0153
K_K5701  L_L35  L_L41  0.0127
K_K5702  L_L35  L_L42  0.0109
K_K5703  L_L35  L_L43  0.0095
K_K5704  L_L35  L_L44  0.0084
K_K5705  L_L35  L_L45  0.0076
K_K5706  L_L35  L_L46  0.0069
K_K5707  L_L35  L_L47  0.0063
K_K5708  L_L35  L_L48  0.0058
K_K5709  L_L35  L_L49  0.0054
K_K5710  L_L35  L_L50  0.0051
K_K5711  L_L35  L_L51  0.0047
K_K5712  L_L35  L_L52  0.0045
K_K5713  L_L35  L_L53  0.0042
K_K5714  L_L35  L_L54  0.0040
K_K5715  L_L35  L_L55  0.0038
K_K5716  L_L35  L_L56  0.0036
K_K5717  L_L35  L_L57  0.0034
K_K5718  L_L35  L_L58  0.0033
K_K5719  L_L35  L_L59  0.0032
K_K5720  L_L35  L_L60  0.0030
K_K5721  L_L35  L_L61  0.0029
K_K5722  L_L35  L_L62  0.0028
K_K5723  L_L35  L_L63  0.0027
K_K5724  L_L35  L_L64  0.0026
K_K5725  L_L35  L_L65  0.0025
K_K5726  L_L35  L_L66  0.0024
K_K5727  L_L35  L_L67  0.0024
K_K5728  L_L35  L_L68  0.0023
K_K5729  L_L35  L_L69  0.0022
K_K5730  L_L35  L_L70  0.0022
K_K5731  L_L35  L_L71  0.0021
K_K5732  L_L35  L_L72  0.0020
K_K5733  L_L35  L_L73  0.0020
K_K5734  L_L35  L_L74  0.0019
K_K5735  L_L35  L_L75  0.0019
K_K5736  L_L35  L_L76  0.0019
K_K5737  L_L35  L_L77  0.0018
K_K5738  L_L35  L_L78  0.0018
K_K5739  L_L35  L_L79  0.0017
K_K5740  L_L35  L_L80  0.0017
K_K5741  L_L35  L_L81  0.0017
K_K5742  L_L35  L_L82  0.0016
K_K5743  L_L35  L_L83  0.0016
K_K5744  L_L35  L_L84  0.0015
K_K5745  L_L35  L_L85  0.0015
K_K5746  L_L35  L_L86  0.0015
K_K5747  L_L35  L_L87  0.0015
K_K5748  L_L35  L_L88  0.0014
K_K5749  L_L35  L_L89  0.0014
K_K5750  L_L35  L_L90  0.0014
K_K5751  L_L35  L_L91  0.0014
K_K5752  L_L35  L_L92  0.0013
K_K5753  L_L35  L_L93  0.0013
K_K5754  L_L35  L_L94  0.0013
K_K5755  L_L35  L_L95  0.0013
K_K5756  L_L35  L_L96  0.0013
K_K5757  L_L35  L_L97  0.0012
K_K5758  L_L35  L_L98  0.0012
K_K5759  L_L35  L_L99  0.0012
K_K5760  L_L35  L_L100  0.0012
K_K5761  L_L35  L_L101  0.0011
K_K5762  L_L35  L_L102  0.0011
K_K5763  L_L35  L_L103  0.0011
K_K5764  L_L35  L_L104  0.0011
K_K5765  L_L35  L_L105  0.0011
K_K5766  L_L35  L_L106  0.0011
K_K5767  L_L35  L_L107  0.0011
K_K5768  L_L35  L_L108  0.0010
K_K5769  L_L35  L_L109  0.0010
K_K5770  L_L35  L_L110  0.0010
K_K5771  L_L35  L_L139  0.0022
K_K5772  L_L35  L_L140  0.0023
K_K5773  L_L35  L_L141  0.0024
K_K5774  L_L35  L_L142  0.0024
K_K5775  L_L35  L_L143  0.0025
K_K5776  L_L35  L_L144  0.0026
K_K5777  L_L35  L_L145  0.0027
K_K5778  L_L35  L_L146  0.0028
K_K5779  L_L35  L_L147  0.0029
K_K5780  L_L35  L_L148  0.0030
K_K5781  L_L35  L_L149  0.0032
K_K5782  L_L35  L_L150  0.0033
K_K5783  L_L35  L_L151  0.0034
K_K5784  L_L35  L_L152  0.0036
K_K5785  L_L35  L_L153  0.0038
K_K5786  L_L35  L_L154  0.0040
K_K5787  L_L35  L_L155  0.0042
K_K5788  L_L35  L_L156  0.0045
K_K5789  L_L35  L_L157  0.0047
K_K5790  L_L35  L_L158  0.0051
K_K5791  L_L35  L_L159  0.0054
K_K5792  L_L35  L_L160  0.0058
K_K5793  L_L35  L_L161  0.0063
K_K5794  L_L35  L_L162  0.0069
K_K5795  L_L35  L_L163  0.0076
K_K5796  L_L35  L_L164  0.0084
K_K5797  L_L35  L_L165  0.0095
K_K5798  L_L35  L_L166  0.0109
K_K5799  L_L35  L_L167  0.0127
K_K5800  L_L35  L_L168  0.0152
K_K5801  L_L35  L_L169  0.0191
K_K5802  L_L35  L_L170  0.0256
K_K5803  L_L35  L_L171  0.0389
K_K5804  L_L35  L_L172  0.0812
K_K5805  L_L35  L_L173  0.1569
K_K5806  L_L35  L_L174  0.0812
K_K5807  L_L35  L_L175  0.0389
K_K5808  L_L35  L_L176  0.0256
K_K5809  L_L35  L_L177  0.0191
K_K5810  L_L35  L_L178  0.0152
K_K5811  L_L35  L_L179  0.0127
K_K5812  L_L35  L_L180  0.0109
K_K5813  L_L35  L_L181  0.0095
K_K5814  L_L35  L_L182  0.0084
K_K5815  L_L35  L_L183  0.0076
K_K5816  L_L35  L_L184  0.0069
K_K5817  L_L35  L_L185  0.0063
K_K5818  L_L35  L_L186  0.0058
K_K5819  L_L35  L_L187  0.0054
K_K5820  L_L35  L_L188  0.0051
K_K5821  L_L35  L_L189  0.0047
K_K5822  L_L35  L_L190  0.0045
K_K5823  L_L35  L_L191  0.0042
K_K5824  L_L35  L_L192  0.0040
K_K5825  L_L35  L_L193  0.0038
K_K5826  L_L35  L_L194  0.0036
K_K5827  L_L35  L_L195  0.0034
K_K5828  L_L35  L_L196  0.0033
K_K5829  L_L35  L_L197  0.0032
K_K5830  L_L35  L_L198  0.0030
K_K5831  L_L35  L_L199  0.0029
K_K5832  L_L35  L_L200  0.0028
K_K5833  L_L35  L_L201  0.0027
K_K5834  L_L35  L_L202  0.0026
K_K5835  L_L35  L_L203  0.0025
K_K5836  L_L35  L_L204  0.0024
K_K5837  L_L35  L_L205  0.0024
K_K5838  L_L35  L_L206  0.0023
K_K5839  L_L35  L_L207  0.0022
K_K5840  L_L35  L_L208  0.0022
K_K5841  L_L35  L_L209  0.0021
K_K5842  L_L35  L_L210  0.0020
K_K5843  L_L35  L_L211  0.0020
K_K5844  L_L35  L_L212  0.0019
K_K5845  L_L35  L_L213  0.0019
K_K5846  L_L35  L_L214  0.0018
K_K5847  L_L35  L_L215  0.0018
K_K5848  L_L35  L_L216  0.0018
K_K5849  L_L35  L_L217  0.0017
K_K5850  L_L35  L_L218  0.0017
K_K5851  L_L35  L_L219  0.0016
K_K5852  L_L35  L_L220  0.0016
K_K5853  L_L35  L_L221  0.0016
K_K5854  L_L35  L_L222  0.0015
K_K5855  L_L35  L_L223  0.0015
K_K5856  L_L35  L_L224  0.0015
K_K5857  L_L35  L_L225  0.0015
K_K5858  L_L35  L_L226  0.0014
K_K5859  L_L35  L_L227  0.0014
K_K5860  L_L35  L_L228  0.0014
K_K5861  L_L35  L_L229  0.0014
K_K5862  L_L35  L_L230  0.0013
K_K5863  L_L35  L_L231  0.0013
K_K5864  L_L35  L_L232  0.0013
K_K5865  L_L35  L_L233  0.0013
K_K5866  L_L35  L_L234  0.0012
K_K5867  L_L35  L_L235  0.0012
K_K5868  L_L35  L_L236  0.0012
K_K5869  L_L35  L_L237  0.0012
K_K5870  L_L35  L_L238  0.0012
K_K5871  L_L35  L_L239  0.0011
K_K5872  L_L35  L_L240  0.0011
K_K5873  L_L35  L_L241  0.0011
K_K5874  L_L35  L_L242  0.0011
K_K5875  L_L35  L_L243  0.0011
K_K5876  L_L35  L_L244  0.0011
K_K5877  L_L35  L_L245  0.0011
K_K5878  L_L35  L_L246  0.0010
K_K5879  L_L35  L_L247  0.0010
K_K5880  L_L35  L_L248  0.0010
* *  Branch  NTMP0000000035 - NTMP0000000036
R_R36  NTMP0000000035  nU_36  32.914993m  TC=0,0
V_Ui36  nU_36  nR_36  STIMULUS=U_IND_0000000036
R_V71  nR_36  nV_71  23.280268m  TC=0,0
L_V71  nR_36  nV_71  0.014646uH
R_V72  nV_71  nV_72  7.852787m  TC=0,0
L_V72  nV_71  nV_72  0.073723uH
L_L36  nV_72  NTMP0000000036  6.519695uH
K_K5881  L_L36  L_L37  0.1050
K_K5882  L_L36  L_L38  0.0397
K_K5883  L_L36  L_L39  0.0258
K_K5884  L_L36  L_L40  0.0192
K_K5885  L_L36  L_L41  0.0153
K_K5886  L_L36  L_L42  0.0127
K_K5887  L_L36  L_L43  0.0109
K_K5888  L_L36  L_L44  0.0095
K_K5889  L_L36  L_L45  0.0084
K_K5890  L_L36  L_L46  0.0076
K_K5891  L_L36  L_L47  0.0069
K_K5892  L_L36  L_L48  0.0063
K_K5893  L_L36  L_L49  0.0058
K_K5894  L_L36  L_L50  0.0054
K_K5895  L_L36  L_L51  0.0051
K_K5896  L_L36  L_L52  0.0047
K_K5897  L_L36  L_L53  0.0045
K_K5898  L_L36  L_L54  0.0042
K_K5899  L_L36  L_L55  0.0040
K_K5900  L_L36  L_L56  0.0038
K_K5901  L_L36  L_L57  0.0036
K_K5902  L_L36  L_L58  0.0034
K_K5903  L_L36  L_L59  0.0033
K_K5904  L_L36  L_L60  0.0032
K_K5905  L_L36  L_L61  0.0030
K_K5906  L_L36  L_L62  0.0029
K_K5907  L_L36  L_L63  0.0028
K_K5908  L_L36  L_L64  0.0027
K_K5909  L_L36  L_L65  0.0026
K_K5910  L_L36  L_L66  0.0025
K_K5911  L_L36  L_L67  0.0024
K_K5912  L_L36  L_L68  0.0024
K_K5913  L_L36  L_L69  0.0023
K_K5914  L_L36  L_L70  0.0022
K_K5915  L_L36  L_L71  0.0022
K_K5916  L_L36  L_L72  0.0021
K_K5917  L_L36  L_L73  0.0020
K_K5918  L_L36  L_L74  0.0020
K_K5919  L_L36  L_L75  0.0019
K_K5920  L_L36  L_L76  0.0019
K_K5921  L_L36  L_L77  0.0019
K_K5922  L_L36  L_L78  0.0018
K_K5923  L_L36  L_L79  0.0018
K_K5924  L_L36  L_L80  0.0017
K_K5925  L_L36  L_L81  0.0017
K_K5926  L_L36  L_L82  0.0017
K_K5927  L_L36  L_L83  0.0016
K_K5928  L_L36  L_L84  0.0016
K_K5929  L_L36  L_L85  0.0015
K_K5930  L_L36  L_L86  0.0015
K_K5931  L_L36  L_L87  0.0015
K_K5932  L_L36  L_L88  0.0015
K_K5933  L_L36  L_L89  0.0014
K_K5934  L_L36  L_L90  0.0014
K_K5935  L_L36  L_L91  0.0014
K_K5936  L_L36  L_L92  0.0014
K_K5937  L_L36  L_L93  0.0013
K_K5938  L_L36  L_L94  0.0013
K_K5939  L_L36  L_L95  0.0013
K_K5940  L_L36  L_L96  0.0013
K_K5941  L_L36  L_L97  0.0013
K_K5942  L_L36  L_L98  0.0012
K_K5943  L_L36  L_L99  0.0012
K_K5944  L_L36  L_L100  0.0012
K_K5945  L_L36  L_L101  0.0012
K_K5946  L_L36  L_L102  0.0011
K_K5947  L_L36  L_L103  0.0011
K_K5948  L_L36  L_L104  0.0011
K_K5949  L_L36  L_L105  0.0011
K_K5950  L_L36  L_L106  0.0011
K_K5951  L_L36  L_L107  0.0011
K_K5952  L_L36  L_L108  0.0011
K_K5953  L_L36  L_L109  0.0010
K_K5954  L_L36  L_L110  0.0010
K_K5955  L_L36  L_L111  0.0010
K_K5956  L_L36  L_L139  0.0022
K_K5957  L_L36  L_L140  0.0022
K_K5958  L_L36  L_L141  0.0023
K_K5959  L_L36  L_L142  0.0024
K_K5960  L_L36  L_L143  0.0024
K_K5961  L_L36  L_L144  0.0025
K_K5962  L_L36  L_L145  0.0026
K_K5963  L_L36  L_L146  0.0027
K_K5964  L_L36  L_L147  0.0028
K_K5965  L_L36  L_L148  0.0029
K_K5966  L_L36  L_L149  0.0030
K_K5967  L_L36  L_L150  0.0032
K_K5968  L_L36  L_L151  0.0033
K_K5969  L_L36  L_L152  0.0034
K_K5970  L_L36  L_L153  0.0036
K_K5971  L_L36  L_L154  0.0038
K_K5972  L_L36  L_L155  0.0040
K_K5973  L_L36  L_L156  0.0042
K_K5974  L_L36  L_L157  0.0045
K_K5975  L_L36  L_L158  0.0047
K_K5976  L_L36  L_L159  0.0051
K_K5977  L_L36  L_L160  0.0054
K_K5978  L_L36  L_L161  0.0058
K_K5979  L_L36  L_L162  0.0063
K_K5980  L_L36  L_L163  0.0069
K_K5981  L_L36  L_L164  0.0076
K_K5982  L_L36  L_L165  0.0084
K_K5983  L_L36  L_L166  0.0095
K_K5984  L_L36  L_L167  0.0109
K_K5985  L_L36  L_L168  0.0127
K_K5986  L_L36  L_L169  0.0152
K_K5987  L_L36  L_L170  0.0191
K_K5988  L_L36  L_L171  0.0256
K_K5989  L_L36  L_L172  0.0389
K_K5990  L_L36  L_L173  0.0812
K_K5991  L_L36  L_L174  0.1569
K_K5992  L_L36  L_L175  0.0812
K_K5993  L_L36  L_L176  0.0389
K_K5994  L_L36  L_L177  0.0256
K_K5995  L_L36  L_L178  0.0191
K_K5996  L_L36  L_L179  0.0152
K_K5997  L_L36  L_L180  0.0127
K_K5998  L_L36  L_L181  0.0109
K_K5999  L_L36  L_L182  0.0095
K_K6000  L_L36  L_L183  0.0084
K_K6001  L_L36  L_L184  0.0076
K_K6002  L_L36  L_L185  0.0069
K_K6003  L_L36  L_L186  0.0063
K_K6004  L_L36  L_L187  0.0058
K_K6005  L_L36  L_L188  0.0054
K_K6006  L_L36  L_L189  0.0051
K_K6007  L_L36  L_L190  0.0047
K_K6008  L_L36  L_L191  0.0045
K_K6009  L_L36  L_L192  0.0042
K_K6010  L_L36  L_L193  0.0040
K_K6011  L_L36  L_L194  0.0038
K_K6012  L_L36  L_L195  0.0036
K_K6013  L_L36  L_L196  0.0034
K_K6014  L_L36  L_L197  0.0033
K_K6015  L_L36  L_L198  0.0032
K_K6016  L_L36  L_L199  0.0030
K_K6017  L_L36  L_L200  0.0029
K_K6018  L_L36  L_L201  0.0028
K_K6019  L_L36  L_L202  0.0027
K_K6020  L_L36  L_L203  0.0026
K_K6021  L_L36  L_L204  0.0025
K_K6022  L_L36  L_L205  0.0024
K_K6023  L_L36  L_L206  0.0024
K_K6024  L_L36  L_L207  0.0023
K_K6025  L_L36  L_L208  0.0022
K_K6026  L_L36  L_L209  0.0022
K_K6027  L_L36  L_L210  0.0021
K_K6028  L_L36  L_L211  0.0020
K_K6029  L_L36  L_L212  0.0020
K_K6030  L_L36  L_L213  0.0019
K_K6031  L_L36  L_L214  0.0019
K_K6032  L_L36  L_L215  0.0018
K_K6033  L_L36  L_L216  0.0018
K_K6034  L_L36  L_L217  0.0018
K_K6035  L_L36  L_L218  0.0017
K_K6036  L_L36  L_L219  0.0017
K_K6037  L_L36  L_L220  0.0016
K_K6038  L_L36  L_L221  0.0016
K_K6039  L_L36  L_L222  0.0016
K_K6040  L_L36  L_L223  0.0015
K_K6041  L_L36  L_L224  0.0015
K_K6042  L_L36  L_L225  0.0015
K_K6043  L_L36  L_L226  0.0015
K_K6044  L_L36  L_L227  0.0014
K_K6045  L_L36  L_L228  0.0014
K_K6046  L_L36  L_L229  0.0014
K_K6047  L_L36  L_L230  0.0014
K_K6048  L_L36  L_L231  0.0013
K_K6049  L_L36  L_L232  0.0013
K_K6050  L_L36  L_L233  0.0013
K_K6051  L_L36  L_L234  0.0013
K_K6052  L_L36  L_L235  0.0012
K_K6053  L_L36  L_L236  0.0012
K_K6054  L_L36  L_L237  0.0012
K_K6055  L_L36  L_L238  0.0012
K_K6056  L_L36  L_L239  0.0012
K_K6057  L_L36  L_L240  0.0011
K_K6058  L_L36  L_L241  0.0011
K_K6059  L_L36  L_L242  0.0011
K_K6060  L_L36  L_L243  0.0011
K_K6061  L_L36  L_L244  0.0011
K_K6062  L_L36  L_L245  0.0011
K_K6063  L_L36  L_L246  0.0011
K_K6064  L_L36  L_L247  0.0010
K_K6065  L_L36  L_L248  0.0010
K_K6066  L_L36  L_L249  0.0010
* *  Branch  NTMP0000000036 - NTMP0000000037
R_R37  NTMP0000000036  nU_37  32.914993m  TC=0,0
V_Ui37  nU_37  nR_37  STIMULUS=U_IND_0000000037
R_V73  nR_37  nV_73  23.280268m  TC=0,0
L_V73  nR_37  nV_73  0.014646uH
R_V74  nV_73  nV_74  7.852787m  TC=0,0
L_V74  nV_73  nV_74  0.073723uH
L_L37  nV_74  NTMP0000000037  6.519695uH
K_K6067  L_L37  L_L38  0.1050
K_K6068  L_L37  L_L39  0.0397
K_K6069  L_L37  L_L40  0.0258
K_K6070  L_L37  L_L41  0.0192
K_K6071  L_L37  L_L42  0.0153
K_K6072  L_L37  L_L43  0.0127
K_K6073  L_L37  L_L44  0.0109
K_K6074  L_L37  L_L45  0.0095
K_K6075  L_L37  L_L46  0.0084
K_K6076  L_L37  L_L47  0.0076
K_K6077  L_L37  L_L48  0.0069
K_K6078  L_L37  L_L49  0.0063
K_K6079  L_L37  L_L50  0.0058
K_K6080  L_L37  L_L51  0.0054
K_K6081  L_L37  L_L52  0.0051
K_K6082  L_L37  L_L53  0.0047
K_K6083  L_L37  L_L54  0.0045
K_K6084  L_L37  L_L55  0.0042
K_K6085  L_L37  L_L56  0.0040
K_K6086  L_L37  L_L57  0.0038
K_K6087  L_L37  L_L58  0.0036
K_K6088  L_L37  L_L59  0.0034
K_K6089  L_L37  L_L60  0.0033
K_K6090  L_L37  L_L61  0.0032
K_K6091  L_L37  L_L62  0.0030
K_K6092  L_L37  L_L63  0.0029
K_K6093  L_L37  L_L64  0.0028
K_K6094  L_L37  L_L65  0.0027
K_K6095  L_L37  L_L66  0.0026
K_K6096  L_L37  L_L67  0.0025
K_K6097  L_L37  L_L68  0.0024
K_K6098  L_L37  L_L69  0.0024
K_K6099  L_L37  L_L70  0.0023
K_K6100  L_L37  L_L71  0.0022
K_K6101  L_L37  L_L72  0.0022
K_K6102  L_L37  L_L73  0.0021
K_K6103  L_L37  L_L74  0.0020
K_K6104  L_L37  L_L75  0.0020
K_K6105  L_L37  L_L76  0.0019
K_K6106  L_L37  L_L77  0.0019
K_K6107  L_L37  L_L78  0.0018
K_K6108  L_L37  L_L79  0.0018
K_K6109  L_L37  L_L80  0.0018
K_K6110  L_L37  L_L81  0.0017
K_K6111  L_L37  L_L82  0.0017
K_K6112  L_L37  L_L83  0.0016
K_K6113  L_L37  L_L84  0.0016
K_K6114  L_L37  L_L85  0.0016
K_K6115  L_L37  L_L86  0.0015
K_K6116  L_L37  L_L87  0.0015
K_K6117  L_L37  L_L88  0.0015
K_K6118  L_L37  L_L89  0.0015
K_K6119  L_L37  L_L90  0.0014
K_K6120  L_L37  L_L91  0.0014
K_K6121  L_L37  L_L92  0.0014
K_K6122  L_L37  L_L93  0.0014
K_K6123  L_L37  L_L94  0.0013
K_K6124  L_L37  L_L95  0.0013
K_K6125  L_L37  L_L96  0.0013
K_K6126  L_L37  L_L97  0.0013
K_K6127  L_L37  L_L98  0.0013
K_K6128  L_L37  L_L99  0.0012
K_K6129  L_L37  L_L100  0.0012
K_K6130  L_L37  L_L101  0.0012
K_K6131  L_L37  L_L102  0.0012
K_K6132  L_L37  L_L103  0.0011
K_K6133  L_L37  L_L104  0.0011
K_K6134  L_L37  L_L105  0.0011
K_K6135  L_L37  L_L106  0.0011
K_K6136  L_L37  L_L107  0.0011
K_K6137  L_L37  L_L108  0.0011
K_K6138  L_L37  L_L109  0.0011
K_K6139  L_L37  L_L110  0.0010
K_K6140  L_L37  L_L111  0.0010
K_K6141  L_L37  L_L112  0.0010
K_K6142  L_L37  L_L139  0.0021
K_K6143  L_L37  L_L140  0.0022
K_K6144  L_L37  L_L141  0.0022
K_K6145  L_L37  L_L142  0.0023
K_K6146  L_L37  L_L143  0.0024
K_K6147  L_L37  L_L144  0.0024
K_K6148  L_L37  L_L145  0.0025
K_K6149  L_L37  L_L146  0.0026
K_K6150  L_L37  L_L147  0.0027
K_K6151  L_L37  L_L148  0.0028
K_K6152  L_L37  L_L149  0.0029
K_K6153  L_L37  L_L150  0.0030
K_K6154  L_L37  L_L151  0.0032
K_K6155  L_L37  L_L152  0.0033
K_K6156  L_L37  L_L153  0.0034
K_K6157  L_L37  L_L154  0.0036
K_K6158  L_L37  L_L155  0.0038
K_K6159  L_L37  L_L156  0.0040
K_K6160  L_L37  L_L157  0.0042
K_K6161  L_L37  L_L158  0.0045
K_K6162  L_L37  L_L159  0.0047
K_K6163  L_L37  L_L160  0.0051
K_K6164  L_L37  L_L161  0.0054
K_K6165  L_L37  L_L162  0.0058
K_K6166  L_L37  L_L163  0.0063
K_K6167  L_L37  L_L164  0.0069
K_K6168  L_L37  L_L165  0.0076
K_K6169  L_L37  L_L166  0.0084
K_K6170  L_L37  L_L167  0.0095
K_K6171  L_L37  L_L168  0.0109
K_K6172  L_L37  L_L169  0.0127
K_K6173  L_L37  L_L170  0.0152
K_K6174  L_L37  L_L171  0.0191
K_K6175  L_L37  L_L172  0.0256
K_K6176  L_L37  L_L173  0.0389
K_K6177  L_L37  L_L174  0.0812
K_K6178  L_L37  L_L175  0.1569
K_K6179  L_L37  L_L176  0.0812
K_K6180  L_L37  L_L177  0.0389
K_K6181  L_L37  L_L178  0.0256
K_K6182  L_L37  L_L179  0.0191
K_K6183  L_L37  L_L180  0.0152
K_K6184  L_L37  L_L181  0.0127
K_K6185  L_L37  L_L182  0.0109
K_K6186  L_L37  L_L183  0.0095
K_K6187  L_L37  L_L184  0.0084
K_K6188  L_L37  L_L185  0.0076
K_K6189  L_L37  L_L186  0.0069
K_K6190  L_L37  L_L187  0.0063
K_K6191  L_L37  L_L188  0.0058
K_K6192  L_L37  L_L189  0.0054
K_K6193  L_L37  L_L190  0.0051
K_K6194  L_L37  L_L191  0.0047
K_K6195  L_L37  L_L192  0.0045
K_K6196  L_L37  L_L193  0.0042
K_K6197  L_L37  L_L194  0.0040
K_K6198  L_L37  L_L195  0.0038
K_K6199  L_L37  L_L196  0.0036
K_K6200  L_L37  L_L197  0.0034
K_K6201  L_L37  L_L198  0.0033
K_K6202  L_L37  L_L199  0.0032
K_K6203  L_L37  L_L200  0.0030
K_K6204  L_L37  L_L201  0.0029
K_K6205  L_L37  L_L202  0.0028
K_K6206  L_L37  L_L203  0.0027
K_K6207  L_L37  L_L204  0.0026
K_K6208  L_L37  L_L205  0.0025
K_K6209  L_L37  L_L206  0.0024
K_K6210  L_L37  L_L207  0.0024
K_K6211  L_L37  L_L208  0.0023
K_K6212  L_L37  L_L209  0.0022
K_K6213  L_L37  L_L210  0.0022
K_K6214  L_L37  L_L211  0.0021
K_K6215  L_L37  L_L212  0.0020
K_K6216  L_L37  L_L213  0.0020
K_K6217  L_L37  L_L214  0.0019
K_K6218  L_L37  L_L215  0.0019
K_K6219  L_L37  L_L216  0.0018
K_K6220  L_L37  L_L217  0.0018
K_K6221  L_L37  L_L218  0.0018
K_K6222  L_L37  L_L219  0.0017
K_K6223  L_L37  L_L220  0.0017
K_K6224  L_L37  L_L221  0.0016
K_K6225  L_L37  L_L222  0.0016
K_K6226  L_L37  L_L223  0.0016
K_K6227  L_L37  L_L224  0.0015
K_K6228  L_L37  L_L225  0.0015
K_K6229  L_L37  L_L226  0.0015
K_K6230  L_L37  L_L227  0.0015
K_K6231  L_L37  L_L228  0.0014
K_K6232  L_L37  L_L229  0.0014
K_K6233  L_L37  L_L230  0.0014
K_K6234  L_L37  L_L231  0.0014
K_K6235  L_L37  L_L232  0.0013
K_K6236  L_L37  L_L233  0.0013
K_K6237  L_L37  L_L234  0.0013
K_K6238  L_L37  L_L235  0.0013
K_K6239  L_L37  L_L236  0.0012
K_K6240  L_L37  L_L237  0.0012
K_K6241  L_L37  L_L238  0.0012
K_K6242  L_L37  L_L239  0.0012
K_K6243  L_L37  L_L240  0.0012
K_K6244  L_L37  L_L241  0.0011
K_K6245  L_L37  L_L242  0.0011
K_K6246  L_L37  L_L243  0.0011
K_K6247  L_L37  L_L244  0.0011
K_K6248  L_L37  L_L245  0.0011
K_K6249  L_L37  L_L246  0.0011
K_K6250  L_L37  L_L247  0.0011
K_K6251  L_L37  L_L248  0.0010
K_K6252  L_L37  L_L249  0.0010
K_K6253  L_L37  L_L250  0.0010
* *  Branch  NTMP0000000037 - NTMP0000000038
R_R38  NTMP0000000037  nU_38  32.914993m  TC=0,0
V_Ui38  nU_38  nR_38  STIMULUS=U_IND_0000000038
R_V75  nR_38  nV_75  23.280268m  TC=0,0
L_V75  nR_38  nV_75  0.014646uH
R_V76  nV_75  nV_76  7.852787m  TC=0,0
L_V76  nV_75  nV_76  0.073723uH
L_L38  nV_76  NTMP0000000038  6.519695uH
K_K6254  L_L38  L_L39  0.1050
K_K6255  L_L38  L_L40  0.0397
K_K6256  L_L38  L_L41  0.0258
K_K6257  L_L38  L_L42  0.0192
K_K6258  L_L38  L_L43  0.0153
K_K6259  L_L38  L_L44  0.0127
K_K6260  L_L38  L_L45  0.0109
K_K6261  L_L38  L_L46  0.0095
K_K6262  L_L38  L_L47  0.0084
K_K6263  L_L38  L_L48  0.0076
K_K6264  L_L38  L_L49  0.0069
K_K6265  L_L38  L_L50  0.0063
K_K6266  L_L38  L_L51  0.0058
K_K6267  L_L38  L_L52  0.0054
K_K6268  L_L38  L_L53  0.0051
K_K6269  L_L38  L_L54  0.0047
K_K6270  L_L38  L_L55  0.0045
K_K6271  L_L38  L_L56  0.0042
K_K6272  L_L38  L_L57  0.0040
K_K6273  L_L38  L_L58  0.0038
K_K6274  L_L38  L_L59  0.0036
K_K6275  L_L38  L_L60  0.0034
K_K6276  L_L38  L_L61  0.0033
K_K6277  L_L38  L_L62  0.0032
K_K6278  L_L38  L_L63  0.0030
K_K6279  L_L38  L_L64  0.0029
K_K6280  L_L38  L_L65  0.0028
K_K6281  L_L38  L_L66  0.0027
K_K6282  L_L38  L_L67  0.0026
K_K6283  L_L38  L_L68  0.0025
K_K6284  L_L38  L_L69  0.0024
K_K6285  L_L38  L_L70  0.0024
K_K6286  L_L38  L_L71  0.0023
K_K6287  L_L38  L_L72  0.0022
K_K6288  L_L38  L_L73  0.0022
K_K6289  L_L38  L_L74  0.0021
K_K6290  L_L38  L_L75  0.0020
K_K6291  L_L38  L_L76  0.0020
K_K6292  L_L38  L_L77  0.0019
K_K6293  L_L38  L_L78  0.0019
K_K6294  L_L38  L_L79  0.0018
K_K6295  L_L38  L_L80  0.0018
K_K6296  L_L38  L_L81  0.0018
K_K6297  L_L38  L_L82  0.0017
K_K6298  L_L38  L_L83  0.0017
K_K6299  L_L38  L_L84  0.0016
K_K6300  L_L38  L_L85  0.0016
K_K6301  L_L38  L_L86  0.0016
K_K6302  L_L38  L_L87  0.0016
K_K6303  L_L38  L_L88  0.0015
K_K6304  L_L38  L_L89  0.0015
K_K6305  L_L38  L_L90  0.0015
K_K6306  L_L38  L_L91  0.0014
K_K6307  L_L38  L_L92  0.0014
K_K6308  L_L38  L_L93  0.0014
K_K6309  L_L38  L_L94  0.0014
K_K6310  L_L38  L_L95  0.0013
K_K6311  L_L38  L_L96  0.0013
K_K6312  L_L38  L_L97  0.0013
K_K6313  L_L38  L_L98  0.0013
K_K6314  L_L38  L_L99  0.0013
K_K6315  L_L38  L_L100  0.0012
K_K6316  L_L38  L_L101  0.0012
K_K6317  L_L38  L_L102  0.0012
K_K6318  L_L38  L_L103  0.0012
K_K6319  L_L38  L_L104  0.0011
K_K6320  L_L38  L_L105  0.0011
K_K6321  L_L38  L_L106  0.0011
K_K6322  L_L38  L_L107  0.0011
K_K6323  L_L38  L_L108  0.0011
K_K6324  L_L38  L_L109  0.0011
K_K6325  L_L38  L_L110  0.0011
K_K6326  L_L38  L_L111  0.0010
K_K6327  L_L38  L_L112  0.0010
K_K6328  L_L38  L_L113  0.0010
K_K6329  L_L38  L_L139  0.0020
K_K6330  L_L38  L_L140  0.0021
K_K6331  L_L38  L_L141  0.0022
K_K6332  L_L38  L_L142  0.0022
K_K6333  L_L38  L_L143  0.0023
K_K6334  L_L38  L_L144  0.0024
K_K6335  L_L38  L_L145  0.0024
K_K6336  L_L38  L_L146  0.0025
K_K6337  L_L38  L_L147  0.0026
K_K6338  L_L38  L_L148  0.0027
K_K6339  L_L38  L_L149  0.0028
K_K6340  L_L38  L_L150  0.0029
K_K6341  L_L38  L_L151  0.0030
K_K6342  L_L38  L_L152  0.0032
K_K6343  L_L38  L_L153  0.0033
K_K6344  L_L38  L_L154  0.0034
K_K6345  L_L38  L_L155  0.0036
K_K6346  L_L38  L_L156  0.0038
K_K6347  L_L38  L_L157  0.0040
K_K6348  L_L38  L_L158  0.0042
K_K6349  L_L38  L_L159  0.0045
K_K6350  L_L38  L_L160  0.0047
K_K6351  L_L38  L_L161  0.0051
K_K6352  L_L38  L_L162  0.0054
K_K6353  L_L38  L_L163  0.0058
K_K6354  L_L38  L_L164  0.0063
K_K6355  L_L38  L_L165  0.0069
K_K6356  L_L38  L_L166  0.0076
K_K6357  L_L38  L_L167  0.0084
K_K6358  L_L38  L_L168  0.0095
K_K6359  L_L38  L_L169  0.0109
K_K6360  L_L38  L_L170  0.0127
K_K6361  L_L38  L_L171  0.0152
K_K6362  L_L38  L_L172  0.0191
K_K6363  L_L38  L_L173  0.0256
K_K6364  L_L38  L_L174  0.0389
K_K6365  L_L38  L_L175  0.0812
K_K6366  L_L38  L_L176  0.1569
K_K6367  L_L38  L_L177  0.0812
K_K6368  L_L38  L_L178  0.0389
K_K6369  L_L38  L_L179  0.0256
K_K6370  L_L38  L_L180  0.0191
K_K6371  L_L38  L_L181  0.0152
K_K6372  L_L38  L_L182  0.0127
K_K6373  L_L38  L_L183  0.0109
K_K6374  L_L38  L_L184  0.0095
K_K6375  L_L38  L_L185  0.0084
K_K6376  L_L38  L_L186  0.0076
K_K6377  L_L38  L_L187  0.0069
K_K6378  L_L38  L_L188  0.0063
K_K6379  L_L38  L_L189  0.0058
K_K6380  L_L38  L_L190  0.0054
K_K6381  L_L38  L_L191  0.0051
K_K6382  L_L38  L_L192  0.0047
K_K6383  L_L38  L_L193  0.0045
K_K6384  L_L38  L_L194  0.0042
K_K6385  L_L38  L_L195  0.0040
K_K6386  L_L38  L_L196  0.0038
K_K6387  L_L38  L_L197  0.0036
K_K6388  L_L38  L_L198  0.0034
K_K6389  L_L38  L_L199  0.0033
K_K6390  L_L38  L_L200  0.0032
K_K6391  L_L38  L_L201  0.0030
K_K6392  L_L38  L_L202  0.0029
K_K6393  L_L38  L_L203  0.0028
K_K6394  L_L38  L_L204  0.0027
K_K6395  L_L38  L_L205  0.0026
K_K6396  L_L38  L_L206  0.0025
K_K6397  L_L38  L_L207  0.0024
K_K6398  L_L38  L_L208  0.0024
K_K6399  L_L38  L_L209  0.0023
K_K6400  L_L38  L_L210  0.0022
K_K6401  L_L38  L_L211  0.0022
K_K6402  L_L38  L_L212  0.0021
K_K6403  L_L38  L_L213  0.0020
K_K6404  L_L38  L_L214  0.0020
K_K6405  L_L38  L_L215  0.0019
K_K6406  L_L38  L_L216  0.0019
K_K6407  L_L38  L_L217  0.0018
K_K6408  L_L38  L_L218  0.0018
K_K6409  L_L38  L_L219  0.0018
K_K6410  L_L38  L_L220  0.0017
K_K6411  L_L38  L_L221  0.0017
K_K6412  L_L38  L_L222  0.0016
K_K6413  L_L38  L_L223  0.0016
K_K6414  L_L38  L_L224  0.0016
K_K6415  L_L38  L_L225  0.0015
K_K6416  L_L38  L_L226  0.0015
K_K6417  L_L38  L_L227  0.0015
K_K6418  L_L38  L_L228  0.0015
K_K6419  L_L38  L_L229  0.0014
K_K6420  L_L38  L_L230  0.0014
K_K6421  L_L38  L_L231  0.0014
K_K6422  L_L38  L_L232  0.0014
K_K6423  L_L38  L_L233  0.0013
K_K6424  L_L38  L_L234  0.0013
K_K6425  L_L38  L_L235  0.0013
K_K6426  L_L38  L_L236  0.0013
K_K6427  L_L38  L_L237  0.0012
K_K6428  L_L38  L_L238  0.0012
K_K6429  L_L38  L_L239  0.0012
K_K6430  L_L38  L_L240  0.0012
K_K6431  L_L38  L_L241  0.0012
K_K6432  L_L38  L_L242  0.0011
K_K6433  L_L38  L_L243  0.0011
K_K6434  L_L38  L_L244  0.0011
K_K6435  L_L38  L_L245  0.0011
K_K6436  L_L38  L_L246  0.0011
K_K6437  L_L38  L_L247  0.0011
K_K6438  L_L38  L_L248  0.0011
K_K6439  L_L38  L_L249  0.0010
K_K6440  L_L38  L_L250  0.0010
K_K6441  L_L38  L_L251  0.0010
* *  Branch  NTMP0000000038 - NTMP0000000039
R_R39  NTMP0000000038  nU_39  32.914993m  TC=0,0
V_Ui39  nU_39  nR_39  STIMULUS=U_IND_0000000039
R_V77  nR_39  nV_77  23.280268m  TC=0,0
L_V77  nR_39  nV_77  0.014646uH
R_V78  nV_77  nV_78  7.852787m  TC=0,0
L_V78  nV_77  nV_78  0.073723uH
L_L39  nV_78  NTMP0000000039  6.519695uH
K_K6442  L_L39  L_L40  0.1050
K_K6443  L_L39  L_L41  0.0397
K_K6444  L_L39  L_L42  0.0258
K_K6445  L_L39  L_L43  0.0192
K_K6446  L_L39  L_L44  0.0153
K_K6447  L_L39  L_L45  0.0127
K_K6448  L_L39  L_L46  0.0109
K_K6449  L_L39  L_L47  0.0095
K_K6450  L_L39  L_L48  0.0084
K_K6451  L_L39  L_L49  0.0076
K_K6452  L_L39  L_L50  0.0069
K_K6453  L_L39  L_L51  0.0063
K_K6454  L_L39  L_L52  0.0058
K_K6455  L_L39  L_L53  0.0054
K_K6456  L_L39  L_L54  0.0051
K_K6457  L_L39  L_L55  0.0047
K_K6458  L_L39  L_L56  0.0045
K_K6459  L_L39  L_L57  0.0042
K_K6460  L_L39  L_L58  0.0040
K_K6461  L_L39  L_L59  0.0038
K_K6462  L_L39  L_L60  0.0036
K_K6463  L_L39  L_L61  0.0034
K_K6464  L_L39  L_L62  0.0033
K_K6465  L_L39  L_L63  0.0032
K_K6466  L_L39  L_L64  0.0030
K_K6467  L_L39  L_L65  0.0029
K_K6468  L_L39  L_L66  0.0028
K_K6469  L_L39  L_L67  0.0027
K_K6470  L_L39  L_L68  0.0026
K_K6471  L_L39  L_L69  0.0025
K_K6472  L_L39  L_L70  0.0024
K_K6473  L_L39  L_L71  0.0024
K_K6474  L_L39  L_L72  0.0023
K_K6475  L_L39  L_L73  0.0022
K_K6476  L_L39  L_L74  0.0022
K_K6477  L_L39  L_L75  0.0021
K_K6478  L_L39  L_L76  0.0020
K_K6479  L_L39  L_L77  0.0020
K_K6480  L_L39  L_L78  0.0019
K_K6481  L_L39  L_L79  0.0019
K_K6482  L_L39  L_L80  0.0018
K_K6483  L_L39  L_L81  0.0018
K_K6484  L_L39  L_L82  0.0018
K_K6485  L_L39  L_L83  0.0017
K_K6486  L_L39  L_L84  0.0017
K_K6487  L_L39  L_L85  0.0016
K_K6488  L_L39  L_L86  0.0016
K_K6489  L_L39  L_L87  0.0016
K_K6490  L_L39  L_L88  0.0016
K_K6491  L_L39  L_L89  0.0015
K_K6492  L_L39  L_L90  0.0015
K_K6493  L_L39  L_L91  0.0015
K_K6494  L_L39  L_L92  0.0014
K_K6495  L_L39  L_L93  0.0014
K_K6496  L_L39  L_L94  0.0014
K_K6497  L_L39  L_L95  0.0014
K_K6498  L_L39  L_L96  0.0013
K_K6499  L_L39  L_L97  0.0013
K_K6500  L_L39  L_L98  0.0013
K_K6501  L_L39  L_L99  0.0013
K_K6502  L_L39  L_L100  0.0013
K_K6503  L_L39  L_L101  0.0012
K_K6504  L_L39  L_L102  0.0012
K_K6505  L_L39  L_L103  0.0012
K_K6506  L_L39  L_L104  0.0012
K_K6507  L_L39  L_L105  0.0011
K_K6508  L_L39  L_L106  0.0011
K_K6509  L_L39  L_L107  0.0011
K_K6510  L_L39  L_L108  0.0011
K_K6511  L_L39  L_L109  0.0011
K_K6512  L_L39  L_L110  0.0011
K_K6513  L_L39  L_L111  0.0011
K_K6514  L_L39  L_L112  0.0010
K_K6515  L_L39  L_L113  0.0010
K_K6516  L_L39  L_L114  0.0010
K_K6517  L_L39  L_L139  0.0020
K_K6518  L_L39  L_L140  0.0020
K_K6519  L_L39  L_L141  0.0021
K_K6520  L_L39  L_L142  0.0022
K_K6521  L_L39  L_L143  0.0022
K_K6522  L_L39  L_L144  0.0023
K_K6523  L_L39  L_L145  0.0024
K_K6524  L_L39  L_L146  0.0024
K_K6525  L_L39  L_L147  0.0025
K_K6526  L_L39  L_L148  0.0026
K_K6527  L_L39  L_L149  0.0027
K_K6528  L_L39  L_L150  0.0028
K_K6529  L_L39  L_L151  0.0029
K_K6530  L_L39  L_L152  0.0030
K_K6531  L_L39  L_L153  0.0032
K_K6532  L_L39  L_L154  0.0033
K_K6533  L_L39  L_L155  0.0034
K_K6534  L_L39  L_L156  0.0036
K_K6535  L_L39  L_L157  0.0038
K_K6536  L_L39  L_L158  0.0040
K_K6537  L_L39  L_L159  0.0042
K_K6538  L_L39  L_L160  0.0045
K_K6539  L_L39  L_L161  0.0047
K_K6540  L_L39  L_L162  0.0051
K_K6541  L_L39  L_L163  0.0054
K_K6542  L_L39  L_L164  0.0058
K_K6543  L_L39  L_L165  0.0063
K_K6544  L_L39  L_L166  0.0069
K_K6545  L_L39  L_L167  0.0076
K_K6546  L_L39  L_L168  0.0084
K_K6547  L_L39  L_L169  0.0095
K_K6548  L_L39  L_L170  0.0109
K_K6549  L_L39  L_L171  0.0127
K_K6550  L_L39  L_L172  0.0152
K_K6551  L_L39  L_L173  0.0191
K_K6552  L_L39  L_L174  0.0256
K_K6553  L_L39  L_L175  0.0389
K_K6554  L_L39  L_L176  0.0812
K_K6555  L_L39  L_L177  0.1569
K_K6556  L_L39  L_L178  0.0812
K_K6557  L_L39  L_L179  0.0389
K_K6558  L_L39  L_L180  0.0256
K_K6559  L_L39  L_L181  0.0191
K_K6560  L_L39  L_L182  0.0152
K_K6561  L_L39  L_L183  0.0127
K_K6562  L_L39  L_L184  0.0109
K_K6563  L_L39  L_L185  0.0095
K_K6564  L_L39  L_L186  0.0084
K_K6565  L_L39  L_L187  0.0076
K_K6566  L_L39  L_L188  0.0069
K_K6567  L_L39  L_L189  0.0063
K_K6568  L_L39  L_L190  0.0058
K_K6569  L_L39  L_L191  0.0054
K_K6570  L_L39  L_L192  0.0051
K_K6571  L_L39  L_L193  0.0047
K_K6572  L_L39  L_L194  0.0045
K_K6573  L_L39  L_L195  0.0042
K_K6574  L_L39  L_L196  0.0040
K_K6575  L_L39  L_L197  0.0038
K_K6576  L_L39  L_L198  0.0036
K_K6577  L_L39  L_L199  0.0034
K_K6578  L_L39  L_L200  0.0033
K_K6579  L_L39  L_L201  0.0032
K_K6580  L_L39  L_L202  0.0030
K_K6581  L_L39  L_L203  0.0029
K_K6582  L_L39  L_L204  0.0028
K_K6583  L_L39  L_L205  0.0027
K_K6584  L_L39  L_L206  0.0026
K_K6585  L_L39  L_L207  0.0025
K_K6586  L_L39  L_L208  0.0024
K_K6587  L_L39  L_L209  0.0024
K_K6588  L_L39  L_L210  0.0023
K_K6589  L_L39  L_L211  0.0022
K_K6590  L_L39  L_L212  0.0022
K_K6591  L_L39  L_L213  0.0021
K_K6592  L_L39  L_L214  0.0020
K_K6593  L_L39  L_L215  0.0020
K_K6594  L_L39  L_L216  0.0019
K_K6595  L_L39  L_L217  0.0019
K_K6596  L_L39  L_L218  0.0018
K_K6597  L_L39  L_L219  0.0018
K_K6598  L_L39  L_L220  0.0018
K_K6599  L_L39  L_L221  0.0017
K_K6600  L_L39  L_L222  0.0017
K_K6601  L_L39  L_L223  0.0016
K_K6602  L_L39  L_L224  0.0016
K_K6603  L_L39  L_L225  0.0016
K_K6604  L_L39  L_L226  0.0015
K_K6605  L_L39  L_L227  0.0015
K_K6606  L_L39  L_L228  0.0015
K_K6607  L_L39  L_L229  0.0015
K_K6608  L_L39  L_L230  0.0014
K_K6609  L_L39  L_L231  0.0014
K_K6610  L_L39  L_L232  0.0014
K_K6611  L_L39  L_L233  0.0014
K_K6612  L_L39  L_L234  0.0013
K_K6613  L_L39  L_L235  0.0013
K_K6614  L_L39  L_L236  0.0013
K_K6615  L_L39  L_L237  0.0013
K_K6616  L_L39  L_L238  0.0012
K_K6617  L_L39  L_L239  0.0012
K_K6618  L_L39  L_L240  0.0012
K_K6619  L_L39  L_L241  0.0012
K_K6620  L_L39  L_L242  0.0012
K_K6621  L_L39  L_L243  0.0011
K_K6622  L_L39  L_L244  0.0011
K_K6623  L_L39  L_L245  0.0011
K_K6624  L_L39  L_L246  0.0011
K_K6625  L_L39  L_L247  0.0011
K_K6626  L_L39  L_L248  0.0011
K_K6627  L_L39  L_L249  0.0011
K_K6628  L_L39  L_L250  0.0010
K_K6629  L_L39  L_L251  0.0010
K_K6630  L_L39  L_L252  0.0010
* *  Branch  NTMP0000000039 - NTMP0000000040
R_R40  NTMP0000000039  nU_40  32.914993m  TC=0,0
V_Ui40  nU_40  nR_40  STIMULUS=U_IND_0000000040
R_V79  nR_40  nV_79  23.280268m  TC=0,0
L_V79  nR_40  nV_79  0.014646uH
R_V80  nV_79  nV_80  7.852787m  TC=0,0
L_V80  nV_79  nV_80  0.073723uH
L_L40  nV_80  NTMP0000000040  6.519695uH
K_K6631  L_L40  L_L41  0.1050
K_K6632  L_L40  L_L42  0.0397
K_K6633  L_L40  L_L43  0.0258
K_K6634  L_L40  L_L44  0.0192
K_K6635  L_L40  L_L45  0.0153
K_K6636  L_L40  L_L46  0.0127
K_K6637  L_L40  L_L47  0.0109
K_K6638  L_L40  L_L48  0.0095
K_K6639  L_L40  L_L49  0.0084
K_K6640  L_L40  L_L50  0.0076
K_K6641  L_L40  L_L51  0.0069
K_K6642  L_L40  L_L52  0.0063
K_K6643  L_L40  L_L53  0.0058
K_K6644  L_L40  L_L54  0.0054
K_K6645  L_L40  L_L55  0.0051
K_K6646  L_L40  L_L56  0.0047
K_K6647  L_L40  L_L57  0.0045
K_K6648  L_L40  L_L58  0.0042
K_K6649  L_L40  L_L59  0.0040
K_K6650  L_L40  L_L60  0.0038
K_K6651  L_L40  L_L61  0.0036
K_K6652  L_L40  L_L62  0.0034
K_K6653  L_L40  L_L63  0.0033
K_K6654  L_L40  L_L64  0.0032
K_K6655  L_L40  L_L65  0.0030
K_K6656  L_L40  L_L66  0.0029
K_K6657  L_L40  L_L67  0.0028
K_K6658  L_L40  L_L68  0.0027
K_K6659  L_L40  L_L69  0.0026
K_K6660  L_L40  L_L70  0.0025
K_K6661  L_L40  L_L71  0.0024
K_K6662  L_L40  L_L72  0.0024
K_K6663  L_L40  L_L73  0.0023
K_K6664  L_L40  L_L74  0.0022
K_K6665  L_L40  L_L75  0.0022
K_K6666  L_L40  L_L76  0.0021
K_K6667  L_L40  L_L77  0.0020
K_K6668  L_L40  L_L78  0.0020
K_K6669  L_L40  L_L79  0.0019
K_K6670  L_L40  L_L80  0.0019
K_K6671  L_L40  L_L81  0.0018
K_K6672  L_L40  L_L82  0.0018
K_K6673  L_L40  L_L83  0.0018
K_K6674  L_L40  L_L84  0.0017
K_K6675  L_L40  L_L85  0.0017
K_K6676  L_L40  L_L86  0.0016
K_K6677  L_L40  L_L87  0.0016
K_K6678  L_L40  L_L88  0.0016
K_K6679  L_L40  L_L89  0.0016
K_K6680  L_L40  L_L90  0.0015
K_K6681  L_L40  L_L91  0.0015
K_K6682  L_L40  L_L92  0.0015
K_K6683  L_L40  L_L93  0.0014
K_K6684  L_L40  L_L94  0.0014
K_K6685  L_L40  L_L95  0.0014
K_K6686  L_L40  L_L96  0.0014
K_K6687  L_L40  L_L97  0.0013
K_K6688  L_L40  L_L98  0.0013
K_K6689  L_L40  L_L99  0.0013
K_K6690  L_L40  L_L100  0.0013
K_K6691  L_L40  L_L101  0.0013
K_K6692  L_L40  L_L102  0.0012
K_K6693  L_L40  L_L103  0.0012
K_K6694  L_L40  L_L104  0.0012
K_K6695  L_L40  L_L105  0.0012
K_K6696  L_L40  L_L106  0.0011
K_K6697  L_L40  L_L107  0.0011
K_K6698  L_L40  L_L108  0.0011
K_K6699  L_L40  L_L109  0.0011
K_K6700  L_L40  L_L110  0.0011
K_K6701  L_L40  L_L111  0.0011
K_K6702  L_L40  L_L112  0.0011
K_K6703  L_L40  L_L113  0.0010
K_K6704  L_L40  L_L114  0.0010
K_K6705  L_L40  L_L115  0.0010
K_K6706  L_L40  L_L139  0.0019
K_K6707  L_L40  L_L140  0.0020
K_K6708  L_L40  L_L141  0.0020
K_K6709  L_L40  L_L142  0.0021
K_K6710  L_L40  L_L143  0.0022
K_K6711  L_L40  L_L144  0.0022
K_K6712  L_L40  L_L145  0.0023
K_K6713  L_L40  L_L146  0.0024
K_K6714  L_L40  L_L147  0.0024
K_K6715  L_L40  L_L148  0.0025
K_K6716  L_L40  L_L149  0.0026
K_K6717  L_L40  L_L150  0.0027
K_K6718  L_L40  L_L151  0.0028
K_K6719  L_L40  L_L152  0.0029
K_K6720  L_L40  L_L153  0.0030
K_K6721  L_L40  L_L154  0.0032
K_K6722  L_L40  L_L155  0.0033
K_K6723  L_L40  L_L156  0.0034
K_K6724  L_L40  L_L157  0.0036
K_K6725  L_L40  L_L158  0.0038
K_K6726  L_L40  L_L159  0.0040
K_K6727  L_L40  L_L160  0.0042
K_K6728  L_L40  L_L161  0.0045
K_K6729  L_L40  L_L162  0.0047
K_K6730  L_L40  L_L163  0.0051
K_K6731  L_L40  L_L164  0.0054
K_K6732  L_L40  L_L165  0.0058
K_K6733  L_L40  L_L166  0.0063
K_K6734  L_L40  L_L167  0.0069
K_K6735  L_L40  L_L168  0.0076
K_K6736  L_L40  L_L169  0.0084
K_K6737  L_L40  L_L170  0.0095
K_K6738  L_L40  L_L171  0.0109
K_K6739  L_L40  L_L172  0.0127
K_K6740  L_L40  L_L173  0.0152
K_K6741  L_L40  L_L174  0.0191
K_K6742  L_L40  L_L175  0.0256
K_K6743  L_L40  L_L176  0.0389
K_K6744  L_L40  L_L177  0.0812
K_K6745  L_L40  L_L178  0.1569
K_K6746  L_L40  L_L179  0.0812
K_K6747  L_L40  L_L180  0.0389
K_K6748  L_L40  L_L181  0.0256
K_K6749  L_L40  L_L182  0.0191
K_K6750  L_L40  L_L183  0.0152
K_K6751  L_L40  L_L184  0.0127
K_K6752  L_L40  L_L185  0.0109
K_K6753  L_L40  L_L186  0.0095
K_K6754  L_L40  L_L187  0.0084
K_K6755  L_L40  L_L188  0.0076
K_K6756  L_L40  L_L189  0.0069
K_K6757  L_L40  L_L190  0.0063
K_K6758  L_L40  L_L191  0.0058
K_K6759  L_L40  L_L192  0.0054
K_K6760  L_L40  L_L193  0.0051
K_K6761  L_L40  L_L194  0.0047
K_K6762  L_L40  L_L195  0.0045
K_K6763  L_L40  L_L196  0.0042
K_K6764  L_L40  L_L197  0.0040
K_K6765  L_L40  L_L198  0.0038
K_K6766  L_L40  L_L199  0.0036
K_K6767  L_L40  L_L200  0.0034
K_K6768  L_L40  L_L201  0.0033
K_K6769  L_L40  L_L202  0.0032
K_K6770  L_L40  L_L203  0.0030
K_K6771  L_L40  L_L204  0.0029
K_K6772  L_L40  L_L205  0.0028
K_K6773  L_L40  L_L206  0.0027
K_K6774  L_L40  L_L207  0.0026
K_K6775  L_L40  L_L208  0.0025
K_K6776  L_L40  L_L209  0.0024
K_K6777  L_L40  L_L210  0.0024
K_K6778  L_L40  L_L211  0.0023
K_K6779  L_L40  L_L212  0.0022
K_K6780  L_L40  L_L213  0.0022
K_K6781  L_L40  L_L214  0.0021
K_K6782  L_L40  L_L215  0.0020
K_K6783  L_L40  L_L216  0.0020
K_K6784  L_L40  L_L217  0.0019
K_K6785  L_L40  L_L218  0.0019
K_K6786  L_L40  L_L219  0.0018
K_K6787  L_L40  L_L220  0.0018
K_K6788  L_L40  L_L221  0.0018
K_K6789  L_L40  L_L222  0.0017
K_K6790  L_L40  L_L223  0.0017
K_K6791  L_L40  L_L224  0.0016
K_K6792  L_L40  L_L225  0.0016
K_K6793  L_L40  L_L226  0.0016
K_K6794  L_L40  L_L227  0.0015
K_K6795  L_L40  L_L228  0.0015
K_K6796  L_L40  L_L229  0.0015
K_K6797  L_L40  L_L230  0.0015
K_K6798  L_L40  L_L231  0.0014
K_K6799  L_L40  L_L232  0.0014
K_K6800  L_L40  L_L233  0.0014
K_K6801  L_L40  L_L234  0.0014
K_K6802  L_L40  L_L235  0.0013
K_K6803  L_L40  L_L236  0.0013
K_K6804  L_L40  L_L237  0.0013
K_K6805  L_L40  L_L238  0.0013
K_K6806  L_L40  L_L239  0.0012
K_K6807  L_L40  L_L240  0.0012
K_K6808  L_L40  L_L241  0.0012
K_K6809  L_L40  L_L242  0.0012
K_K6810  L_L40  L_L243  0.0012
K_K6811  L_L40  L_L244  0.0011
K_K6812  L_L40  L_L245  0.0011
K_K6813  L_L40  L_L246  0.0011
K_K6814  L_L40  L_L247  0.0011
K_K6815  L_L40  L_L248  0.0011
K_K6816  L_L40  L_L249  0.0011
K_K6817  L_L40  L_L250  0.0011
K_K6818  L_L40  L_L251  0.0010
K_K6819  L_L40  L_L252  0.0010
K_K6820  L_L40  L_L253  0.0010
* *  Branch  NTMP0000000040 - NTMP0000000041
R_R41  NTMP0000000040  nU_41  32.914993m  TC=0,0
V_Ui41  nU_41  nR_41  STIMULUS=U_IND_0000000041
R_V81  nR_41  nV_81  23.280268m  TC=0,0
L_V81  nR_41  nV_81  0.014646uH
R_V82  nV_81  nV_82  7.852787m  TC=0,0
L_V82  nV_81  nV_82  0.073723uH
L_L41  nV_82  NTMP0000000041  6.519695uH
K_K6821  L_L41  L_L42  0.1050
K_K6822  L_L41  L_L43  0.0397
K_K6823  L_L41  L_L44  0.0258
K_K6824  L_L41  L_L45  0.0192
K_K6825  L_L41  L_L46  0.0153
K_K6826  L_L41  L_L47  0.0127
K_K6827  L_L41  L_L48  0.0109
K_K6828  L_L41  L_L49  0.0095
K_K6829  L_L41  L_L50  0.0084
K_K6830  L_L41  L_L51  0.0076
K_K6831  L_L41  L_L52  0.0069
K_K6832  L_L41  L_L53  0.0063
K_K6833  L_L41  L_L54  0.0058
K_K6834  L_L41  L_L55  0.0054
K_K6835  L_L41  L_L56  0.0051
K_K6836  L_L41  L_L57  0.0047
K_K6837  L_L41  L_L58  0.0045
K_K6838  L_L41  L_L59  0.0042
K_K6839  L_L41  L_L60  0.0040
K_K6840  L_L41  L_L61  0.0038
K_K6841  L_L41  L_L62  0.0036
K_K6842  L_L41  L_L63  0.0034
K_K6843  L_L41  L_L64  0.0033
K_K6844  L_L41  L_L65  0.0032
K_K6845  L_L41  L_L66  0.0030
K_K6846  L_L41  L_L67  0.0029
K_K6847  L_L41  L_L68  0.0028
K_K6848  L_L41  L_L69  0.0027
K_K6849  L_L41  L_L70  0.0026
K_K6850  L_L41  L_L71  0.0025
K_K6851  L_L41  L_L72  0.0024
K_K6852  L_L41  L_L73  0.0024
K_K6853  L_L41  L_L74  0.0023
K_K6854  L_L41  L_L75  0.0022
K_K6855  L_L41  L_L76  0.0022
K_K6856  L_L41  L_L77  0.0021
K_K6857  L_L41  L_L78  0.0020
K_K6858  L_L41  L_L79  0.0020
K_K6859  L_L41  L_L80  0.0019
K_K6860  L_L41  L_L81  0.0019
K_K6861  L_L41  L_L82  0.0018
K_K6862  L_L41  L_L83  0.0018
K_K6863  L_L41  L_L84  0.0018
K_K6864  L_L41  L_L85  0.0017
K_K6865  L_L41  L_L86  0.0017
K_K6866  L_L41  L_L87  0.0016
K_K6867  L_L41  L_L88  0.0016
K_K6868  L_L41  L_L89  0.0016
K_K6869  L_L41  L_L90  0.0016
K_K6870  L_L41  L_L91  0.0015
K_K6871  L_L41  L_L92  0.0015
K_K6872  L_L41  L_L93  0.0015
K_K6873  L_L41  L_L94  0.0014
K_K6874  L_L41  L_L95  0.0014
K_K6875  L_L41  L_L96  0.0014
K_K6876  L_L41  L_L97  0.0014
K_K6877  L_L41  L_L98  0.0013
K_K6878  L_L41  L_L99  0.0013
K_K6879  L_L41  L_L100  0.0013
K_K6880  L_L41  L_L101  0.0013
K_K6881  L_L41  L_L102  0.0013
K_K6882  L_L41  L_L103  0.0012
K_K6883  L_L41  L_L104  0.0012
K_K6884  L_L41  L_L105  0.0012
K_K6885  L_L41  L_L106  0.0012
K_K6886  L_L41  L_L107  0.0011
K_K6887  L_L41  L_L108  0.0011
K_K6888  L_L41  L_L109  0.0011
K_K6889  L_L41  L_L110  0.0011
K_K6890  L_L41  L_L111  0.0011
K_K6891  L_L41  L_L112  0.0011
K_K6892  L_L41  L_L113  0.0011
K_K6893  L_L41  L_L114  0.0010
K_K6894  L_L41  L_L115  0.0010
K_K6895  L_L41  L_L116  0.0010
K_K6896  L_L41  L_L139  0.0019
K_K6897  L_L41  L_L140  0.0019
K_K6898  L_L41  L_L141  0.0020
K_K6899  L_L41  L_L142  0.0020
K_K6900  L_L41  L_L143  0.0021
K_K6901  L_L41  L_L144  0.0022
K_K6902  L_L41  L_L145  0.0022
K_K6903  L_L41  L_L146  0.0023
K_K6904  L_L41  L_L147  0.0024
K_K6905  L_L41  L_L148  0.0024
K_K6906  L_L41  L_L149  0.0025
K_K6907  L_L41  L_L150  0.0026
K_K6908  L_L41  L_L151  0.0027
K_K6909  L_L41  L_L152  0.0028
K_K6910  L_L41  L_L153  0.0029
K_K6911  L_L41  L_L154  0.0030
K_K6912  L_L41  L_L155  0.0032
K_K6913  L_L41  L_L156  0.0033
K_K6914  L_L41  L_L157  0.0034
K_K6915  L_L41  L_L158  0.0036
K_K6916  L_L41  L_L159  0.0038
K_K6917  L_L41  L_L160  0.0040
K_K6918  L_L41  L_L161  0.0042
K_K6919  L_L41  L_L162  0.0045
K_K6920  L_L41  L_L163  0.0047
K_K6921  L_L41  L_L164  0.0051
K_K6922  L_L41  L_L165  0.0054
K_K6923  L_L41  L_L166  0.0058
K_K6924  L_L41  L_L167  0.0063
K_K6925  L_L41  L_L168  0.0069
K_K6926  L_L41  L_L169  0.0076
K_K6927  L_L41  L_L170  0.0084
K_K6928  L_L41  L_L171  0.0095
K_K6929  L_L41  L_L172  0.0109
K_K6930  L_L41  L_L173  0.0127
K_K6931  L_L41  L_L174  0.0152
K_K6932  L_L41  L_L175  0.0191
K_K6933  L_L41  L_L176  0.0256
K_K6934  L_L41  L_L177  0.0389
K_K6935  L_L41  L_L178  0.0812
K_K6936  L_L41  L_L179  0.1569
K_K6937  L_L41  L_L180  0.0812
K_K6938  L_L41  L_L181  0.0389
K_K6939  L_L41  L_L182  0.0256
K_K6940  L_L41  L_L183  0.0191
K_K6941  L_L41  L_L184  0.0152
K_K6942  L_L41  L_L185  0.0127
K_K6943  L_L41  L_L186  0.0109
K_K6944  L_L41  L_L187  0.0095
K_K6945  L_L41  L_L188  0.0084
K_K6946  L_L41  L_L189  0.0076
K_K6947  L_L41  L_L190  0.0069
K_K6948  L_L41  L_L191  0.0063
K_K6949  L_L41  L_L192  0.0058
K_K6950  L_L41  L_L193  0.0054
K_K6951  L_L41  L_L194  0.0051
K_K6952  L_L41  L_L195  0.0047
K_K6953  L_L41  L_L196  0.0045
K_K6954  L_L41  L_L197  0.0042
K_K6955  L_L41  L_L198  0.0040
K_K6956  L_L41  L_L199  0.0038
K_K6957  L_L41  L_L200  0.0036
K_K6958  L_L41  L_L201  0.0034
K_K6959  L_L41  L_L202  0.0033
K_K6960  L_L41  L_L203  0.0032
K_K6961  L_L41  L_L204  0.0030
K_K6962  L_L41  L_L205  0.0029
K_K6963  L_L41  L_L206  0.0028
K_K6964  L_L41  L_L207  0.0027
K_K6965  L_L41  L_L208  0.0026
K_K6966  L_L41  L_L209  0.0025
K_K6967  L_L41  L_L210  0.0024
K_K6968  L_L41  L_L211  0.0024
K_K6969  L_L41  L_L212  0.0023
K_K6970  L_L41  L_L213  0.0022
K_K6971  L_L41  L_L214  0.0022
K_K6972  L_L41  L_L215  0.0021
K_K6973  L_L41  L_L216  0.0020
K_K6974  L_L41  L_L217  0.0020
K_K6975  L_L41  L_L218  0.0019
K_K6976  L_L41  L_L219  0.0019
K_K6977  L_L41  L_L220  0.0018
K_K6978  L_L41  L_L221  0.0018
K_K6979  L_L41  L_L222  0.0018
K_K6980  L_L41  L_L223  0.0017
K_K6981  L_L41  L_L224  0.0017
K_K6982  L_L41  L_L225  0.0016
K_K6983  L_L41  L_L226  0.0016
K_K6984  L_L41  L_L227  0.0016
K_K6985  L_L41  L_L228  0.0015
K_K6986  L_L41  L_L229  0.0015
K_K6987  L_L41  L_L230  0.0015
K_K6988  L_L41  L_L231  0.0015
K_K6989  L_L41  L_L232  0.0014
K_K6990  L_L41  L_L233  0.0014
K_K6991  L_L41  L_L234  0.0014
K_K6992  L_L41  L_L235  0.0014
K_K6993  L_L41  L_L236  0.0013
K_K6994  L_L41  L_L237  0.0013
K_K6995  L_L41  L_L238  0.0013
K_K6996  L_L41  L_L239  0.0013
K_K6997  L_L41  L_L240  0.0012
K_K6998  L_L41  L_L241  0.0012
K_K6999  L_L41  L_L242  0.0012
K_K7000  L_L41  L_L243  0.0012
K_K7001  L_L41  L_L244  0.0012
K_K7002  L_L41  L_L245  0.0011
K_K7003  L_L41  L_L246  0.0011
K_K7004  L_L41  L_L247  0.0011
K_K7005  L_L41  L_L248  0.0011
K_K7006  L_L41  L_L249  0.0011
K_K7007  L_L41  L_L250  0.0011
K_K7008  L_L41  L_L251  0.0011
K_K7009  L_L41  L_L252  0.0010
K_K7010  L_L41  L_L253  0.0010
K_K7011  L_L41  L_L254  0.0010
* *  Branch  NTMP0000000041 - NTMP0000000042
R_R42  NTMP0000000041  nU_42  32.914993m  TC=0,0
V_Ui42  nU_42  nR_42  STIMULUS=U_IND_0000000042
R_V83  nR_42  nV_83  23.280268m  TC=0,0
L_V83  nR_42  nV_83  0.014646uH
R_V84  nV_83  nV_84  7.852787m  TC=0,0
L_V84  nV_83  nV_84  0.073723uH
L_L42  nV_84  NTMP0000000042  6.519695uH
K_K7012  L_L42  L_L43  0.1050
K_K7013  L_L42  L_L44  0.0397
K_K7014  L_L42  L_L45  0.0258
K_K7015  L_L42  L_L46  0.0192
K_K7016  L_L42  L_L47  0.0153
K_K7017  L_L42  L_L48  0.0127
K_K7018  L_L42  L_L49  0.0109
K_K7019  L_L42  L_L50  0.0095
K_K7020  L_L42  L_L51  0.0084
K_K7021  L_L42  L_L52  0.0076
K_K7022  L_L42  L_L53  0.0069
K_K7023  L_L42  L_L54  0.0063
K_K7024  L_L42  L_L55  0.0058
K_K7025  L_L42  L_L56  0.0054
K_K7026  L_L42  L_L57  0.0051
K_K7027  L_L42  L_L58  0.0047
K_K7028  L_L42  L_L59  0.0045
K_K7029  L_L42  L_L60  0.0042
K_K7030  L_L42  L_L61  0.0040
K_K7031  L_L42  L_L62  0.0038
K_K7032  L_L42  L_L63  0.0036
K_K7033  L_L42  L_L64  0.0034
K_K7034  L_L42  L_L65  0.0033
K_K7035  L_L42  L_L66  0.0032
K_K7036  L_L42  L_L67  0.0030
K_K7037  L_L42  L_L68  0.0029
K_K7038  L_L42  L_L69  0.0028
K_K7039  L_L42  L_L70  0.0027
K_K7040  L_L42  L_L71  0.0026
K_K7041  L_L42  L_L72  0.0025
K_K7042  L_L42  L_L73  0.0024
K_K7043  L_L42  L_L74  0.0024
K_K7044  L_L42  L_L75  0.0023
K_K7045  L_L42  L_L76  0.0022
K_K7046  L_L42  L_L77  0.0022
K_K7047  L_L42  L_L78  0.0021
K_K7048  L_L42  L_L79  0.0020
K_K7049  L_L42  L_L80  0.0020
K_K7050  L_L42  L_L81  0.0019
K_K7051  L_L42  L_L82  0.0019
K_K7052  L_L42  L_L83  0.0018
K_K7053  L_L42  L_L84  0.0018
K_K7054  L_L42  L_L85  0.0018
K_K7055  L_L42  L_L86  0.0017
K_K7056  L_L42  L_L87  0.0017
K_K7057  L_L42  L_L88  0.0016
K_K7058  L_L42  L_L89  0.0016
K_K7059  L_L42  L_L90  0.0016
K_K7060  L_L42  L_L91  0.0015
K_K7061  L_L42  L_L92  0.0015
K_K7062  L_L42  L_L93  0.0015
K_K7063  L_L42  L_L94  0.0015
K_K7064  L_L42  L_L95  0.0014
K_K7065  L_L42  L_L96  0.0014
K_K7066  L_L42  L_L97  0.0014
K_K7067  L_L42  L_L98  0.0014
K_K7068  L_L42  L_L99  0.0013
K_K7069  L_L42  L_L100  0.0013
K_K7070  L_L42  L_L101  0.0013
K_K7071  L_L42  L_L102  0.0013
K_K7072  L_L42  L_L103  0.0013
K_K7073  L_L42  L_L104  0.0012
K_K7074  L_L42  L_L105  0.0012
K_K7075  L_L42  L_L106  0.0012
K_K7076  L_L42  L_L107  0.0012
K_K7077  L_L42  L_L108  0.0011
K_K7078  L_L42  L_L109  0.0011
K_K7079  L_L42  L_L110  0.0011
K_K7080  L_L42  L_L111  0.0011
K_K7081  L_L42  L_L112  0.0011
K_K7082  L_L42  L_L113  0.0011
K_K7083  L_L42  L_L114  0.0011
K_K7084  L_L42  L_L115  0.0010
K_K7085  L_L42  L_L116  0.0010
K_K7086  L_L42  L_L117  0.0010
K_K7087  L_L42  L_L139  0.0018
K_K7088  L_L42  L_L140  0.0019
K_K7089  L_L42  L_L141  0.0019
K_K7090  L_L42  L_L142  0.0020
K_K7091  L_L42  L_L143  0.0020
K_K7092  L_L42  L_L144  0.0021
K_K7093  L_L42  L_L145  0.0022
K_K7094  L_L42  L_L146  0.0022
K_K7095  L_L42  L_L147  0.0023
K_K7096  L_L42  L_L148  0.0024
K_K7097  L_L42  L_L149  0.0024
K_K7098  L_L42  L_L150  0.0025
K_K7099  L_L42  L_L151  0.0026
K_K7100  L_L42  L_L152  0.0027
K_K7101  L_L42  L_L153  0.0028
K_K7102  L_L42  L_L154  0.0029
K_K7103  L_L42  L_L155  0.0030
K_K7104  L_L42  L_L156  0.0032
K_K7105  L_L42  L_L157  0.0033
K_K7106  L_L42  L_L158  0.0034
K_K7107  L_L42  L_L159  0.0036
K_K7108  L_L42  L_L160  0.0038
K_K7109  L_L42  L_L161  0.0040
K_K7110  L_L42  L_L162  0.0042
K_K7111  L_L42  L_L163  0.0045
K_K7112  L_L42  L_L164  0.0047
K_K7113  L_L42  L_L165  0.0051
K_K7114  L_L42  L_L166  0.0054
K_K7115  L_L42  L_L167  0.0058
K_K7116  L_L42  L_L168  0.0063
K_K7117  L_L42  L_L169  0.0069
K_K7118  L_L42  L_L170  0.0076
K_K7119  L_L42  L_L171  0.0084
K_K7120  L_L42  L_L172  0.0095
K_K7121  L_L42  L_L173  0.0109
K_K7122  L_L42  L_L174  0.0127
K_K7123  L_L42  L_L175  0.0152
K_K7124  L_L42  L_L176  0.0191
K_K7125  L_L42  L_L177  0.0256
K_K7126  L_L42  L_L178  0.0389
K_K7127  L_L42  L_L179  0.0812
K_K7128  L_L42  L_L180  0.1569
K_K7129  L_L42  L_L181  0.0812
K_K7130  L_L42  L_L182  0.0389
K_K7131  L_L42  L_L183  0.0256
K_K7132  L_L42  L_L184  0.0191
K_K7133  L_L42  L_L185  0.0152
K_K7134  L_L42  L_L186  0.0127
K_K7135  L_L42  L_L187  0.0109
K_K7136  L_L42  L_L188  0.0095
K_K7137  L_L42  L_L189  0.0084
K_K7138  L_L42  L_L190  0.0076
K_K7139  L_L42  L_L191  0.0069
K_K7140  L_L42  L_L192  0.0063
K_K7141  L_L42  L_L193  0.0058
K_K7142  L_L42  L_L194  0.0054
K_K7143  L_L42  L_L195  0.0051
K_K7144  L_L42  L_L196  0.0047
K_K7145  L_L42  L_L197  0.0045
K_K7146  L_L42  L_L198  0.0042
K_K7147  L_L42  L_L199  0.0040
K_K7148  L_L42  L_L200  0.0038
K_K7149  L_L42  L_L201  0.0036
K_K7150  L_L42  L_L202  0.0034
K_K7151  L_L42  L_L203  0.0033
K_K7152  L_L42  L_L204  0.0032
K_K7153  L_L42  L_L205  0.0030
K_K7154  L_L42  L_L206  0.0029
K_K7155  L_L42  L_L207  0.0028
K_K7156  L_L42  L_L208  0.0027
K_K7157  L_L42  L_L209  0.0026
K_K7158  L_L42  L_L210  0.0025
K_K7159  L_L42  L_L211  0.0024
K_K7160  L_L42  L_L212  0.0024
K_K7161  L_L42  L_L213  0.0023
K_K7162  L_L42  L_L214  0.0022
K_K7163  L_L42  L_L215  0.0022
K_K7164  L_L42  L_L216  0.0021
K_K7165  L_L42  L_L217  0.0020
K_K7166  L_L42  L_L218  0.0020
K_K7167  L_L42  L_L219  0.0019
K_K7168  L_L42  L_L220  0.0019
K_K7169  L_L42  L_L221  0.0018
K_K7170  L_L42  L_L222  0.0018
K_K7171  L_L42  L_L223  0.0018
K_K7172  L_L42  L_L224  0.0017
K_K7173  L_L42  L_L225  0.0017
K_K7174  L_L42  L_L226  0.0016
K_K7175  L_L42  L_L227  0.0016
K_K7176  L_L42  L_L228  0.0016
K_K7177  L_L42  L_L229  0.0015
K_K7178  L_L42  L_L230  0.0015
K_K7179  L_L42  L_L231  0.0015
K_K7180  L_L42  L_L232  0.0015
K_K7181  L_L42  L_L233  0.0014
K_K7182  L_L42  L_L234  0.0014
K_K7183  L_L42  L_L235  0.0014
K_K7184  L_L42  L_L236  0.0014
K_K7185  L_L42  L_L237  0.0013
K_K7186  L_L42  L_L238  0.0013
K_K7187  L_L42  L_L239  0.0013
K_K7188  L_L42  L_L240  0.0013
K_K7189  L_L42  L_L241  0.0012
K_K7190  L_L42  L_L242  0.0012
K_K7191  L_L42  L_L243  0.0012
K_K7192  L_L42  L_L244  0.0012
K_K7193  L_L42  L_L245  0.0012
K_K7194  L_L42  L_L246  0.0011
K_K7195  L_L42  L_L247  0.0011
K_K7196  L_L42  L_L248  0.0011
K_K7197  L_L42  L_L249  0.0011
K_K7198  L_L42  L_L250  0.0011
K_K7199  L_L42  L_L251  0.0011
K_K7200  L_L42  L_L252  0.0011
K_K7201  L_L42  L_L253  0.0010
K_K7202  L_L42  L_L254  0.0010
K_K7203  L_L42  L_L255  0.0010
* *  Branch  NTMP0000000042 - NTMP0000000043
R_R43  NTMP0000000042  nU_43  32.914993m  TC=0,0
V_Ui43  nU_43  nR_43  STIMULUS=U_IND_0000000043
R_V85  nR_43  nV_85  23.280268m  TC=0,0
L_V85  nR_43  nV_85  0.014646uH
R_V86  nV_85  nV_86  7.852787m  TC=0,0
L_V86  nV_85  nV_86  0.073723uH
L_L43  nV_86  NTMP0000000043  6.519695uH
K_K7204  L_L43  L_L44  0.1050
K_K7205  L_L43  L_L45  0.0397
K_K7206  L_L43  L_L46  0.0258
K_K7207  L_L43  L_L47  0.0192
K_K7208  L_L43  L_L48  0.0153
K_K7209  L_L43  L_L49  0.0127
K_K7210  L_L43  L_L50  0.0109
K_K7211  L_L43  L_L51  0.0095
K_K7212  L_L43  L_L52  0.0084
K_K7213  L_L43  L_L53  0.0076
K_K7214  L_L43  L_L54  0.0069
K_K7215  L_L43  L_L55  0.0063
K_K7216  L_L43  L_L56  0.0058
K_K7217  L_L43  L_L57  0.0054
K_K7218  L_L43  L_L58  0.0051
K_K7219  L_L43  L_L59  0.0047
K_K7220  L_L43  L_L60  0.0045
K_K7221  L_L43  L_L61  0.0042
K_K7222  L_L43  L_L62  0.0040
K_K7223  L_L43  L_L63  0.0038
K_K7224  L_L43  L_L64  0.0036
K_K7225  L_L43  L_L65  0.0034
K_K7226  L_L43  L_L66  0.0033
K_K7227  L_L43  L_L67  0.0032
K_K7228  L_L43  L_L68  0.0030
K_K7229  L_L43  L_L69  0.0029
K_K7230  L_L43  L_L70  0.0028
K_K7231  L_L43  L_L71  0.0027
K_K7232  L_L43  L_L72  0.0026
K_K7233  L_L43  L_L73  0.0025
K_K7234  L_L43  L_L74  0.0024
K_K7235  L_L43  L_L75  0.0024
K_K7236  L_L43  L_L76  0.0023
K_K7237  L_L43  L_L77  0.0022
K_K7238  L_L43  L_L78  0.0022
K_K7239  L_L43  L_L79  0.0021
K_K7240  L_L43  L_L80  0.0020
K_K7241  L_L43  L_L81  0.0020
K_K7242  L_L43  L_L82  0.0019
K_K7243  L_L43  L_L83  0.0019
K_K7244  L_L43  L_L84  0.0018
K_K7245  L_L43  L_L85  0.0018
K_K7246  L_L43  L_L86  0.0018
K_K7247  L_L43  L_L87  0.0017
K_K7248  L_L43  L_L88  0.0017
K_K7249  L_L43  L_L89  0.0016
K_K7250  L_L43  L_L90  0.0016
K_K7251  L_L43  L_L91  0.0016
K_K7252  L_L43  L_L92  0.0015
K_K7253  L_L43  L_L93  0.0015
K_K7254  L_L43  L_L94  0.0015
K_K7255  L_L43  L_L95  0.0015
K_K7256  L_L43  L_L96  0.0014
K_K7257  L_L43  L_L97  0.0014
K_K7258  L_L43  L_L98  0.0014
K_K7259  L_L43  L_L99  0.0014
K_K7260  L_L43  L_L100  0.0013
K_K7261  L_L43  L_L101  0.0013
K_K7262  L_L43  L_L102  0.0013
K_K7263  L_L43  L_L103  0.0013
K_K7264  L_L43  L_L104  0.0013
K_K7265  L_L43  L_L105  0.0012
K_K7266  L_L43  L_L106  0.0012
K_K7267  L_L43  L_L107  0.0012
K_K7268  L_L43  L_L108  0.0012
K_K7269  L_L43  L_L109  0.0011
K_K7270  L_L43  L_L110  0.0011
K_K7271  L_L43  L_L111  0.0011
K_K7272  L_L43  L_L112  0.0011
K_K7273  L_L43  L_L113  0.0011
K_K7274  L_L43  L_L114  0.0011
K_K7275  L_L43  L_L115  0.0011
K_K7276  L_L43  L_L116  0.0010
K_K7277  L_L43  L_L117  0.0010
K_K7278  L_L43  L_L118  0.0010
K_K7279  L_L43  L_L139  0.0018
K_K7280  L_L43  L_L140  0.0018
K_K7281  L_L43  L_L141  0.0019
K_K7282  L_L43  L_L142  0.0019
K_K7283  L_L43  L_L143  0.0020
K_K7284  L_L43  L_L144  0.0020
K_K7285  L_L43  L_L145  0.0021
K_K7286  L_L43  L_L146  0.0022
K_K7287  L_L43  L_L147  0.0022
K_K7288  L_L43  L_L148  0.0023
K_K7289  L_L43  L_L149  0.0024
K_K7290  L_L43  L_L150  0.0024
K_K7291  L_L43  L_L151  0.0025
K_K7292  L_L43  L_L152  0.0026
K_K7293  L_L43  L_L153  0.0027
K_K7294  L_L43  L_L154  0.0028
K_K7295  L_L43  L_L155  0.0029
K_K7296  L_L43  L_L156  0.0030
K_K7297  L_L43  L_L157  0.0032
K_K7298  L_L43  L_L158  0.0033
K_K7299  L_L43  L_L159  0.0034
K_K7300  L_L43  L_L160  0.0036
K_K7301  L_L43  L_L161  0.0038
K_K7302  L_L43  L_L162  0.0040
K_K7303  L_L43  L_L163  0.0042
K_K7304  L_L43  L_L164  0.0045
K_K7305  L_L43  L_L165  0.0047
K_K7306  L_L43  L_L166  0.0051
K_K7307  L_L43  L_L167  0.0054
K_K7308  L_L43  L_L168  0.0058
K_K7309  L_L43  L_L169  0.0063
K_K7310  L_L43  L_L170  0.0069
K_K7311  L_L43  L_L171  0.0076
K_K7312  L_L43  L_L172  0.0084
K_K7313  L_L43  L_L173  0.0095
K_K7314  L_L43  L_L174  0.0109
K_K7315  L_L43  L_L175  0.0127
K_K7316  L_L43  L_L176  0.0152
K_K7317  L_L43  L_L177  0.0191
K_K7318  L_L43  L_L178  0.0256
K_K7319  L_L43  L_L179  0.0389
K_K7320  L_L43  L_L180  0.0812
K_K7321  L_L43  L_L181  0.1569
K_K7322  L_L43  L_L182  0.0812
K_K7323  L_L43  L_L183  0.0389
K_K7324  L_L43  L_L184  0.0256
K_K7325  L_L43  L_L185  0.0191
K_K7326  L_L43  L_L186  0.0152
K_K7327  L_L43  L_L187  0.0127
K_K7328  L_L43  L_L188  0.0109
K_K7329  L_L43  L_L189  0.0095
K_K7330  L_L43  L_L190  0.0084
K_K7331  L_L43  L_L191  0.0076
K_K7332  L_L43  L_L192  0.0069
K_K7333  L_L43  L_L193  0.0063
K_K7334  L_L43  L_L194  0.0058
K_K7335  L_L43  L_L195  0.0054
K_K7336  L_L43  L_L196  0.0051
K_K7337  L_L43  L_L197  0.0047
K_K7338  L_L43  L_L198  0.0045
K_K7339  L_L43  L_L199  0.0042
K_K7340  L_L43  L_L200  0.0040
K_K7341  L_L43  L_L201  0.0038
K_K7342  L_L43  L_L202  0.0036
K_K7343  L_L43  L_L203  0.0034
K_K7344  L_L43  L_L204  0.0033
K_K7345  L_L43  L_L205  0.0032
K_K7346  L_L43  L_L206  0.0030
K_K7347  L_L43  L_L207  0.0029
K_K7348  L_L43  L_L208  0.0028
K_K7349  L_L43  L_L209  0.0027
K_K7350  L_L43  L_L210  0.0026
K_K7351  L_L43  L_L211  0.0025
K_K7352  L_L43  L_L212  0.0024
K_K7353  L_L43  L_L213  0.0024
K_K7354  L_L43  L_L214  0.0023
K_K7355  L_L43  L_L215  0.0022
K_K7356  L_L43  L_L216  0.0022
K_K7357  L_L43  L_L217  0.0021
K_K7358  L_L43  L_L218  0.0020
K_K7359  L_L43  L_L219  0.0020
K_K7360  L_L43  L_L220  0.0019
K_K7361  L_L43  L_L221  0.0019
K_K7362  L_L43  L_L222  0.0018
K_K7363  L_L43  L_L223  0.0018
K_K7364  L_L43  L_L224  0.0018
K_K7365  L_L43  L_L225  0.0017
K_K7366  L_L43  L_L226  0.0017
K_K7367  L_L43  L_L227  0.0016
K_K7368  L_L43  L_L228  0.0016
K_K7369  L_L43  L_L229  0.0016
K_K7370  L_L43  L_L230  0.0015
K_K7371  L_L43  L_L231  0.0015
K_K7372  L_L43  L_L232  0.0015
K_K7373  L_L43  L_L233  0.0015
K_K7374  L_L43  L_L234  0.0014
K_K7375  L_L43  L_L235  0.0014
K_K7376  L_L43  L_L236  0.0014
K_K7377  L_L43  L_L237  0.0014
K_K7378  L_L43  L_L238  0.0013
K_K7379  L_L43  L_L239  0.0013
K_K7380  L_L43  L_L240  0.0013
K_K7381  L_L43  L_L241  0.0013
K_K7382  L_L43  L_L242  0.0012
K_K7383  L_L43  L_L243  0.0012
K_K7384  L_L43  L_L244  0.0012
K_K7385  L_L43  L_L245  0.0012
K_K7386  L_L43  L_L246  0.0012
K_K7387  L_L43  L_L247  0.0011
K_K7388  L_L43  L_L248  0.0011
K_K7389  L_L43  L_L249  0.0011
K_K7390  L_L43  L_L250  0.0011
K_K7391  L_L43  L_L251  0.0011
K_K7392  L_L43  L_L252  0.0011
K_K7393  L_L43  L_L253  0.0011
K_K7394  L_L43  L_L254  0.0010
K_K7395  L_L43  L_L255  0.0010
K_K7396  L_L43  L_L256  0.0010
* *  Branch  NTMP0000000043 - NTMP0000000044
R_R44  NTMP0000000043  nU_44  32.914993m  TC=0,0
V_Ui44  nU_44  nR_44  STIMULUS=U_IND_0000000044
R_V87  nR_44  nV_87  23.280268m  TC=0,0
L_V87  nR_44  nV_87  0.014646uH
R_V88  nV_87  nV_88  7.852787m  TC=0,0
L_V88  nV_87  nV_88  0.073723uH
L_L44  nV_88  NTMP0000000044  6.519695uH
K_K7397  L_L44  L_L45  0.1050
K_K7398  L_L44  L_L46  0.0397
K_K7399  L_L44  L_L47  0.0258
K_K7400  L_L44  L_L48  0.0192
K_K7401  L_L44  L_L49  0.0153
K_K7402  L_L44  L_L50  0.0127
K_K7403  L_L44  L_L51  0.0109
K_K7404  L_L44  L_L52  0.0095
K_K7405  L_L44  L_L53  0.0084
K_K7406  L_L44  L_L54  0.0076
K_K7407  L_L44  L_L55  0.0069
K_K7408  L_L44  L_L56  0.0063
K_K7409  L_L44  L_L57  0.0058
K_K7410  L_L44  L_L58  0.0054
K_K7411  L_L44  L_L59  0.0051
K_K7412  L_L44  L_L60  0.0047
K_K7413  L_L44  L_L61  0.0045
K_K7414  L_L44  L_L62  0.0042
K_K7415  L_L44  L_L63  0.0040
K_K7416  L_L44  L_L64  0.0038
K_K7417  L_L44  L_L65  0.0036
K_K7418  L_L44  L_L66  0.0034
K_K7419  L_L44  L_L67  0.0033
K_K7420  L_L44  L_L68  0.0032
K_K7421  L_L44  L_L69  0.0030
K_K7422  L_L44  L_L70  0.0029
K_K7423  L_L44  L_L71  0.0028
K_K7424  L_L44  L_L72  0.0027
K_K7425  L_L44  L_L73  0.0026
K_K7426  L_L44  L_L74  0.0025
K_K7427  L_L44  L_L75  0.0024
K_K7428  L_L44  L_L76  0.0024
K_K7429  L_L44  L_L77  0.0023
K_K7430  L_L44  L_L78  0.0022
K_K7431  L_L44  L_L79  0.0022
K_K7432  L_L44  L_L80  0.0021
K_K7433  L_L44  L_L81  0.0020
K_K7434  L_L44  L_L82  0.0020
K_K7435  L_L44  L_L83  0.0019
K_K7436  L_L44  L_L84  0.0019
K_K7437  L_L44  L_L85  0.0018
K_K7438  L_L44  L_L86  0.0018
K_K7439  L_L44  L_L87  0.0018
K_K7440  L_L44  L_L88  0.0017
K_K7441  L_L44  L_L89  0.0017
K_K7442  L_L44  L_L90  0.0016
K_K7443  L_L44  L_L91  0.0016
K_K7444  L_L44  L_L92  0.0016
K_K7445  L_L44  L_L93  0.0015
K_K7446  L_L44  L_L94  0.0015
K_K7447  L_L44  L_L95  0.0015
K_K7448  L_L44  L_L96  0.0015
K_K7449  L_L44  L_L97  0.0014
K_K7450  L_L44  L_L98  0.0014
K_K7451  L_L44  L_L99  0.0014
K_K7452  L_L44  L_L100  0.0014
K_K7453  L_L44  L_L101  0.0013
K_K7454  L_L44  L_L102  0.0013
K_K7455  L_L44  L_L103  0.0013
K_K7456  L_L44  L_L104  0.0013
K_K7457  L_L44  L_L105  0.0013
K_K7458  L_L44  L_L106  0.0012
K_K7459  L_L44  L_L107  0.0012
K_K7460  L_L44  L_L108  0.0012
K_K7461  L_L44  L_L109  0.0012
K_K7462  L_L44  L_L110  0.0011
K_K7463  L_L44  L_L111  0.0011
K_K7464  L_L44  L_L112  0.0011
K_K7465  L_L44  L_L113  0.0011
K_K7466  L_L44  L_L114  0.0011
K_K7467  L_L44  L_L115  0.0011
K_K7468  L_L44  L_L116  0.0011
K_K7469  L_L44  L_L117  0.0010
K_K7470  L_L44  L_L118  0.0010
K_K7471  L_L44  L_L119  0.0010
K_K7472  L_L44  L_L139  0.0018
K_K7473  L_L44  L_L140  0.0018
K_K7474  L_L44  L_L141  0.0018
K_K7475  L_L44  L_L142  0.0019
K_K7476  L_L44  L_L143  0.0019
K_K7477  L_L44  L_L144  0.0020
K_K7478  L_L44  L_L145  0.0020
K_K7479  L_L44  L_L146  0.0021
K_K7480  L_L44  L_L147  0.0022
K_K7481  L_L44  L_L148  0.0022
K_K7482  L_L44  L_L149  0.0023
K_K7483  L_L44  L_L150  0.0024
K_K7484  L_L44  L_L151  0.0024
K_K7485  L_L44  L_L152  0.0025
K_K7486  L_L44  L_L153  0.0026
K_K7487  L_L44  L_L154  0.0027
K_K7488  L_L44  L_L155  0.0028
K_K7489  L_L44  L_L156  0.0029
K_K7490  L_L44  L_L157  0.0030
K_K7491  L_L44  L_L158  0.0032
K_K7492  L_L44  L_L159  0.0033
K_K7493  L_L44  L_L160  0.0034
K_K7494  L_L44  L_L161  0.0036
K_K7495  L_L44  L_L162  0.0038
K_K7496  L_L44  L_L163  0.0040
K_K7497  L_L44  L_L164  0.0042
K_K7498  L_L44  L_L165  0.0045
K_K7499  L_L44  L_L166  0.0047
K_K7500  L_L44  L_L167  0.0051
K_K7501  L_L44  L_L168  0.0054
K_K7502  L_L44  L_L169  0.0058
K_K7503  L_L44  L_L170  0.0063
K_K7504  L_L44  L_L171  0.0069
K_K7505  L_L44  L_L172  0.0076
K_K7506  L_L44  L_L173  0.0084
K_K7507  L_L44  L_L174  0.0095
K_K7508  L_L44  L_L175  0.0109
K_K7509  L_L44  L_L176  0.0127
K_K7510  L_L44  L_L177  0.0152
K_K7511  L_L44  L_L178  0.0191
K_K7512  L_L44  L_L179  0.0256
K_K7513  L_L44  L_L180  0.0389
K_K7514  L_L44  L_L181  0.0812
K_K7515  L_L44  L_L182  0.1569
K_K7516  L_L44  L_L183  0.0812
K_K7517  L_L44  L_L184  0.0389
K_K7518  L_L44  L_L185  0.0256
K_K7519  L_L44  L_L186  0.0191
K_K7520  L_L44  L_L187  0.0152
K_K7521  L_L44  L_L188  0.0127
K_K7522  L_L44  L_L189  0.0109
K_K7523  L_L44  L_L190  0.0095
K_K7524  L_L44  L_L191  0.0084
K_K7525  L_L44  L_L192  0.0076
K_K7526  L_L44  L_L193  0.0069
K_K7527  L_L44  L_L194  0.0063
K_K7528  L_L44  L_L195  0.0058
K_K7529  L_L44  L_L196  0.0054
K_K7530  L_L44  L_L197  0.0051
K_K7531  L_L44  L_L198  0.0047
K_K7532  L_L44  L_L199  0.0045
K_K7533  L_L44  L_L200  0.0042
K_K7534  L_L44  L_L201  0.0040
K_K7535  L_L44  L_L202  0.0038
K_K7536  L_L44  L_L203  0.0036
K_K7537  L_L44  L_L204  0.0034
K_K7538  L_L44  L_L205  0.0033
K_K7539  L_L44  L_L206  0.0032
K_K7540  L_L44  L_L207  0.0030
K_K7541  L_L44  L_L208  0.0029
K_K7542  L_L44  L_L209  0.0028
K_K7543  L_L44  L_L210  0.0027
K_K7544  L_L44  L_L211  0.0026
K_K7545  L_L44  L_L212  0.0025
K_K7546  L_L44  L_L213  0.0024
K_K7547  L_L44  L_L214  0.0024
K_K7548  L_L44  L_L215  0.0023
K_K7549  L_L44  L_L216  0.0022
K_K7550  L_L44  L_L217  0.0022
K_K7551  L_L44  L_L218  0.0021
K_K7552  L_L44  L_L219  0.0020
K_K7553  L_L44  L_L220  0.0020
K_K7554  L_L44  L_L221  0.0019
K_K7555  L_L44  L_L222  0.0019
K_K7556  L_L44  L_L223  0.0018
K_K7557  L_L44  L_L224  0.0018
K_K7558  L_L44  L_L225  0.0018
K_K7559  L_L44  L_L226  0.0017
K_K7560  L_L44  L_L227  0.0017
K_K7561  L_L44  L_L228  0.0016
K_K7562  L_L44  L_L229  0.0016
K_K7563  L_L44  L_L230  0.0016
K_K7564  L_L44  L_L231  0.0015
K_K7565  L_L44  L_L232  0.0015
K_K7566  L_L44  L_L233  0.0015
K_K7567  L_L44  L_L234  0.0015
K_K7568  L_L44  L_L235  0.0014
K_K7569  L_L44  L_L236  0.0014
K_K7570  L_L44  L_L237  0.0014
K_K7571  L_L44  L_L238  0.0014
K_K7572  L_L44  L_L239  0.0013
K_K7573  L_L44  L_L240  0.0013
K_K7574  L_L44  L_L241  0.0013
K_K7575  L_L44  L_L242  0.0013
K_K7576  L_L44  L_L243  0.0012
K_K7577  L_L44  L_L244  0.0012
K_K7578  L_L44  L_L245  0.0012
K_K7579  L_L44  L_L246  0.0012
K_K7580  L_L44  L_L247  0.0012
K_K7581  L_L44  L_L248  0.0011
K_K7582  L_L44  L_L249  0.0011
K_K7583  L_L44  L_L250  0.0011
K_K7584  L_L44  L_L251  0.0011
K_K7585  L_L44  L_L252  0.0011
K_K7586  L_L44  L_L253  0.0011
K_K7587  L_L44  L_L254  0.0011
K_K7588  L_L44  L_L255  0.0010
K_K7589  L_L44  L_L256  0.0010
K_K7590  L_L44  L_L257  0.0010
* *  Branch  NTMP0000000044 - NTMP0000000045
R_R45  NTMP0000000044  nU_45  32.914993m  TC=0,0
V_Ui45  nU_45  nR_45  STIMULUS=U_IND_0000000045
R_V89  nR_45  nV_89  23.280268m  TC=0,0
L_V89  nR_45  nV_89  0.014646uH
R_V90  nV_89  nV_90  7.852787m  TC=0,0
L_V90  nV_89  nV_90  0.073723uH
L_L45  nV_90  NTMP0000000045  6.519695uH
K_K7591  L_L45  L_L46  0.1050
K_K7592  L_L45  L_L47  0.0397
K_K7593  L_L45  L_L48  0.0258
K_K7594  L_L45  L_L49  0.0192
K_K7595  L_L45  L_L50  0.0153
K_K7596  L_L45  L_L51  0.0127
K_K7597  L_L45  L_L52  0.0109
K_K7598  L_L45  L_L53  0.0095
K_K7599  L_L45  L_L54  0.0084
K_K7600  L_L45  L_L55  0.0076
K_K7601  L_L45  L_L56  0.0069
K_K7602  L_L45  L_L57  0.0063
K_K7603  L_L45  L_L58  0.0058
K_K7604  L_L45  L_L59  0.0054
K_K7605  L_L45  L_L60  0.0051
K_K7606  L_L45  L_L61  0.0047
K_K7607  L_L45  L_L62  0.0045
K_K7608  L_L45  L_L63  0.0042
K_K7609  L_L45  L_L64  0.0040
K_K7610  L_L45  L_L65  0.0038
K_K7611  L_L45  L_L66  0.0036
K_K7612  L_L45  L_L67  0.0034
K_K7613  L_L45  L_L68  0.0033
K_K7614  L_L45  L_L69  0.0032
K_K7615  L_L45  L_L70  0.0030
K_K7616  L_L45  L_L71  0.0029
K_K7617  L_L45  L_L72  0.0028
K_K7618  L_L45  L_L73  0.0027
K_K7619  L_L45  L_L74  0.0026
K_K7620  L_L45  L_L75  0.0025
K_K7621  L_L45  L_L76  0.0024
K_K7622  L_L45  L_L77  0.0024
K_K7623  L_L45  L_L78  0.0023
K_K7624  L_L45  L_L79  0.0022
K_K7625  L_L45  L_L80  0.0022
K_K7626  L_L45  L_L81  0.0021
K_K7627  L_L45  L_L82  0.0020
K_K7628  L_L45  L_L83  0.0020
K_K7629  L_L45  L_L84  0.0019
K_K7630  L_L45  L_L85  0.0019
K_K7631  L_L45  L_L86  0.0019
K_K7632  L_L45  L_L87  0.0018
K_K7633  L_L45  L_L88  0.0018
K_K7634  L_L45  L_L89  0.0017
K_K7635  L_L45  L_L90  0.0017
K_K7636  L_L45  L_L91  0.0017
K_K7637  L_L45  L_L92  0.0016
K_K7638  L_L45  L_L93  0.0016
K_K7639  L_L45  L_L94  0.0015
K_K7640  L_L45  L_L95  0.0015
K_K7641  L_L45  L_L96  0.0015
K_K7642  L_L45  L_L97  0.0015
K_K7643  L_L45  L_L98  0.0014
K_K7644  L_L45  L_L99  0.0014
K_K7645  L_L45  L_L100  0.0014
K_K7646  L_L45  L_L101  0.0014
K_K7647  L_L45  L_L102  0.0013
K_K7648  L_L45  L_L103  0.0013
K_K7649  L_L45  L_L104  0.0013
K_K7650  L_L45  L_L105  0.0013
K_K7651  L_L45  L_L106  0.0013
K_K7652  L_L45  L_L107  0.0012
K_K7653  L_L45  L_L108  0.0012
K_K7654  L_L45  L_L109  0.0012
K_K7655  L_L45  L_L110  0.0012
K_K7656  L_L45  L_L111  0.0011
K_K7657  L_L45  L_L112  0.0011
K_K7658  L_L45  L_L113  0.0011
K_K7659  L_L45  L_L114  0.0011
K_K7660  L_L45  L_L115  0.0011
K_K7661  L_L45  L_L116  0.0011
K_K7662  L_L45  L_L117  0.0011
K_K7663  L_L45  L_L118  0.0010
K_K7664  L_L45  L_L119  0.0010
K_K7665  L_L45  L_L120  0.0010
K_K7666  L_L45  L_L139  0.0017
K_K7667  L_L45  L_L140  0.0018
K_K7668  L_L45  L_L141  0.0018
K_K7669  L_L45  L_L142  0.0018
K_K7670  L_L45  L_L143  0.0019
K_K7671  L_L45  L_L144  0.0019
K_K7672  L_L45  L_L145  0.0020
K_K7673  L_L45  L_L146  0.0020
K_K7674  L_L45  L_L147  0.0021
K_K7675  L_L45  L_L148  0.0022
K_K7676  L_L45  L_L149  0.0022
K_K7677  L_L45  L_L150  0.0023
K_K7678  L_L45  L_L151  0.0024
K_K7679  L_L45  L_L152  0.0024
K_K7680  L_L45  L_L153  0.0025
K_K7681  L_L45  L_L154  0.0026
K_K7682  L_L45  L_L155  0.0027
K_K7683  L_L45  L_L156  0.0028
K_K7684  L_L45  L_L157  0.0029
K_K7685  L_L45  L_L158  0.0030
K_K7686  L_L45  L_L159  0.0032
K_K7687  L_L45  L_L160  0.0033
K_K7688  L_L45  L_L161  0.0034
K_K7689  L_L45  L_L162  0.0036
K_K7690  L_L45  L_L163  0.0038
K_K7691  L_L45  L_L164  0.0040
K_K7692  L_L45  L_L165  0.0042
K_K7693  L_L45  L_L166  0.0045
K_K7694  L_L45  L_L167  0.0047
K_K7695  L_L45  L_L168  0.0051
K_K7696  L_L45  L_L169  0.0054
K_K7697  L_L45  L_L170  0.0058
K_K7698  L_L45  L_L171  0.0063
K_K7699  L_L45  L_L172  0.0069
K_K7700  L_L45  L_L173  0.0076
K_K7701  L_L45  L_L174  0.0084
K_K7702  L_L45  L_L175  0.0095
K_K7703  L_L45  L_L176  0.0109
K_K7704  L_L45  L_L177  0.0127
K_K7705  L_L45  L_L178  0.0152
K_K7706  L_L45  L_L179  0.0191
K_K7707  L_L45  L_L180  0.0256
K_K7708  L_L45  L_L181  0.0389
K_K7709  L_L45  L_L182  0.0812
K_K7710  L_L45  L_L183  0.1569
K_K7711  L_L45  L_L184  0.0812
K_K7712  L_L45  L_L185  0.0389
K_K7713  L_L45  L_L186  0.0256
K_K7714  L_L45  L_L187  0.0191
K_K7715  L_L45  L_L188  0.0152
K_K7716  L_L45  L_L189  0.0127
K_K7717  L_L45  L_L190  0.0109
K_K7718  L_L45  L_L191  0.0095
K_K7719  L_L45  L_L192  0.0084
K_K7720  L_L45  L_L193  0.0076
K_K7721  L_L45  L_L194  0.0069
K_K7722  L_L45  L_L195  0.0063
K_K7723  L_L45  L_L196  0.0058
K_K7724  L_L45  L_L197  0.0054
K_K7725  L_L45  L_L198  0.0051
K_K7726  L_L45  L_L199  0.0047
K_K7727  L_L45  L_L200  0.0045
K_K7728  L_L45  L_L201  0.0042
K_K7729  L_L45  L_L202  0.0040
K_K7730  L_L45  L_L203  0.0038
K_K7731  L_L45  L_L204  0.0036
K_K7732  L_L45  L_L205  0.0034
K_K7733  L_L45  L_L206  0.0033
K_K7734  L_L45  L_L207  0.0032
K_K7735  L_L45  L_L208  0.0030
K_K7736  L_L45  L_L209  0.0029
K_K7737  L_L45  L_L210  0.0028
K_K7738  L_L45  L_L211  0.0027
K_K7739  L_L45  L_L212  0.0026
K_K7740  L_L45  L_L213  0.0025
K_K7741  L_L45  L_L214  0.0024
K_K7742  L_L45  L_L215  0.0024
K_K7743  L_L45  L_L216  0.0023
K_K7744  L_L45  L_L217  0.0022
K_K7745  L_L45  L_L218  0.0022
K_K7746  L_L45  L_L219  0.0021
K_K7747  L_L45  L_L220  0.0020
K_K7748  L_L45  L_L221  0.0020
K_K7749  L_L45  L_L222  0.0019
K_K7750  L_L45  L_L223  0.0019
K_K7751  L_L45  L_L224  0.0018
K_K7752  L_L45  L_L225  0.0018
K_K7753  L_L45  L_L226  0.0018
K_K7754  L_L45  L_L227  0.0017
K_K7755  L_L45  L_L228  0.0017
K_K7756  L_L45  L_L229  0.0016
K_K7757  L_L45  L_L230  0.0016
K_K7758  L_L45  L_L231  0.0016
K_K7759  L_L45  L_L232  0.0015
K_K7760  L_L45  L_L233  0.0015
K_K7761  L_L45  L_L234  0.0015
K_K7762  L_L45  L_L235  0.0015
K_K7763  L_L45  L_L236  0.0014
K_K7764  L_L45  L_L237  0.0014
K_K7765  L_L45  L_L238  0.0014
K_K7766  L_L45  L_L239  0.0014
K_K7767  L_L45  L_L240  0.0013
K_K7768  L_L45  L_L241  0.0013
K_K7769  L_L45  L_L242  0.0013
K_K7770  L_L45  L_L243  0.0013
K_K7771  L_L45  L_L244  0.0012
K_K7772  L_L45  L_L245  0.0012
K_K7773  L_L45  L_L246  0.0012
K_K7774  L_L45  L_L247  0.0012
K_K7775  L_L45  L_L248  0.0012
K_K7776  L_L45  L_L249  0.0011
K_K7777  L_L45  L_L250  0.0011
K_K7778  L_L45  L_L251  0.0011
K_K7779  L_L45  L_L252  0.0011
K_K7780  L_L45  L_L253  0.0011
K_K7781  L_L45  L_L254  0.0011
K_K7782  L_L45  L_L255  0.0011
K_K7783  L_L45  L_L256  0.0010
K_K7784  L_L45  L_L257  0.0010
K_K7785  L_L45  L_L258  0.0010
* *  Branch  NTMP0000000045 - NTMP0000000046
R_R46  NTMP0000000045  nU_46  32.914993m  TC=0,0
V_Ui46  nU_46  nR_46  STIMULUS=U_IND_0000000046
R_V91  nR_46  nV_91  23.280268m  TC=0,0
L_V91  nR_46  nV_91  0.014646uH
R_V92  nV_91  nV_92  7.852787m  TC=0,0
L_V92  nV_91  nV_92  0.073723uH
L_L46  nV_92  NTMP0000000046  6.519695uH
K_K7786  L_L46  L_L47  0.1050
K_K7787  L_L46  L_L48  0.0397
K_K7788  L_L46  L_L49  0.0258
K_K7789  L_L46  L_L50  0.0192
K_K7790  L_L46  L_L51  0.0153
K_K7791  L_L46  L_L52  0.0127
K_K7792  L_L46  L_L53  0.0109
K_K7793  L_L46  L_L54  0.0095
K_K7794  L_L46  L_L55  0.0084
K_K7795  L_L46  L_L56  0.0076
K_K7796  L_L46  L_L57  0.0069
K_K7797  L_L46  L_L58  0.0063
K_K7798  L_L46  L_L59  0.0058
K_K7799  L_L46  L_L60  0.0054
K_K7800  L_L46  L_L61  0.0051
K_K7801  L_L46  L_L62  0.0047
K_K7802  L_L46  L_L63  0.0045
K_K7803  L_L46  L_L64  0.0042
K_K7804  L_L46  L_L65  0.0040
K_K7805  L_L46  L_L66  0.0038
K_K7806  L_L46  L_L67  0.0036
K_K7807  L_L46  L_L68  0.0034
K_K7808  L_L46  L_L69  0.0033
K_K7809  L_L46  L_L70  0.0032
K_K7810  L_L46  L_L71  0.0030
K_K7811  L_L46  L_L72  0.0029
K_K7812  L_L46  L_L73  0.0028
K_K7813  L_L46  L_L74  0.0027
K_K7814  L_L46  L_L75  0.0026
K_K7815  L_L46  L_L76  0.0025
K_K7816  L_L46  L_L77  0.0024
K_K7817  L_L46  L_L78  0.0024
K_K7818  L_L46  L_L79  0.0023
K_K7819  L_L46  L_L80  0.0022
K_K7820  L_L46  L_L81  0.0022
K_K7821  L_L46  L_L82  0.0021
K_K7822  L_L46  L_L83  0.0020
K_K7823  L_L46  L_L84  0.0020
K_K7824  L_L46  L_L85  0.0019
K_K7825  L_L46  L_L86  0.0019
K_K7826  L_L46  L_L87  0.0019
K_K7827  L_L46  L_L88  0.0018
K_K7828  L_L46  L_L89  0.0018
K_K7829  L_L46  L_L90  0.0017
K_K7830  L_L46  L_L91  0.0017
K_K7831  L_L46  L_L92  0.0017
K_K7832  L_L46  L_L93  0.0016
K_K7833  L_L46  L_L94  0.0016
K_K7834  L_L46  L_L95  0.0015
K_K7835  L_L46  L_L96  0.0015
K_K7836  L_L46  L_L97  0.0015
K_K7837  L_L46  L_L98  0.0015
K_K7838  L_L46  L_L99  0.0014
K_K7839  L_L46  L_L100  0.0014
K_K7840  L_L46  L_L101  0.0014
K_K7841  L_L46  L_L102  0.0014
K_K7842  L_L46  L_L103  0.0013
K_K7843  L_L46  L_L104  0.0013
K_K7844  L_L46  L_L105  0.0013
K_K7845  L_L46  L_L106  0.0013
K_K7846  L_L46  L_L107  0.0013
K_K7847  L_L46  L_L108  0.0012
K_K7848  L_L46  L_L109  0.0012
K_K7849  L_L46  L_L110  0.0012
K_K7850  L_L46  L_L111  0.0012
K_K7851  L_L46  L_L112  0.0011
K_K7852  L_L46  L_L113  0.0011
K_K7853  L_L46  L_L114  0.0011
K_K7854  L_L46  L_L115  0.0011
K_K7855  L_L46  L_L116  0.0011
K_K7856  L_L46  L_L117  0.0011
K_K7857  L_L46  L_L118  0.0011
K_K7858  L_L46  L_L119  0.0010
K_K7859  L_L46  L_L120  0.0010
K_K7860  L_L46  L_L121  0.0010
K_K7861  L_L46  L_L139  0.0017
K_K7862  L_L46  L_L140  0.0017
K_K7863  L_L46  L_L141  0.0018
K_K7864  L_L46  L_L142  0.0018
K_K7865  L_L46  L_L143  0.0018
K_K7866  L_L46  L_L144  0.0019
K_K7867  L_L46  L_L145  0.0019
K_K7868  L_L46  L_L146  0.0020
K_K7869  L_L46  L_L147  0.0020
K_K7870  L_L46  L_L148  0.0021
K_K7871  L_L46  L_L149  0.0022
K_K7872  L_L46  L_L150  0.0022
K_K7873  L_L46  L_L151  0.0023
K_K7874  L_L46  L_L152  0.0024
K_K7875  L_L46  L_L153  0.0024
K_K7876  L_L46  L_L154  0.0025
K_K7877  L_L46  L_L155  0.0026
K_K7878  L_L46  L_L156  0.0027
K_K7879  L_L46  L_L157  0.0028
K_K7880  L_L46  L_L158  0.0029
K_K7881  L_L46  L_L159  0.0030
K_K7882  L_L46  L_L160  0.0032
K_K7883  L_L46  L_L161  0.0033
K_K7884  L_L46  L_L162  0.0034
K_K7885  L_L46  L_L163  0.0036
K_K7886  L_L46  L_L164  0.0038
K_K7887  L_L46  L_L165  0.0040
K_K7888  L_L46  L_L166  0.0042
K_K7889  L_L46  L_L167  0.0045
K_K7890  L_L46  L_L168  0.0047
K_K7891  L_L46  L_L169  0.0051
K_K7892  L_L46  L_L170  0.0054
K_K7893  L_L46  L_L171  0.0058
K_K7894  L_L46  L_L172  0.0063
K_K7895  L_L46  L_L173  0.0069
K_K7896  L_L46  L_L174  0.0076
K_K7897  L_L46  L_L175  0.0084
K_K7898  L_L46  L_L176  0.0095
K_K7899  L_L46  L_L177  0.0109
K_K7900  L_L46  L_L178  0.0127
K_K7901  L_L46  L_L179  0.0152
K_K7902  L_L46  L_L180  0.0191
K_K7903  L_L46  L_L181  0.0256
K_K7904  L_L46  L_L182  0.0389
K_K7905  L_L46  L_L183  0.0812
K_K7906  L_L46  L_L184  0.1569
K_K7907  L_L46  L_L185  0.0812
K_K7908  L_L46  L_L186  0.0389
K_K7909  L_L46  L_L187  0.0256
K_K7910  L_L46  L_L188  0.0191
K_K7911  L_L46  L_L189  0.0152
K_K7912  L_L46  L_L190  0.0127
K_K7913  L_L46  L_L191  0.0109
K_K7914  L_L46  L_L192  0.0095
K_K7915  L_L46  L_L193  0.0084
K_K7916  L_L46  L_L194  0.0076
K_K7917  L_L46  L_L195  0.0069
K_K7918  L_L46  L_L196  0.0063
K_K7919  L_L46  L_L197  0.0058
K_K7920  L_L46  L_L198  0.0054
K_K7921  L_L46  L_L199  0.0051
K_K7922  L_L46  L_L200  0.0047
K_K7923  L_L46  L_L201  0.0045
K_K7924  L_L46  L_L202  0.0042
K_K7925  L_L46  L_L203  0.0040
K_K7926  L_L46  L_L204  0.0038
K_K7927  L_L46  L_L205  0.0036
K_K7928  L_L46  L_L206  0.0034
K_K7929  L_L46  L_L207  0.0033
K_K7930  L_L46  L_L208  0.0032
K_K7931  L_L46  L_L209  0.0030
K_K7932  L_L46  L_L210  0.0029
K_K7933  L_L46  L_L211  0.0028
K_K7934  L_L46  L_L212  0.0027
K_K7935  L_L46  L_L213  0.0026
K_K7936  L_L46  L_L214  0.0025
K_K7937  L_L46  L_L215  0.0024
K_K7938  L_L46  L_L216  0.0024
K_K7939  L_L46  L_L217  0.0023
K_K7940  L_L46  L_L218  0.0022
K_K7941  L_L46  L_L219  0.0022
K_K7942  L_L46  L_L220  0.0021
K_K7943  L_L46  L_L221  0.0020
K_K7944  L_L46  L_L222  0.0020
K_K7945  L_L46  L_L223  0.0019
K_K7946  L_L46  L_L224  0.0019
K_K7947  L_L46  L_L225  0.0018
K_K7948  L_L46  L_L226  0.0018
K_K7949  L_L46  L_L227  0.0018
K_K7950  L_L46  L_L228  0.0017
K_K7951  L_L46  L_L229  0.0017
K_K7952  L_L46  L_L230  0.0016
K_K7953  L_L46  L_L231  0.0016
K_K7954  L_L46  L_L232  0.0016
K_K7955  L_L46  L_L233  0.0015
K_K7956  L_L46  L_L234  0.0015
K_K7957  L_L46  L_L235  0.0015
K_K7958  L_L46  L_L236  0.0015
K_K7959  L_L46  L_L237  0.0014
K_K7960  L_L46  L_L238  0.0014
K_K7961  L_L46  L_L239  0.0014
K_K7962  L_L46  L_L240  0.0014
K_K7963  L_L46  L_L241  0.0013
K_K7964  L_L46  L_L242  0.0013
K_K7965  L_L46  L_L243  0.0013
K_K7966  L_L46  L_L244  0.0013
K_K7967  L_L46  L_L245  0.0012
K_K7968  L_L46  L_L246  0.0012
K_K7969  L_L46  L_L247  0.0012
K_K7970  L_L46  L_L248  0.0012
K_K7971  L_L46  L_L249  0.0012
K_K7972  L_L46  L_L250  0.0011
K_K7973  L_L46  L_L251  0.0011
K_K7974  L_L46  L_L252  0.0011
K_K7975  L_L46  L_L253  0.0011
K_K7976  L_L46  L_L254  0.0011
K_K7977  L_L46  L_L255  0.0011
K_K7978  L_L46  L_L256  0.0011
K_K7979  L_L46  L_L257  0.0010
K_K7980  L_L46  L_L258  0.0010
K_K7981  L_L46  L_L259  0.0010
* *  Branch  NTMP0000000046 - NTMP0000000047
R_R47  NTMP0000000046  nU_47  32.914993m  TC=0,0
V_Ui47  nU_47  nR_47  STIMULUS=U_IND_0000000047
R_V93  nR_47  nV_93  23.280268m  TC=0,0
L_V93  nR_47  nV_93  0.014646uH
R_V94  nV_93  nV_94  7.852787m  TC=0,0
L_V94  nV_93  nV_94  0.073723uH
L_L47  nV_94  NTMP0000000047  6.519695uH
K_K7982  L_L47  L_L48  0.1050
K_K7983  L_L47  L_L49  0.0397
K_K7984  L_L47  L_L50  0.0258
K_K7985  L_L47  L_L51  0.0192
K_K7986  L_L47  L_L52  0.0153
K_K7987  L_L47  L_L53  0.0127
K_K7988  L_L47  L_L54  0.0109
K_K7989  L_L47  L_L55  0.0095
K_K7990  L_L47  L_L56  0.0084
K_K7991  L_L47  L_L57  0.0076
K_K7992  L_L47  L_L58  0.0069
K_K7993  L_L47  L_L59  0.0063
K_K7994  L_L47  L_L60  0.0058
K_K7995  L_L47  L_L61  0.0054
K_K7996  L_L47  L_L62  0.0051
K_K7997  L_L47  L_L63  0.0047
K_K7998  L_L47  L_L64  0.0045
K_K7999  L_L47  L_L65  0.0042
K_K8000  L_L47  L_L66  0.0040
K_K8001  L_L47  L_L67  0.0038
K_K8002  L_L47  L_L68  0.0036
K_K8003  L_L47  L_L69  0.0034
K_K8004  L_L47  L_L70  0.0033
K_K8005  L_L47  L_L71  0.0032
K_K8006  L_L47  L_L72  0.0030
K_K8007  L_L47  L_L73  0.0029
K_K8008  L_L47  L_L74  0.0028
K_K8009  L_L47  L_L75  0.0027
K_K8010  L_L47  L_L76  0.0026
K_K8011  L_L47  L_L77  0.0025
K_K8012  L_L47  L_L78  0.0024
K_K8013  L_L47  L_L79  0.0024
K_K8014  L_L47  L_L80  0.0023
K_K8015  L_L47  L_L81  0.0022
K_K8016  L_L47  L_L82  0.0022
K_K8017  L_L47  L_L83  0.0021
K_K8018  L_L47  L_L84  0.0020
K_K8019  L_L47  L_L85  0.0020
K_K8020  L_L47  L_L86  0.0019
K_K8021  L_L47  L_L87  0.0019
K_K8022  L_L47  L_L88  0.0019
K_K8023  L_L47  L_L89  0.0018
K_K8024  L_L47  L_L90  0.0018
K_K8025  L_L47  L_L91  0.0017
K_K8026  L_L47  L_L92  0.0017
K_K8027  L_L47  L_L93  0.0017
K_K8028  L_L47  L_L94  0.0016
K_K8029  L_L47  L_L95  0.0016
K_K8030  L_L47  L_L96  0.0015
K_K8031  L_L47  L_L97  0.0015
K_K8032  L_L47  L_L98  0.0015
K_K8033  L_L47  L_L99  0.0015
K_K8034  L_L47  L_L100  0.0014
K_K8035  L_L47  L_L101  0.0014
K_K8036  L_L47  L_L102  0.0014
K_K8037  L_L47  L_L103  0.0014
K_K8038  L_L47  L_L104  0.0013
K_K8039  L_L47  L_L105  0.0013
K_K8040  L_L47  L_L106  0.0013
K_K8041  L_L47  L_L107  0.0013
K_K8042  L_L47  L_L108  0.0013
K_K8043  L_L47  L_L109  0.0012
K_K8044  L_L47  L_L110  0.0012
K_K8045  L_L47  L_L111  0.0012
K_K8046  L_L47  L_L112  0.0012
K_K8047  L_L47  L_L113  0.0011
K_K8048  L_L47  L_L114  0.0011
K_K8049  L_L47  L_L115  0.0011
K_K8050  L_L47  L_L116  0.0011
K_K8051  L_L47  L_L117  0.0011
K_K8052  L_L47  L_L118  0.0011
K_K8053  L_L47  L_L119  0.0011
K_K8054  L_L47  L_L120  0.0010
K_K8055  L_L47  L_L121  0.0010
K_K8056  L_L47  L_L122  0.0010
K_K8057  L_L47  L_L139  0.0016
K_K8058  L_L47  L_L140  0.0017
K_K8059  L_L47  L_L141  0.0017
K_K8060  L_L47  L_L142  0.0018
K_K8061  L_L47  L_L143  0.0018
K_K8062  L_L47  L_L144  0.0018
K_K8063  L_L47  L_L145  0.0019
K_K8064  L_L47  L_L146  0.0019
K_K8065  L_L47  L_L147  0.0020
K_K8066  L_L47  L_L148  0.0020
K_K8067  L_L47  L_L149  0.0021
K_K8068  L_L47  L_L150  0.0022
K_K8069  L_L47  L_L151  0.0022
K_K8070  L_L47  L_L152  0.0023
K_K8071  L_L47  L_L153  0.0024
K_K8072  L_L47  L_L154  0.0024
K_K8073  L_L47  L_L155  0.0025
K_K8074  L_L47  L_L156  0.0026
K_K8075  L_L47  L_L157  0.0027
K_K8076  L_L47  L_L158  0.0028
K_K8077  L_L47  L_L159  0.0029
K_K8078  L_L47  L_L160  0.0030
K_K8079  L_L47  L_L161  0.0032
K_K8080  L_L47  L_L162  0.0033
K_K8081  L_L47  L_L163  0.0034
K_K8082  L_L47  L_L164  0.0036
K_K8083  L_L47  L_L165  0.0038
K_K8084  L_L47  L_L166  0.0040
K_K8085  L_L47  L_L167  0.0042
K_K8086  L_L47  L_L168  0.0045
K_K8087  L_L47  L_L169  0.0047
K_K8088  L_L47  L_L170  0.0051
K_K8089  L_L47  L_L171  0.0054
K_K8090  L_L47  L_L172  0.0058
K_K8091  L_L47  L_L173  0.0063
K_K8092  L_L47  L_L174  0.0069
K_K8093  L_L47  L_L175  0.0076
K_K8094  L_L47  L_L176  0.0084
K_K8095  L_L47  L_L177  0.0095
K_K8096  L_L47  L_L178  0.0109
K_K8097  L_L47  L_L179  0.0127
K_K8098  L_L47  L_L180  0.0152
K_K8099  L_L47  L_L181  0.0191
K_K8100  L_L47  L_L182  0.0256
K_K8101  L_L47  L_L183  0.0389
K_K8102  L_L47  L_L184  0.0812
K_K8103  L_L47  L_L185  0.1569
K_K8104  L_L47  L_L186  0.0812
K_K8105  L_L47  L_L187  0.0389
K_K8106  L_L47  L_L188  0.0256
K_K8107  L_L47  L_L189  0.0191
K_K8108  L_L47  L_L190  0.0152
K_K8109  L_L47  L_L191  0.0127
K_K8110  L_L47  L_L192  0.0109
K_K8111  L_L47  L_L193  0.0095
K_K8112  L_L47  L_L194  0.0084
K_K8113  L_L47  L_L195  0.0076
K_K8114  L_L47  L_L196  0.0069
K_K8115  L_L47  L_L197  0.0063
K_K8116  L_L47  L_L198  0.0058
K_K8117  L_L47  L_L199  0.0054
K_K8118  L_L47  L_L200  0.0051
K_K8119  L_L47  L_L201  0.0047
K_K8120  L_L47  L_L202  0.0045
K_K8121  L_L47  L_L203  0.0042
K_K8122  L_L47  L_L204  0.0040
K_K8123  L_L47  L_L205  0.0038
K_K8124  L_L47  L_L206  0.0036
K_K8125  L_L47  L_L207  0.0034
K_K8126  L_L47  L_L208  0.0033
K_K8127  L_L47  L_L209  0.0032
K_K8128  L_L47  L_L210  0.0030
K_K8129  L_L47  L_L211  0.0029
K_K8130  L_L47  L_L212  0.0028
K_K8131  L_L47  L_L213  0.0027
K_K8132  L_L47  L_L214  0.0026
K_K8133  L_L47  L_L215  0.0025
K_K8134  L_L47  L_L216  0.0024
K_K8135  L_L47  L_L217  0.0024
K_K8136  L_L47  L_L218  0.0023
K_K8137  L_L47  L_L219  0.0022
K_K8138  L_L47  L_L220  0.0022
K_K8139  L_L47  L_L221  0.0021
K_K8140  L_L47  L_L222  0.0020
K_K8141  L_L47  L_L223  0.0020
K_K8142  L_L47  L_L224  0.0019
K_K8143  L_L47  L_L225  0.0019
K_K8144  L_L47  L_L226  0.0018
K_K8145  L_L47  L_L227  0.0018
K_K8146  L_L47  L_L228  0.0018
K_K8147  L_L47  L_L229  0.0017
K_K8148  L_L47  L_L230  0.0017
K_K8149  L_L47  L_L231  0.0016
K_K8150  L_L47  L_L232  0.0016
K_K8151  L_L47  L_L233  0.0016
K_K8152  L_L47  L_L234  0.0015
K_K8153  L_L47  L_L235  0.0015
K_K8154  L_L47  L_L236  0.0015
K_K8155  L_L47  L_L237  0.0015
K_K8156  L_L47  L_L238  0.0014
K_K8157  L_L47  L_L239  0.0014
K_K8158  L_L47  L_L240  0.0014
K_K8159  L_L47  L_L241  0.0014
K_K8160  L_L47  L_L242  0.0013
K_K8161  L_L47  L_L243  0.0013
K_K8162  L_L47  L_L244  0.0013
K_K8163  L_L47  L_L245  0.0013
K_K8164  L_L47  L_L246  0.0012
K_K8165  L_L47  L_L247  0.0012
K_K8166  L_L47  L_L248  0.0012
K_K8167  L_L47  L_L249  0.0012
K_K8168  L_L47  L_L250  0.0012
K_K8169  L_L47  L_L251  0.0011
K_K8170  L_L47  L_L252  0.0011
K_K8171  L_L47  L_L253  0.0011
K_K8172  L_L47  L_L254  0.0011
K_K8173  L_L47  L_L255  0.0011
K_K8174  L_L47  L_L256  0.0011
K_K8175  L_L47  L_L257  0.0011
K_K8176  L_L47  L_L258  0.0010
K_K8177  L_L47  L_L259  0.0010
K_K8178  L_L47  L_L260  0.0010
* *  Branch  NTMP0000000047 - NTMP0000000048
R_R48  NTMP0000000047  nU_48  32.914993m  TC=0,0
V_Ui48  nU_48  nR_48  STIMULUS=U_IND_0000000048
R_V95  nR_48  nV_95  23.280268m  TC=0,0
L_V95  nR_48  nV_95  0.014646uH
R_V96  nV_95  nV_96  7.852787m  TC=0,0
L_V96  nV_95  nV_96  0.073723uH
L_L48  nV_96  NTMP0000000048  6.519695uH
K_K8179  L_L48  L_L49  0.1050
K_K8180  L_L48  L_L50  0.0397
K_K8181  L_L48  L_L51  0.0258
K_K8182  L_L48  L_L52  0.0192
K_K8183  L_L48  L_L53  0.0153
K_K8184  L_L48  L_L54  0.0127
K_K8185  L_L48  L_L55  0.0109
K_K8186  L_L48  L_L56  0.0095
K_K8187  L_L48  L_L57  0.0084
K_K8188  L_L48  L_L58  0.0076
K_K8189  L_L48  L_L59  0.0069
K_K8190  L_L48  L_L60  0.0063
K_K8191  L_L48  L_L61  0.0058
K_K8192  L_L48  L_L62  0.0054
K_K8193  L_L48  L_L63  0.0051
K_K8194  L_L48  L_L64  0.0047
K_K8195  L_L48  L_L65  0.0045
K_K8196  L_L48  L_L66  0.0042
K_K8197  L_L48  L_L67  0.0040
K_K8198  L_L48  L_L68  0.0038
K_K8199  L_L48  L_L69  0.0036
K_K8200  L_L48  L_L70  0.0034
K_K8201  L_L48  L_L71  0.0033
K_K8202  L_L48  L_L72  0.0032
K_K8203  L_L48  L_L73  0.0030
K_K8204  L_L48  L_L74  0.0029
K_K8205  L_L48  L_L75  0.0028
K_K8206  L_L48  L_L76  0.0027
K_K8207  L_L48  L_L77  0.0026
K_K8208  L_L48  L_L78  0.0025
K_K8209  L_L48  L_L79  0.0024
K_K8210  L_L48  L_L80  0.0024
K_K8211  L_L48  L_L81  0.0023
K_K8212  L_L48  L_L82  0.0022
K_K8213  L_L48  L_L83  0.0022
K_K8214  L_L48  L_L84  0.0021
K_K8215  L_L48  L_L85  0.0020
K_K8216  L_L48  L_L86  0.0020
K_K8217  L_L48  L_L87  0.0019
K_K8218  L_L48  L_L88  0.0019
K_K8219  L_L48  L_L89  0.0019
K_K8220  L_L48  L_L90  0.0018
K_K8221  L_L48  L_L91  0.0018
K_K8222  L_L48  L_L92  0.0017
K_K8223  L_L48  L_L93  0.0017
K_K8224  L_L48  L_L94  0.0017
K_K8225  L_L48  L_L95  0.0016
K_K8226  L_L48  L_L96  0.0016
K_K8227  L_L48  L_L97  0.0015
K_K8228  L_L48  L_L98  0.0015
K_K8229  L_L48  L_L99  0.0015
K_K8230  L_L48  L_L100  0.0015
K_K8231  L_L48  L_L101  0.0014
K_K8232  L_L48  L_L102  0.0014
K_K8233  L_L48  L_L103  0.0014
K_K8234  L_L48  L_L104  0.0014
K_K8235  L_L48  L_L105  0.0013
K_K8236  L_L48  L_L106  0.0013
K_K8237  L_L48  L_L107  0.0013
K_K8238  L_L48  L_L108  0.0013
K_K8239  L_L48  L_L109  0.0013
K_K8240  L_L48  L_L110  0.0012
K_K8241  L_L48  L_L111  0.0012
K_K8242  L_L48  L_L112  0.0012
K_K8243  L_L48  L_L113  0.0012
K_K8244  L_L48  L_L114  0.0011
K_K8245  L_L48  L_L115  0.0011
K_K8246  L_L48  L_L116  0.0011
K_K8247  L_L48  L_L117  0.0011
K_K8248  L_L48  L_L118  0.0011
K_K8249  L_L48  L_L119  0.0011
K_K8250  L_L48  L_L120  0.0011
K_K8251  L_L48  L_L121  0.0010
K_K8252  L_L48  L_L122  0.0010
K_K8253  L_L48  L_L123  0.0010
K_K8254  L_L48  L_L139  0.0016
K_K8255  L_L48  L_L140  0.0016
K_K8256  L_L48  L_L141  0.0017
K_K8257  L_L48  L_L142  0.0017
K_K8258  L_L48  L_L143  0.0018
K_K8259  L_L48  L_L144  0.0018
K_K8260  L_L48  L_L145  0.0018
K_K8261  L_L48  L_L146  0.0019
K_K8262  L_L48  L_L147  0.0019
K_K8263  L_L48  L_L148  0.0020
K_K8264  L_L48  L_L149  0.0020
K_K8265  L_L48  L_L150  0.0021
K_K8266  L_L48  L_L151  0.0022
K_K8267  L_L48  L_L152  0.0022
K_K8268  L_L48  L_L153  0.0023
K_K8269  L_L48  L_L154  0.0024
K_K8270  L_L48  L_L155  0.0024
K_K8271  L_L48  L_L156  0.0025
K_K8272  L_L48  L_L157  0.0026
K_K8273  L_L48  L_L158  0.0027
K_K8274  L_L48  L_L159  0.0028
K_K8275  L_L48  L_L160  0.0029
K_K8276  L_L48  L_L161  0.0030
K_K8277  L_L48  L_L162  0.0032
K_K8278  L_L48  L_L163  0.0033
K_K8279  L_L48  L_L164  0.0034
K_K8280  L_L48  L_L165  0.0036
K_K8281  L_L48  L_L166  0.0038
K_K8282  L_L48  L_L167  0.0040
K_K8283  L_L48  L_L168  0.0042
K_K8284  L_L48  L_L169  0.0045
K_K8285  L_L48  L_L170  0.0047
K_K8286  L_L48  L_L171  0.0051
K_K8287  L_L48  L_L172  0.0054
K_K8288  L_L48  L_L173  0.0058
K_K8289  L_L48  L_L174  0.0063
K_K8290  L_L48  L_L175  0.0069
K_K8291  L_L48  L_L176  0.0076
K_K8292  L_L48  L_L177  0.0084
K_K8293  L_L48  L_L178  0.0095
K_K8294  L_L48  L_L179  0.0109
K_K8295  L_L48  L_L180  0.0127
K_K8296  L_L48  L_L181  0.0152
K_K8297  L_L48  L_L182  0.0191
K_K8298  L_L48  L_L183  0.0256
K_K8299  L_L48  L_L184  0.0389
K_K8300  L_L48  L_L185  0.0812
K_K8301  L_L48  L_L186  0.1569
K_K8302  L_L48  L_L187  0.0812
K_K8303  L_L48  L_L188  0.0389
K_K8304  L_L48  L_L189  0.0256
K_K8305  L_L48  L_L190  0.0191
K_K8306  L_L48  L_L191  0.0152
K_K8307  L_L48  L_L192  0.0127
K_K8308  L_L48  L_L193  0.0109
K_K8309  L_L48  L_L194  0.0095
K_K8310  L_L48  L_L195  0.0084
K_K8311  L_L48  L_L196  0.0076
K_K8312  L_L48  L_L197  0.0069
K_K8313  L_L48  L_L198  0.0063
K_K8314  L_L48  L_L199  0.0058
K_K8315  L_L48  L_L200  0.0054
K_K8316  L_L48  L_L201  0.0051
K_K8317  L_L48  L_L202  0.0047
K_K8318  L_L48  L_L203  0.0045
K_K8319  L_L48  L_L204  0.0042
K_K8320  L_L48  L_L205  0.0040
K_K8321  L_L48  L_L206  0.0038
K_K8322  L_L48  L_L207  0.0036
K_K8323  L_L48  L_L208  0.0034
K_K8324  L_L48  L_L209  0.0033
K_K8325  L_L48  L_L210  0.0032
K_K8326  L_L48  L_L211  0.0030
K_K8327  L_L48  L_L212  0.0029
K_K8328  L_L48  L_L213  0.0028
K_K8329  L_L48  L_L214  0.0027
K_K8330  L_L48  L_L215  0.0026
K_K8331  L_L48  L_L216  0.0025
K_K8332  L_L48  L_L217  0.0024
K_K8333  L_L48  L_L218  0.0024
K_K8334  L_L48  L_L219  0.0023
K_K8335  L_L48  L_L220  0.0022
K_K8336  L_L48  L_L221  0.0022
K_K8337  L_L48  L_L222  0.0021
K_K8338  L_L48  L_L223  0.0020
K_K8339  L_L48  L_L224  0.0020
K_K8340  L_L48  L_L225  0.0019
K_K8341  L_L48  L_L226  0.0019
K_K8342  L_L48  L_L227  0.0018
K_K8343  L_L48  L_L228  0.0018
K_K8344  L_L48  L_L229  0.0018
K_K8345  L_L48  L_L230  0.0017
K_K8346  L_L48  L_L231  0.0017
K_K8347  L_L48  L_L232  0.0016
K_K8348  L_L48  L_L233  0.0016
K_K8349  L_L48  L_L234  0.0016
K_K8350  L_L48  L_L235  0.0015
K_K8351  L_L48  L_L236  0.0015
K_K8352  L_L48  L_L237  0.0015
K_K8353  L_L48  L_L238  0.0015
K_K8354  L_L48  L_L239  0.0014
K_K8355  L_L48  L_L240  0.0014
K_K8356  L_L48  L_L241  0.0014
K_K8357  L_L48  L_L242  0.0014
K_K8358  L_L48  L_L243  0.0013
K_K8359  L_L48  L_L244  0.0013
K_K8360  L_L48  L_L245  0.0013
K_K8361  L_L48  L_L246  0.0013
K_K8362  L_L48  L_L247  0.0012
K_K8363  L_L48  L_L248  0.0012
K_K8364  L_L48  L_L249  0.0012
K_K8365  L_L48  L_L250  0.0012
K_K8366  L_L48  L_L251  0.0012
K_K8367  L_L48  L_L252  0.0011
K_K8368  L_L48  L_L253  0.0011
K_K8369  L_L48  L_L254  0.0011
K_K8370  L_L48  L_L255  0.0011
K_K8371  L_L48  L_L256  0.0011
K_K8372  L_L48  L_L257  0.0011
K_K8373  L_L48  L_L258  0.0011
K_K8374  L_L48  L_L259  0.0010
K_K8375  L_L48  L_L260  0.0010
K_K8376  L_L48  L_L261  0.0010
* *  Branch  NTMP0000000048 - NTMP0000000049
R_R49  NTMP0000000048  nU_49  32.914993m  TC=0,0
V_Ui49  nU_49  nR_49  STIMULUS=U_IND_0000000049
R_V97  nR_49  nV_97  23.280268m  TC=0,0
L_V97  nR_49  nV_97  0.014646uH
R_V98  nV_97  nV_98  7.852787m  TC=0,0
L_V98  nV_97  nV_98  0.073723uH
L_L49  nV_98  NTMP0000000049  6.519695uH
K_K8377  L_L49  L_L50  0.1050
K_K8378  L_L49  L_L51  0.0397
K_K8379  L_L49  L_L52  0.0258
K_K8380  L_L49  L_L53  0.0192
K_K8381  L_L49  L_L54  0.0153
K_K8382  L_L49  L_L55  0.0127
K_K8383  L_L49  L_L56  0.0109
K_K8384  L_L49  L_L57  0.0095
K_K8385  L_L49  L_L58  0.0084
K_K8386  L_L49  L_L59  0.0076
K_K8387  L_L49  L_L60  0.0069
K_K8388  L_L49  L_L61  0.0063
K_K8389  L_L49  L_L62  0.0058
K_K8390  L_L49  L_L63  0.0054
K_K8391  L_L49  L_L64  0.0051
K_K8392  L_L49  L_L65  0.0047
K_K8393  L_L49  L_L66  0.0045
K_K8394  L_L49  L_L67  0.0042
K_K8395  L_L49  L_L68  0.0040
K_K8396  L_L49  L_L69  0.0038
K_K8397  L_L49  L_L70  0.0036
K_K8398  L_L49  L_L71  0.0034
K_K8399  L_L49  L_L72  0.0033
K_K8400  L_L49  L_L73  0.0032
K_K8401  L_L49  L_L74  0.0030
K_K8402  L_L49  L_L75  0.0029
K_K8403  L_L49  L_L76  0.0028
K_K8404  L_L49  L_L77  0.0027
K_K8405  L_L49  L_L78  0.0026
K_K8406  L_L49  L_L79  0.0025
K_K8407  L_L49  L_L80  0.0024
K_K8408  L_L49  L_L81  0.0024
K_K8409  L_L49  L_L82  0.0023
K_K8410  L_L49  L_L83  0.0022
K_K8411  L_L49  L_L84  0.0022
K_K8412  L_L49  L_L85  0.0021
K_K8413  L_L49  L_L86  0.0020
K_K8414  L_L49  L_L87  0.0020
K_K8415  L_L49  L_L88  0.0019
K_K8416  L_L49  L_L89  0.0019
K_K8417  L_L49  L_L90  0.0019
K_K8418  L_L49  L_L91  0.0018
K_K8419  L_L49  L_L92  0.0018
K_K8420  L_L49  L_L93  0.0017
K_K8421  L_L49  L_L94  0.0017
K_K8422  L_L49  L_L95  0.0017
K_K8423  L_L49  L_L96  0.0016
K_K8424  L_L49  L_L97  0.0016
K_K8425  L_L49  L_L98  0.0015
K_K8426  L_L49  L_L99  0.0015
K_K8427  L_L49  L_L100  0.0015
K_K8428  L_L49  L_L101  0.0015
K_K8429  L_L49  L_L102  0.0014
K_K8430  L_L49  L_L103  0.0014
K_K8431  L_L49  L_L104  0.0014
K_K8432  L_L49  L_L105  0.0014
K_K8433  L_L49  L_L106  0.0013
K_K8434  L_L49  L_L107  0.0013
K_K8435  L_L49  L_L108  0.0013
K_K8436  L_L49  L_L109  0.0013
K_K8437  L_L49  L_L110  0.0013
K_K8438  L_L49  L_L111  0.0012
K_K8439  L_L49  L_L112  0.0012
K_K8440  L_L49  L_L113  0.0012
K_K8441  L_L49  L_L114  0.0012
K_K8442  L_L49  L_L115  0.0011
K_K8443  L_L49  L_L116  0.0011
K_K8444  L_L49  L_L117  0.0011
K_K8445  L_L49  L_L118  0.0011
K_K8446  L_L49  L_L119  0.0011
K_K8447  L_L49  L_L120  0.0011
K_K8448  L_L49  L_L121  0.0011
K_K8449  L_L49  L_L122  0.0010
K_K8450  L_L49  L_L123  0.0010
K_K8451  L_L49  L_L124  0.0010
K_K8452  L_L49  L_L139  0.0016
K_K8453  L_L49  L_L140  0.0016
K_K8454  L_L49  L_L141  0.0016
K_K8455  L_L49  L_L142  0.0017
K_K8456  L_L49  L_L143  0.0017
K_K8457  L_L49  L_L144  0.0018
K_K8458  L_L49  L_L145  0.0018
K_K8459  L_L49  L_L146  0.0018
K_K8460  L_L49  L_L147  0.0019
K_K8461  L_L49  L_L148  0.0019
K_K8462  L_L49  L_L149  0.0020
K_K8463  L_L49  L_L150  0.0020
K_K8464  L_L49  L_L151  0.0021
K_K8465  L_L49  L_L152  0.0022
K_K8466  L_L49  L_L153  0.0022
K_K8467  L_L49  L_L154  0.0023
K_K8468  L_L49  L_L155  0.0024
K_K8469  L_L49  L_L156  0.0024
K_K8470  L_L49  L_L157  0.0025
K_K8471  L_L49  L_L158  0.0026
K_K8472  L_L49  L_L159  0.0027
K_K8473  L_L49  L_L160  0.0028
K_K8474  L_L49  L_L161  0.0029
K_K8475  L_L49  L_L162  0.0030
K_K8476  L_L49  L_L163  0.0032
K_K8477  L_L49  L_L164  0.0033
K_K8478  L_L49  L_L165  0.0034
K_K8479  L_L49  L_L166  0.0036
K_K8480  L_L49  L_L167  0.0038
K_K8481  L_L49  L_L168  0.0040
K_K8482  L_L49  L_L169  0.0042
K_K8483  L_L49  L_L170  0.0045
K_K8484  L_L49  L_L171  0.0047
K_K8485  L_L49  L_L172  0.0051
K_K8486  L_L49  L_L173  0.0054
K_K8487  L_L49  L_L174  0.0058
K_K8488  L_L49  L_L175  0.0063
K_K8489  L_L49  L_L176  0.0069
K_K8490  L_L49  L_L177  0.0076
K_K8491  L_L49  L_L178  0.0084
K_K8492  L_L49  L_L179  0.0095
K_K8493  L_L49  L_L180  0.0109
K_K8494  L_L49  L_L181  0.0127
K_K8495  L_L49  L_L182  0.0152
K_K8496  L_L49  L_L183  0.0191
K_K8497  L_L49  L_L184  0.0256
K_K8498  L_L49  L_L185  0.0389
K_K8499  L_L49  L_L186  0.0812
K_K8500  L_L49  L_L187  0.1569
K_K8501  L_L49  L_L188  0.0812
K_K8502  L_L49  L_L189  0.0389
K_K8503  L_L49  L_L190  0.0256
K_K8504  L_L49  L_L191  0.0191
K_K8505  L_L49  L_L192  0.0152
K_K8506  L_L49  L_L193  0.0127
K_K8507  L_L49  L_L194  0.0109
K_K8508  L_L49  L_L195  0.0095
K_K8509  L_L49  L_L196  0.0084
K_K8510  L_L49  L_L197  0.0076
K_K8511  L_L49  L_L198  0.0069
K_K8512  L_L49  L_L199  0.0063
K_K8513  L_L49  L_L200  0.0058
K_K8514  L_L49  L_L201  0.0054
K_K8515  L_L49  L_L202  0.0051
K_K8516  L_L49  L_L203  0.0047
K_K8517  L_L49  L_L204  0.0045
K_K8518  L_L49  L_L205  0.0042
K_K8519  L_L49  L_L206  0.0040
K_K8520  L_L49  L_L207  0.0038
K_K8521  L_L49  L_L208  0.0036
K_K8522  L_L49  L_L209  0.0034
K_K8523  L_L49  L_L210  0.0033
K_K8524  L_L49  L_L211  0.0032
K_K8525  L_L49  L_L212  0.0030
K_K8526  L_L49  L_L213  0.0029
K_K8527  L_L49  L_L214  0.0028
K_K8528  L_L49  L_L215  0.0027
K_K8529  L_L49  L_L216  0.0026
K_K8530  L_L49  L_L217  0.0025
K_K8531  L_L49  L_L218  0.0024
K_K8532  L_L49  L_L219  0.0024
K_K8533  L_L49  L_L220  0.0023
K_K8534  L_L49  L_L221  0.0022
K_K8535  L_L49  L_L222  0.0022
K_K8536  L_L49  L_L223  0.0021
K_K8537  L_L49  L_L224  0.0020
K_K8538  L_L49  L_L225  0.0020
K_K8539  L_L49  L_L226  0.0019
K_K8540  L_L49  L_L227  0.0019
K_K8541  L_L49  L_L228  0.0018
K_K8542  L_L49  L_L229  0.0018
K_K8543  L_L49  L_L230  0.0018
K_K8544  L_L49  L_L231  0.0017
K_K8545  L_L49  L_L232  0.0017
K_K8546  L_L49  L_L233  0.0016
K_K8547  L_L49  L_L234  0.0016
K_K8548  L_L49  L_L235  0.0016
K_K8549  L_L49  L_L236  0.0015
K_K8550  L_L49  L_L237  0.0015
K_K8551  L_L49  L_L238  0.0015
K_K8552  L_L49  L_L239  0.0015
K_K8553  L_L49  L_L240  0.0014
K_K8554  L_L49  L_L241  0.0014
K_K8555  L_L49  L_L242  0.0014
K_K8556  L_L49  L_L243  0.0014
K_K8557  L_L49  L_L244  0.0013
K_K8558  L_L49  L_L245  0.0013
K_K8559  L_L49  L_L246  0.0013
K_K8560  L_L49  L_L247  0.0013
K_K8561  L_L49  L_L248  0.0012
K_K8562  L_L49  L_L249  0.0012
K_K8563  L_L49  L_L250  0.0012
K_K8564  L_L49  L_L251  0.0012
K_K8565  L_L49  L_L252  0.0012
K_K8566  L_L49  L_L253  0.0011
K_K8567  L_L49  L_L254  0.0011
K_K8568  L_L49  L_L255  0.0011
K_K8569  L_L49  L_L256  0.0011
K_K8570  L_L49  L_L257  0.0011
K_K8571  L_L49  L_L258  0.0011
K_K8572  L_L49  L_L259  0.0011
K_K8573  L_L49  L_L260  0.0010
K_K8574  L_L49  L_L261  0.0010
K_K8575  L_L49  L_L262  0.0010
* *  Branch  NTMP0000000049 - NTMP0000000050
R_R50  NTMP0000000049  nU_50  32.914993m  TC=0,0
V_Ui50  nU_50  nR_50  STIMULUS=U_IND_0000000050
R_V99  nR_50  nV_99  23.280268m  TC=0,0
L_V99  nR_50  nV_99  0.014646uH
R_V100  nV_99  nV_100  7.852787m  TC=0,0
L_V100  nV_99  nV_100  0.073723uH
L_L50  nV_100  NTMP0000000050  6.519695uH
K_K8576  L_L50  L_L51  0.1050
K_K8577  L_L50  L_L52  0.0397
K_K8578  L_L50  L_L53  0.0258
K_K8579  L_L50  L_L54  0.0192
K_K8580  L_L50  L_L55  0.0153
K_K8581  L_L50  L_L56  0.0127
K_K8582  L_L50  L_L57  0.0109
K_K8583  L_L50  L_L58  0.0095
K_K8584  L_L50  L_L59  0.0084
K_K8585  L_L50  L_L60  0.0076
K_K8586  L_L50  L_L61  0.0069
K_K8587  L_L50  L_L62  0.0063
K_K8588  L_L50  L_L63  0.0058
K_K8589  L_L50  L_L64  0.0054
K_K8590  L_L50  L_L65  0.0051
K_K8591  L_L50  L_L66  0.0047
K_K8592  L_L50  L_L67  0.0045
K_K8593  L_L50  L_L68  0.0042
K_K8594  L_L50  L_L69  0.0040
K_K8595  L_L50  L_L70  0.0038
K_K8596  L_L50  L_L71  0.0036
K_K8597  L_L50  L_L72  0.0034
K_K8598  L_L50  L_L73  0.0033
K_K8599  L_L50  L_L74  0.0032
K_K8600  L_L50  L_L75  0.0030
K_K8601  L_L50  L_L76  0.0029
K_K8602  L_L50  L_L77  0.0028
K_K8603  L_L50  L_L78  0.0027
K_K8604  L_L50  L_L79  0.0026
K_K8605  L_L50  L_L80  0.0025
K_K8606  L_L50  L_L81  0.0024
K_K8607  L_L50  L_L82  0.0024
K_K8608  L_L50  L_L83  0.0023
K_K8609  L_L50  L_L84  0.0022
K_K8610  L_L50  L_L85  0.0022
K_K8611  L_L50  L_L86  0.0021
K_K8612  L_L50  L_L87  0.0020
K_K8613  L_L50  L_L88  0.0020
K_K8614  L_L50  L_L89  0.0019
K_K8615  L_L50  L_L90  0.0019
K_K8616  L_L50  L_L91  0.0019
K_K8617  L_L50  L_L92  0.0018
K_K8618  L_L50  L_L93  0.0018
K_K8619  L_L50  L_L94  0.0017
K_K8620  L_L50  L_L95  0.0017
K_K8621  L_L50  L_L96  0.0017
K_K8622  L_L50  L_L97  0.0016
K_K8623  L_L50  L_L98  0.0016
K_K8624  L_L50  L_L99  0.0015
K_K8625  L_L50  L_L100  0.0015
K_K8626  L_L50  L_L101  0.0015
K_K8627  L_L50  L_L102  0.0015
K_K8628  L_L50  L_L103  0.0014
K_K8629  L_L50  L_L104  0.0014
K_K8630  L_L50  L_L105  0.0014
K_K8631  L_L50  L_L106  0.0014
K_K8632  L_L50  L_L107  0.0013
K_K8633  L_L50  L_L108  0.0013
K_K8634  L_L50  L_L109  0.0013
K_K8635  L_L50  L_L110  0.0013
K_K8636  L_L50  L_L111  0.0013
K_K8637  L_L50  L_L112  0.0012
K_K8638  L_L50  L_L113  0.0012
K_K8639  L_L50  L_L114  0.0012
K_K8640  L_L50  L_L115  0.0012
K_K8641  L_L50  L_L116  0.0011
K_K8642  L_L50  L_L117  0.0011
K_K8643  L_L50  L_L118  0.0011
K_K8644  L_L50  L_L119  0.0011
K_K8645  L_L50  L_L120  0.0011
K_K8646  L_L50  L_L121  0.0011
K_K8647  L_L50  L_L122  0.0011
K_K8648  L_L50  L_L123  0.0010
K_K8649  L_L50  L_L124  0.0010
K_K8650  L_L50  L_L125  0.0010
K_K8651  L_L50  L_L139  0.0015
K_K8652  L_L50  L_L140  0.0016
K_K8653  L_L50  L_L141  0.0016
K_K8654  L_L50  L_L142  0.0016
K_K8655  L_L50  L_L143  0.0017
K_K8656  L_L50  L_L144  0.0017
K_K8657  L_L50  L_L145  0.0018
K_K8658  L_L50  L_L146  0.0018
K_K8659  L_L50  L_L147  0.0018
K_K8660  L_L50  L_L148  0.0019
K_K8661  L_L50  L_L149  0.0019
K_K8662  L_L50  L_L150  0.0020
K_K8663  L_L50  L_L151  0.0020
K_K8664  L_L50  L_L152  0.0021
K_K8665  L_L50  L_L153  0.0022
K_K8666  L_L50  L_L154  0.0022
K_K8667  L_L50  L_L155  0.0023
K_K8668  L_L50  L_L156  0.0024
K_K8669  L_L50  L_L157  0.0024
K_K8670  L_L50  L_L158  0.0025
K_K8671  L_L50  L_L159  0.0026
K_K8672  L_L50  L_L160  0.0027
K_K8673  L_L50  L_L161  0.0028
K_K8674  L_L50  L_L162  0.0029
K_K8675  L_L50  L_L163  0.0030
K_K8676  L_L50  L_L164  0.0032
K_K8677  L_L50  L_L165  0.0033
K_K8678  L_L50  L_L166  0.0034
K_K8679  L_L50  L_L167  0.0036
K_K8680  L_L50  L_L168  0.0038
K_K8681  L_L50  L_L169  0.0040
K_K8682  L_L50  L_L170  0.0042
K_K8683  L_L50  L_L171  0.0045
K_K8684  L_L50  L_L172  0.0047
K_K8685  L_L50  L_L173  0.0051
K_K8686  L_L50  L_L174  0.0054
K_K8687  L_L50  L_L175  0.0058
K_K8688  L_L50  L_L176  0.0063
K_K8689  L_L50  L_L177  0.0069
K_K8690  L_L50  L_L178  0.0076
K_K8691  L_L50  L_L179  0.0084
K_K8692  L_L50  L_L180  0.0095
K_K8693  L_L50  L_L181  0.0109
K_K8694  L_L50  L_L182  0.0127
K_K8695  L_L50  L_L183  0.0152
K_K8696  L_L50  L_L184  0.0191
K_K8697  L_L50  L_L185  0.0256
K_K8698  L_L50  L_L186  0.0389
K_K8699  L_L50  L_L187  0.0812
K_K8700  L_L50  L_L188  0.1569
K_K8701  L_L50  L_L189  0.0812
K_K8702  L_L50  L_L190  0.0389
K_K8703  L_L50  L_L191  0.0256
K_K8704  L_L50  L_L192  0.0191
K_K8705  L_L50  L_L193  0.0152
K_K8706  L_L50  L_L194  0.0127
K_K8707  L_L50  L_L195  0.0109
K_K8708  L_L50  L_L196  0.0095
K_K8709  L_L50  L_L197  0.0084
K_K8710  L_L50  L_L198  0.0076
K_K8711  L_L50  L_L199  0.0069
K_K8712  L_L50  L_L200  0.0063
K_K8713  L_L50  L_L201  0.0058
K_K8714  L_L50  L_L202  0.0054
K_K8715  L_L50  L_L203  0.0051
K_K8716  L_L50  L_L204  0.0047
K_K8717  L_L50  L_L205  0.0045
K_K8718  L_L50  L_L206  0.0042
K_K8719  L_L50  L_L207  0.0040
K_K8720  L_L50  L_L208  0.0038
K_K8721  L_L50  L_L209  0.0036
K_K8722  L_L50  L_L210  0.0034
K_K8723  L_L50  L_L211  0.0033
K_K8724  L_L50  L_L212  0.0032
K_K8725  L_L50  L_L213  0.0030
K_K8726  L_L50  L_L214  0.0029
K_K8727  L_L50  L_L215  0.0028
K_K8728  L_L50  L_L216  0.0027
K_K8729  L_L50  L_L217  0.0026
K_K8730  L_L50  L_L218  0.0025
K_K8731  L_L50  L_L219  0.0024
K_K8732  L_L50  L_L220  0.0024
K_K8733  L_L50  L_L221  0.0023
K_K8734  L_L50  L_L222  0.0022
K_K8735  L_L50  L_L223  0.0022
K_K8736  L_L50  L_L224  0.0021
K_K8737  L_L50  L_L225  0.0020
K_K8738  L_L50  L_L226  0.0020
K_K8739  L_L50  L_L227  0.0019
K_K8740  L_L50  L_L228  0.0019
K_K8741  L_L50  L_L229  0.0018
K_K8742  L_L50  L_L230  0.0018
K_K8743  L_L50  L_L231  0.0018
K_K8744  L_L50  L_L232  0.0017
K_K8745  L_L50  L_L233  0.0017
K_K8746  L_L50  L_L234  0.0016
K_K8747  L_L50  L_L235  0.0016
K_K8748  L_L50  L_L236  0.0016
K_K8749  L_L50  L_L237  0.0015
K_K8750  L_L50  L_L238  0.0015
K_K8751  L_L50  L_L239  0.0015
K_K8752  L_L50  L_L240  0.0015
K_K8753  L_L50  L_L241  0.0014
K_K8754  L_L50  L_L242  0.0014
K_K8755  L_L50  L_L243  0.0014
K_K8756  L_L50  L_L244  0.0014
K_K8757  L_L50  L_L245  0.0013
K_K8758  L_L50  L_L246  0.0013
K_K8759  L_L50  L_L247  0.0013
K_K8760  L_L50  L_L248  0.0013
K_K8761  L_L50  L_L249  0.0012
K_K8762  L_L50  L_L250  0.0012
K_K8763  L_L50  L_L251  0.0012
K_K8764  L_L50  L_L252  0.0012
K_K8765  L_L50  L_L253  0.0012
K_K8766  L_L50  L_L254  0.0011
K_K8767  L_L50  L_L255  0.0011
K_K8768  L_L50  L_L256  0.0011
K_K8769  L_L50  L_L257  0.0011
K_K8770  L_L50  L_L258  0.0011
K_K8771  L_L50  L_L259  0.0011
K_K8772  L_L50  L_L260  0.0011
K_K8773  L_L50  L_L261  0.0010
K_K8774  L_L50  L_L262  0.0010
K_K8775  L_L50  L_L263  0.0010
* *  Branch  NTMP0000000050 - NTMP0000000051
R_R51  NTMP0000000050  nU_51  32.914993m  TC=0,0
V_Ui51  nU_51  nR_51  STIMULUS=U_IND_0000000051
R_V101  nR_51  nV_101  23.280268m  TC=0,0
L_V101  nR_51  nV_101  0.014646uH
R_V102  nV_101  nV_102  7.852787m  TC=0,0
L_V102  nV_101  nV_102  0.073723uH
L_L51  nV_102  NTMP0000000051  6.519695uH
K_K8776  L_L51  L_L52  0.1050
K_K8777  L_L51  L_L53  0.0397
K_K8778  L_L51  L_L54  0.0258
K_K8779  L_L51  L_L55  0.0192
K_K8780  L_L51  L_L56  0.0153
K_K8781  L_L51  L_L57  0.0127
K_K8782  L_L51  L_L58  0.0109
K_K8783  L_L51  L_L59  0.0095
K_K8784  L_L51  L_L60  0.0084
K_K8785  L_L51  L_L61  0.0076
K_K8786  L_L51  L_L62  0.0069
K_K8787  L_L51  L_L63  0.0063
K_K8788  L_L51  L_L64  0.0058
K_K8789  L_L51  L_L65  0.0054
K_K8790  L_L51  L_L66  0.0051
K_K8791  L_L51  L_L67  0.0047
K_K8792  L_L51  L_L68  0.0045
K_K8793  L_L51  L_L69  0.0042
K_K8794  L_L51  L_L70  0.0040
K_K8795  L_L51  L_L71  0.0038
K_K8796  L_L51  L_L72  0.0036
K_K8797  L_L51  L_L73  0.0034
K_K8798  L_L51  L_L74  0.0033
K_K8799  L_L51  L_L75  0.0032
K_K8800  L_L51  L_L76  0.0030
K_K8801  L_L51  L_L77  0.0029
K_K8802  L_L51  L_L78  0.0028
K_K8803  L_L51  L_L79  0.0027
K_K8804  L_L51  L_L80  0.0026
K_K8805  L_L51  L_L81  0.0025
K_K8806  L_L51  L_L82  0.0024
K_K8807  L_L51  L_L83  0.0024
K_K8808  L_L51  L_L84  0.0023
K_K8809  L_L51  L_L85  0.0022
K_K8810  L_L51  L_L86  0.0022
K_K8811  L_L51  L_L87  0.0021
K_K8812  L_L51  L_L88  0.0020
K_K8813  L_L51  L_L89  0.0020
K_K8814  L_L51  L_L90  0.0019
K_K8815  L_L51  L_L91  0.0019
K_K8816  L_L51  L_L92  0.0019
K_K8817  L_L51  L_L93  0.0018
K_K8818  L_L51  L_L94  0.0018
K_K8819  L_L51  L_L95  0.0017
K_K8820  L_L51  L_L96  0.0017
K_K8821  L_L51  L_L97  0.0017
K_K8822  L_L51  L_L98  0.0016
K_K8823  L_L51  L_L99  0.0016
K_K8824  L_L51  L_L100  0.0015
K_K8825  L_L51  L_L101  0.0015
K_K8826  L_L51  L_L102  0.0015
K_K8827  L_L51  L_L103  0.0015
K_K8828  L_L51  L_L104  0.0014
K_K8829  L_L51  L_L105  0.0014
K_K8830  L_L51  L_L106  0.0014
K_K8831  L_L51  L_L107  0.0014
K_K8832  L_L51  L_L108  0.0013
K_K8833  L_L51  L_L109  0.0013
K_K8834  L_L51  L_L110  0.0013
K_K8835  L_L51  L_L111  0.0013
K_K8836  L_L51  L_L112  0.0013
K_K8837  L_L51  L_L113  0.0012
K_K8838  L_L51  L_L114  0.0012
K_K8839  L_L51  L_L115  0.0012
K_K8840  L_L51  L_L116  0.0012
K_K8841  L_L51  L_L117  0.0011
K_K8842  L_L51  L_L118  0.0011
K_K8843  L_L51  L_L119  0.0011
K_K8844  L_L51  L_L120  0.0011
K_K8845  L_L51  L_L121  0.0011
K_K8846  L_L51  L_L122  0.0011
K_K8847  L_L51  L_L123  0.0011
K_K8848  L_L51  L_L124  0.0010
K_K8849  L_L51  L_L125  0.0010
K_K8850  L_L51  L_L126  0.0010
K_K8851  L_L51  L_L139  0.0015
K_K8852  L_L51  L_L140  0.0015
K_K8853  L_L51  L_L141  0.0016
K_K8854  L_L51  L_L142  0.0016
K_K8855  L_L51  L_L143  0.0016
K_K8856  L_L51  L_L144  0.0017
K_K8857  L_L51  L_L145  0.0017
K_K8858  L_L51  L_L146  0.0018
K_K8859  L_L51  L_L147  0.0018
K_K8860  L_L51  L_L148  0.0018
K_K8861  L_L51  L_L149  0.0019
K_K8862  L_L51  L_L150  0.0019
K_K8863  L_L51  L_L151  0.0020
K_K8864  L_L51  L_L152  0.0020
K_K8865  L_L51  L_L153  0.0021
K_K8866  L_L51  L_L154  0.0022
K_K8867  L_L51  L_L155  0.0022
K_K8868  L_L51  L_L156  0.0023
K_K8869  L_L51  L_L157  0.0024
K_K8870  L_L51  L_L158  0.0024
K_K8871  L_L51  L_L159  0.0025
K_K8872  L_L51  L_L160  0.0026
K_K8873  L_L51  L_L161  0.0027
K_K8874  L_L51  L_L162  0.0028
K_K8875  L_L51  L_L163  0.0029
K_K8876  L_L51  L_L164  0.0030
K_K8877  L_L51  L_L165  0.0032
K_K8878  L_L51  L_L166  0.0033
K_K8879  L_L51  L_L167  0.0034
K_K8880  L_L51  L_L168  0.0036
K_K8881  L_L51  L_L169  0.0038
K_K8882  L_L51  L_L170  0.0040
K_K8883  L_L51  L_L171  0.0042
K_K8884  L_L51  L_L172  0.0045
K_K8885  L_L51  L_L173  0.0047
K_K8886  L_L51  L_L174  0.0051
K_K8887  L_L51  L_L175  0.0054
K_K8888  L_L51  L_L176  0.0058
K_K8889  L_L51  L_L177  0.0063
K_K8890  L_L51  L_L178  0.0069
K_K8891  L_L51  L_L179  0.0076
K_K8892  L_L51  L_L180  0.0084
K_K8893  L_L51  L_L181  0.0095
K_K8894  L_L51  L_L182  0.0109
K_K8895  L_L51  L_L183  0.0127
K_K8896  L_L51  L_L184  0.0152
K_K8897  L_L51  L_L185  0.0191
K_K8898  L_L51  L_L186  0.0256
K_K8899  L_L51  L_L187  0.0389
K_K8900  L_L51  L_L188  0.0812
K_K8901  L_L51  L_L189  0.1569
K_K8902  L_L51  L_L190  0.0812
K_K8903  L_L51  L_L191  0.0389
K_K8904  L_L51  L_L192  0.0256
K_K8905  L_L51  L_L193  0.0191
K_K8906  L_L51  L_L194  0.0152
K_K8907  L_L51  L_L195  0.0127
K_K8908  L_L51  L_L196  0.0109
K_K8909  L_L51  L_L197  0.0095
K_K8910  L_L51  L_L198  0.0084
K_K8911  L_L51  L_L199  0.0076
K_K8912  L_L51  L_L200  0.0069
K_K8913  L_L51  L_L201  0.0063
K_K8914  L_L51  L_L202  0.0058
K_K8915  L_L51  L_L203  0.0054
K_K8916  L_L51  L_L204  0.0051
K_K8917  L_L51  L_L205  0.0047
K_K8918  L_L51  L_L206  0.0045
K_K8919  L_L51  L_L207  0.0042
K_K8920  L_L51  L_L208  0.0040
K_K8921  L_L51  L_L209  0.0038
K_K8922  L_L51  L_L210  0.0036
K_K8923  L_L51  L_L211  0.0034
K_K8924  L_L51  L_L212  0.0033
K_K8925  L_L51  L_L213  0.0032
K_K8926  L_L51  L_L214  0.0030
K_K8927  L_L51  L_L215  0.0029
K_K8928  L_L51  L_L216  0.0028
K_K8929  L_L51  L_L217  0.0027
K_K8930  L_L51  L_L218  0.0026
K_K8931  L_L51  L_L219  0.0025
K_K8932  L_L51  L_L220  0.0024
K_K8933  L_L51  L_L221  0.0024
K_K8934  L_L51  L_L222  0.0023
K_K8935  L_L51  L_L223  0.0022
K_K8936  L_L51  L_L224  0.0022
K_K8937  L_L51  L_L225  0.0021
K_K8938  L_L51  L_L226  0.0020
K_K8939  L_L51  L_L227  0.0020
K_K8940  L_L51  L_L228  0.0019
K_K8941  L_L51  L_L229  0.0019
K_K8942  L_L51  L_L230  0.0018
K_K8943  L_L51  L_L231  0.0018
K_K8944  L_L51  L_L232  0.0018
K_K8945  L_L51  L_L233  0.0017
K_K8946  L_L51  L_L234  0.0017
K_K8947  L_L51  L_L235  0.0016
K_K8948  L_L51  L_L236  0.0016
K_K8949  L_L51  L_L237  0.0016
K_K8950  L_L51  L_L238  0.0015
K_K8951  L_L51  L_L239  0.0015
K_K8952  L_L51  L_L240  0.0015
K_K8953  L_L51  L_L241  0.0015
K_K8954  L_L51  L_L242  0.0014
K_K8955  L_L51  L_L243  0.0014
K_K8956  L_L51  L_L244  0.0014
K_K8957  L_L51  L_L245  0.0014
K_K8958  L_L51  L_L246  0.0013
K_K8959  L_L51  L_L247  0.0013
K_K8960  L_L51  L_L248  0.0013
K_K8961  L_L51  L_L249  0.0013
K_K8962  L_L51  L_L250  0.0012
K_K8963  L_L51  L_L251  0.0012
K_K8964  L_L51  L_L252  0.0012
K_K8965  L_L51  L_L253  0.0012
K_K8966  L_L51  L_L254  0.0012
K_K8967  L_L51  L_L255  0.0011
K_K8968  L_L51  L_L256  0.0011
K_K8969  L_L51  L_L257  0.0011
K_K8970  L_L51  L_L258  0.0011
K_K8971  L_L51  L_L259  0.0011
K_K8972  L_L51  L_L260  0.0011
K_K8973  L_L51  L_L261  0.0011
K_K8974  L_L51  L_L262  0.0010
K_K8975  L_L51  L_L263  0.0010
K_K8976  L_L51  L_L264  0.0010
* *  Branch  NTMP0000000051 - NTMP0000000052
R_R52  NTMP0000000051  nU_52  32.914993m  TC=0,0
V_Ui52  nU_52  nR_52  STIMULUS=U_IND_0000000052
R_V103  nR_52  nV_103  23.280268m  TC=0,0
L_V103  nR_52  nV_103  0.014646uH
R_V104  nV_103  nV_104  7.852787m  TC=0,0
L_V104  nV_103  nV_104  0.073723uH
L_L52  nV_104  NTMP0000000052  6.519695uH
K_K8977  L_L52  L_L53  0.1050
K_K8978  L_L52  L_L54  0.0397
K_K8979  L_L52  L_L55  0.0258
K_K8980  L_L52  L_L56  0.0192
K_K8981  L_L52  L_L57  0.0153
K_K8982  L_L52  L_L58  0.0127
K_K8983  L_L52  L_L59  0.0109
K_K8984  L_L52  L_L60  0.0095
K_K8985  L_L52  L_L61  0.0084
K_K8986  L_L52  L_L62  0.0076
K_K8987  L_L52  L_L63  0.0069
K_K8988  L_L52  L_L64  0.0063
K_K8989  L_L52  L_L65  0.0058
K_K8990  L_L52  L_L66  0.0054
K_K8991  L_L52  L_L67  0.0051
K_K8992  L_L52  L_L68  0.0047
K_K8993  L_L52  L_L69  0.0045
K_K8994  L_L52  L_L70  0.0042
K_K8995  L_L52  L_L71  0.0040
K_K8996  L_L52  L_L72  0.0038
K_K8997  L_L52  L_L73  0.0036
K_K8998  L_L52  L_L74  0.0034
K_K8999  L_L52  L_L75  0.0033
K_K9000  L_L52  L_L76  0.0032
K_K9001  L_L52  L_L77  0.0030
K_K9002  L_L52  L_L78  0.0029
K_K9003  L_L52  L_L79  0.0028
K_K9004  L_L52  L_L80  0.0027
K_K9005  L_L52  L_L81  0.0026
K_K9006  L_L52  L_L82  0.0025
K_K9007  L_L52  L_L83  0.0024
K_K9008  L_L52  L_L84  0.0024
K_K9009  L_L52  L_L85  0.0023
K_K9010  L_L52  L_L86  0.0022
K_K9011  L_L52  L_L87  0.0022
K_K9012  L_L52  L_L88  0.0021
K_K9013  L_L52  L_L89  0.0020
K_K9014  L_L52  L_L90  0.0020
K_K9015  L_L52  L_L91  0.0019
K_K9016  L_L52  L_L92  0.0019
K_K9017  L_L52  L_L93  0.0019
K_K9018  L_L52  L_L94  0.0018
K_K9019  L_L52  L_L95  0.0018
K_K9020  L_L52  L_L96  0.0017
K_K9021  L_L52  L_L97  0.0017
K_K9022  L_L52  L_L98  0.0017
K_K9023  L_L52  L_L99  0.0016
K_K9024  L_L52  L_L100  0.0016
K_K9025  L_L52  L_L101  0.0015
K_K9026  L_L52  L_L102  0.0015
K_K9027  L_L52  L_L103  0.0015
K_K9028  L_L52  L_L104  0.0015
K_K9029  L_L52  L_L105  0.0014
K_K9030  L_L52  L_L106  0.0014
K_K9031  L_L52  L_L107  0.0014
K_K9032  L_L52  L_L108  0.0014
K_K9033  L_L52  L_L109  0.0013
K_K9034  L_L52  L_L110  0.0013
K_K9035  L_L52  L_L111  0.0013
K_K9036  L_L52  L_L112  0.0013
K_K9037  L_L52  L_L113  0.0013
K_K9038  L_L52  L_L114  0.0012
K_K9039  L_L52  L_L115  0.0012
K_K9040  L_L52  L_L116  0.0012
K_K9041  L_L52  L_L117  0.0012
K_K9042  L_L52  L_L118  0.0011
K_K9043  L_L52  L_L119  0.0011
K_K9044  L_L52  L_L120  0.0011
K_K9045  L_L52  L_L121  0.0011
K_K9046  L_L52  L_L122  0.0011
K_K9047  L_L52  L_L123  0.0011
K_K9048  L_L52  L_L124  0.0011
K_K9049  L_L52  L_L125  0.0010
K_K9050  L_L52  L_L126  0.0010
K_K9051  L_L52  L_L127  0.0010
K_K9052  L_L52  L_L139  0.0015
K_K9053  L_L52  L_L140  0.0015
K_K9054  L_L52  L_L141  0.0015
K_K9055  L_L52  L_L142  0.0016
K_K9056  L_L52  L_L143  0.0016
K_K9057  L_L52  L_L144  0.0016
K_K9058  L_L52  L_L145  0.0017
K_K9059  L_L52  L_L146  0.0017
K_K9060  L_L52  L_L147  0.0018
K_K9061  L_L52  L_L148  0.0018
K_K9062  L_L52  L_L149  0.0018
K_K9063  L_L52  L_L150  0.0019
K_K9064  L_L52  L_L151  0.0019
K_K9065  L_L52  L_L152  0.0020
K_K9066  L_L52  L_L153  0.0020
K_K9067  L_L52  L_L154  0.0021
K_K9068  L_L52  L_L155  0.0022
K_K9069  L_L52  L_L156  0.0022
K_K9070  L_L52  L_L157  0.0023
K_K9071  L_L52  L_L158  0.0024
K_K9072  L_L52  L_L159  0.0024
K_K9073  L_L52  L_L160  0.0025
K_K9074  L_L52  L_L161  0.0026
K_K9075  L_L52  L_L162  0.0027
K_K9076  L_L52  L_L163  0.0028
K_K9077  L_L52  L_L164  0.0029
K_K9078  L_L52  L_L165  0.0030
K_K9079  L_L52  L_L166  0.0032
K_K9080  L_L52  L_L167  0.0033
K_K9081  L_L52  L_L168  0.0034
K_K9082  L_L52  L_L169  0.0036
K_K9083  L_L52  L_L170  0.0038
K_K9084  L_L52  L_L171  0.0040
K_K9085  L_L52  L_L172  0.0042
K_K9086  L_L52  L_L173  0.0045
K_K9087  L_L52  L_L174  0.0047
K_K9088  L_L52  L_L175  0.0051
K_K9089  L_L52  L_L176  0.0054
K_K9090  L_L52  L_L177  0.0058
K_K9091  L_L52  L_L178  0.0063
K_K9092  L_L52  L_L179  0.0069
K_K9093  L_L52  L_L180  0.0076
K_K9094  L_L52  L_L181  0.0084
K_K9095  L_L52  L_L182  0.0095
K_K9096  L_L52  L_L183  0.0109
K_K9097  L_L52  L_L184  0.0127
K_K9098  L_L52  L_L185  0.0152
K_K9099  L_L52  L_L186  0.0191
K_K9100  L_L52  L_L187  0.0256
K_K9101  L_L52  L_L188  0.0389
K_K9102  L_L52  L_L189  0.0812
K_K9103  L_L52  L_L190  0.1569
K_K9104  L_L52  L_L191  0.0812
K_K9105  L_L52  L_L192  0.0389
K_K9106  L_L52  L_L193  0.0256
K_K9107  L_L52  L_L194  0.0191
K_K9108  L_L52  L_L195  0.0152
K_K9109  L_L52  L_L196  0.0127
K_K9110  L_L52  L_L197  0.0109
K_K9111  L_L52  L_L198  0.0095
K_K9112  L_L52  L_L199  0.0084
K_K9113  L_L52  L_L200  0.0076
K_K9114  L_L52  L_L201  0.0069
K_K9115  L_L52  L_L202  0.0063
K_K9116  L_L52  L_L203  0.0058
K_K9117  L_L52  L_L204  0.0054
K_K9118  L_L52  L_L205  0.0051
K_K9119  L_L52  L_L206  0.0047
K_K9120  L_L52  L_L207  0.0045
K_K9121  L_L52  L_L208  0.0042
K_K9122  L_L52  L_L209  0.0040
K_K9123  L_L52  L_L210  0.0038
K_K9124  L_L52  L_L211  0.0036
K_K9125  L_L52  L_L212  0.0034
K_K9126  L_L52  L_L213  0.0033
K_K9127  L_L52  L_L214  0.0032
K_K9128  L_L52  L_L215  0.0030
K_K9129  L_L52  L_L216  0.0029
K_K9130  L_L52  L_L217  0.0028
K_K9131  L_L52  L_L218  0.0027
K_K9132  L_L52  L_L219  0.0026
K_K9133  L_L52  L_L220  0.0025
K_K9134  L_L52  L_L221  0.0024
K_K9135  L_L52  L_L222  0.0024
K_K9136  L_L52  L_L223  0.0023
K_K9137  L_L52  L_L224  0.0022
K_K9138  L_L52  L_L225  0.0022
K_K9139  L_L52  L_L226  0.0021
K_K9140  L_L52  L_L227  0.0020
K_K9141  L_L52  L_L228  0.0020
K_K9142  L_L52  L_L229  0.0019
K_K9143  L_L52  L_L230  0.0019
K_K9144  L_L52  L_L231  0.0018
K_K9145  L_L52  L_L232  0.0018
K_K9146  L_L52  L_L233  0.0018
K_K9147  L_L52  L_L234  0.0017
K_K9148  L_L52  L_L235  0.0017
K_K9149  L_L52  L_L236  0.0016
K_K9150  L_L52  L_L237  0.0016
K_K9151  L_L52  L_L238  0.0016
K_K9152  L_L52  L_L239  0.0015
K_K9153  L_L52  L_L240  0.0015
K_K9154  L_L52  L_L241  0.0015
K_K9155  L_L52  L_L242  0.0015
K_K9156  L_L52  L_L243  0.0014
K_K9157  L_L52  L_L244  0.0014
K_K9158  L_L52  L_L245  0.0014
K_K9159  L_L52  L_L246  0.0014
K_K9160  L_L52  L_L247  0.0013
K_K9161  L_L52  L_L248  0.0013
K_K9162  L_L52  L_L249  0.0013
K_K9163  L_L52  L_L250  0.0013
K_K9164  L_L52  L_L251  0.0012
K_K9165  L_L52  L_L252  0.0012
K_K9166  L_L52  L_L253  0.0012
K_K9167  L_L52  L_L254  0.0012
K_K9168  L_L52  L_L255  0.0012
K_K9169  L_L52  L_L256  0.0011
K_K9170  L_L52  L_L257  0.0011
K_K9171  L_L52  L_L258  0.0011
K_K9172  L_L52  L_L259  0.0011
K_K9173  L_L52  L_L260  0.0011
K_K9174  L_L52  L_L261  0.0011
K_K9175  L_L52  L_L262  0.0011
K_K9176  L_L52  L_L263  0.0010
K_K9177  L_L52  L_L264  0.0010
K_K9178  L_L52  L_L265  0.0010
* *  Branch  NTMP0000000052 - NTMP0000000053
R_R53  NTMP0000000052  nU_53  32.914993m  TC=0,0
V_Ui53  nU_53  nR_53  STIMULUS=U_IND_0000000053
R_V105  nR_53  nV_105  23.280268m  TC=0,0
L_V105  nR_53  nV_105  0.014646uH
R_V106  nV_105  nV_106  7.852787m  TC=0,0
L_V106  nV_105  nV_106  0.073723uH
L_L53  nV_106  NTMP0000000053  6.519695uH
K_K9179  L_L53  L_L54  0.1050
K_K9180  L_L53  L_L55  0.0397
K_K9181  L_L53  L_L56  0.0258
K_K9182  L_L53  L_L57  0.0192
K_K9183  L_L53  L_L58  0.0153
K_K9184  L_L53  L_L59  0.0127
K_K9185  L_L53  L_L60  0.0109
K_K9186  L_L53  L_L61  0.0095
K_K9187  L_L53  L_L62  0.0084
K_K9188  L_L53  L_L63  0.0076
K_K9189  L_L53  L_L64  0.0069
K_K9190  L_L53  L_L65  0.0063
K_K9191  L_L53  L_L66  0.0058
K_K9192  L_L53  L_L67  0.0054
K_K9193  L_L53  L_L68  0.0051
K_K9194  L_L53  L_L69  0.0047
K_K9195  L_L53  L_L70  0.0045
K_K9196  L_L53  L_L71  0.0042
K_K9197  L_L53  L_L72  0.0040
K_K9198  L_L53  L_L73  0.0038
K_K9199  L_L53  L_L74  0.0036
K_K9200  L_L53  L_L75  0.0034
K_K9201  L_L53  L_L76  0.0033
K_K9202  L_L53  L_L77  0.0032
K_K9203  L_L53  L_L78  0.0030
K_K9204  L_L53  L_L79  0.0029
K_K9205  L_L53  L_L80  0.0028
K_K9206  L_L53  L_L81  0.0027
K_K9207  L_L53  L_L82  0.0026
K_K9208  L_L53  L_L83  0.0025
K_K9209  L_L53  L_L84  0.0024
K_K9210  L_L53  L_L85  0.0024
K_K9211  L_L53  L_L86  0.0023
K_K9212  L_L53  L_L87  0.0022
K_K9213  L_L53  L_L88  0.0022
K_K9214  L_L53  L_L89  0.0021
K_K9215  L_L53  L_L90  0.0020
K_K9216  L_L53  L_L91  0.0020
K_K9217  L_L53  L_L92  0.0019
K_K9218  L_L53  L_L93  0.0019
K_K9219  L_L53  L_L94  0.0019
K_K9220  L_L53  L_L95  0.0018
K_K9221  L_L53  L_L96  0.0018
K_K9222  L_L53  L_L97  0.0017
K_K9223  L_L53  L_L98  0.0017
K_K9224  L_L53  L_L99  0.0017
K_K9225  L_L53  L_L100  0.0016
K_K9226  L_L53  L_L101  0.0016
K_K9227  L_L53  L_L102  0.0015
K_K9228  L_L53  L_L103  0.0015
K_K9229  L_L53  L_L104  0.0015
K_K9230  L_L53  L_L105  0.0015
K_K9231  L_L53  L_L106  0.0014
K_K9232  L_L53  L_L107  0.0014
K_K9233  L_L53  L_L108  0.0014
K_K9234  L_L53  L_L109  0.0014
K_K9235  L_L53  L_L110  0.0013
K_K9236  L_L53  L_L111  0.0013
K_K9237  L_L53  L_L112  0.0013
K_K9238  L_L53  L_L113  0.0013
K_K9239  L_L53  L_L114  0.0013
K_K9240  L_L53  L_L115  0.0012
K_K9241  L_L53  L_L116  0.0012
K_K9242  L_L53  L_L117  0.0012
K_K9243  L_L53  L_L118  0.0012
K_K9244  L_L53  L_L119  0.0011
K_K9245  L_L53  L_L120  0.0011
K_K9246  L_L53  L_L121  0.0011
K_K9247  L_L53  L_L122  0.0011
K_K9248  L_L53  L_L123  0.0011
K_K9249  L_L53  L_L124  0.0011
K_K9250  L_L53  L_L125  0.0011
K_K9251  L_L53  L_L126  0.0010
K_K9252  L_L53  L_L127  0.0010
K_K9253  L_L53  L_L128  0.0010
K_K9254  L_L53  L_L139  0.0015
K_K9255  L_L53  L_L140  0.0015
K_K9256  L_L53  L_L141  0.0015
K_K9257  L_L53  L_L142  0.0015
K_K9258  L_L53  L_L143  0.0016
K_K9259  L_L53  L_L144  0.0016
K_K9260  L_L53  L_L145  0.0016
K_K9261  L_L53  L_L146  0.0017
K_K9262  L_L53  L_L147  0.0017
K_K9263  L_L53  L_L148  0.0018
K_K9264  L_L53  L_L149  0.0018
K_K9265  L_L53  L_L150  0.0018
K_K9266  L_L53  L_L151  0.0019
K_K9267  L_L53  L_L152  0.0019
K_K9268  L_L53  L_L153  0.0020
K_K9269  L_L53  L_L154  0.0020
K_K9270  L_L53  L_L155  0.0021
K_K9271  L_L53  L_L156  0.0022
K_K9272  L_L53  L_L157  0.0022
K_K9273  L_L53  L_L158  0.0023
K_K9274  L_L53  L_L159  0.0024
K_K9275  L_L53  L_L160  0.0024
K_K9276  L_L53  L_L161  0.0025
K_K9277  L_L53  L_L162  0.0026
K_K9278  L_L53  L_L163  0.0027
K_K9279  L_L53  L_L164  0.0028
K_K9280  L_L53  L_L165  0.0029
K_K9281  L_L53  L_L166  0.0030
K_K9282  L_L53  L_L167  0.0032
K_K9283  L_L53  L_L168  0.0033
K_K9284  L_L53  L_L169  0.0034
K_K9285  L_L53  L_L170  0.0036
K_K9286  L_L53  L_L171  0.0038
K_K9287  L_L53  L_L172  0.0040
K_K9288  L_L53  L_L173  0.0042
K_K9289  L_L53  L_L174  0.0045
K_K9290  L_L53  L_L175  0.0047
K_K9291  L_L53  L_L176  0.0051
K_K9292  L_L53  L_L177  0.0054
K_K9293  L_L53  L_L178  0.0058
K_K9294  L_L53  L_L179  0.0063
K_K9295  L_L53  L_L180  0.0069
K_K9296  L_L53  L_L181  0.0076
K_K9297  L_L53  L_L182  0.0084
K_K9298  L_L53  L_L183  0.0095
K_K9299  L_L53  L_L184  0.0109
K_K9300  L_L53  L_L185  0.0127
K_K9301  L_L53  L_L186  0.0152
K_K9302  L_L53  L_L187  0.0191
K_K9303  L_L53  L_L188  0.0256
K_K9304  L_L53  L_L189  0.0389
K_K9305  L_L53  L_L190  0.0812
K_K9306  L_L53  L_L191  0.1569
K_K9307  L_L53  L_L192  0.0812
K_K9308  L_L53  L_L193  0.0389
K_K9309  L_L53  L_L194  0.0256
K_K9310  L_L53  L_L195  0.0191
K_K9311  L_L53  L_L196  0.0152
K_K9312  L_L53  L_L197  0.0127
K_K9313  L_L53  L_L198  0.0109
K_K9314  L_L53  L_L199  0.0095
K_K9315  L_L53  L_L200  0.0084
K_K9316  L_L53  L_L201  0.0076
K_K9317  L_L53  L_L202  0.0069
K_K9318  L_L53  L_L203  0.0063
K_K9319  L_L53  L_L204  0.0058
K_K9320  L_L53  L_L205  0.0054
K_K9321  L_L53  L_L206  0.0051
K_K9322  L_L53  L_L207  0.0047
K_K9323  L_L53  L_L208  0.0045
K_K9324  L_L53  L_L209  0.0042
K_K9325  L_L53  L_L210  0.0040
K_K9326  L_L53  L_L211  0.0038
K_K9327  L_L53  L_L212  0.0036
K_K9328  L_L53  L_L213  0.0034
K_K9329  L_L53  L_L214  0.0033
K_K9330  L_L53  L_L215  0.0032
K_K9331  L_L53  L_L216  0.0030
K_K9332  L_L53  L_L217  0.0029
K_K9333  L_L53  L_L218  0.0028
K_K9334  L_L53  L_L219  0.0027
K_K9335  L_L53  L_L220  0.0026
K_K9336  L_L53  L_L221  0.0025
K_K9337  L_L53  L_L222  0.0024
K_K9338  L_L53  L_L223  0.0024
K_K9339  L_L53  L_L224  0.0023
K_K9340  L_L53  L_L225  0.0022
K_K9341  L_L53  L_L226  0.0022
K_K9342  L_L53  L_L227  0.0021
K_K9343  L_L53  L_L228  0.0020
K_K9344  L_L53  L_L229  0.0020
K_K9345  L_L53  L_L230  0.0019
K_K9346  L_L53  L_L231  0.0019
K_K9347  L_L53  L_L232  0.0018
K_K9348  L_L53  L_L233  0.0018
K_K9349  L_L53  L_L234  0.0018
K_K9350  L_L53  L_L235  0.0017
K_K9351  L_L53  L_L236  0.0017
K_K9352  L_L53  L_L237  0.0016
K_K9353  L_L53  L_L238  0.0016
K_K9354  L_L53  L_L239  0.0016
K_K9355  L_L53  L_L240  0.0015
K_K9356  L_L53  L_L241  0.0015
K_K9357  L_L53  L_L242  0.0015
K_K9358  L_L53  L_L243  0.0015
K_K9359  L_L53  L_L244  0.0014
K_K9360  L_L53  L_L245  0.0014
K_K9361  L_L53  L_L246  0.0014
K_K9362  L_L53  L_L247  0.0014
K_K9363  L_L53  L_L248  0.0013
K_K9364  L_L53  L_L249  0.0013
K_K9365  L_L53  L_L250  0.0013
K_K9366  L_L53  L_L251  0.0013
K_K9367  L_L53  L_L252  0.0012
K_K9368  L_L53  L_L253  0.0012
K_K9369  L_L53  L_L254  0.0012
K_K9370  L_L53  L_L255  0.0012
K_K9371  L_L53  L_L256  0.0012
K_K9372  L_L53  L_L257  0.0011
K_K9373  L_L53  L_L258  0.0011
K_K9374  L_L53  L_L259  0.0011
K_K9375  L_L53  L_L260  0.0011
K_K9376  L_L53  L_L261  0.0011
K_K9377  L_L53  L_L262  0.0011
K_K9378  L_L53  L_L263  0.0011
K_K9379  L_L53  L_L264  0.0010
K_K9380  L_L53  L_L265  0.0010
K_K9381  L_L53  L_L266  0.0010
* *  Branch  NTMP0000000053 - NTMP0000000054
R_R54  NTMP0000000053  nU_54  32.914993m  TC=0,0
V_Ui54  nU_54  nR_54  STIMULUS=U_IND_0000000054
R_V107  nR_54  nV_107  23.280268m  TC=0,0
L_V107  nR_54  nV_107  0.014646uH
R_V108  nV_107  nV_108  7.852787m  TC=0,0
L_V108  nV_107  nV_108  0.073723uH
L_L54  nV_108  NTMP0000000054  6.519695uH
K_K9382  L_L54  L_L55  0.1050
K_K9383  L_L54  L_L56  0.0397
K_K9384  L_L54  L_L57  0.0258
K_K9385  L_L54  L_L58  0.0192
K_K9386  L_L54  L_L59  0.0153
K_K9387  L_L54  L_L60  0.0127
K_K9388  L_L54  L_L61  0.0109
K_K9389  L_L54  L_L62  0.0095
K_K9390  L_L54  L_L63  0.0084
K_K9391  L_L54  L_L64  0.0076
K_K9392  L_L54  L_L65  0.0069
K_K9393  L_L54  L_L66  0.0063
K_K9394  L_L54  L_L67  0.0058
K_K9395  L_L54  L_L68  0.0054
K_K9396  L_L54  L_L69  0.0051
K_K9397  L_L54  L_L70  0.0047
K_K9398  L_L54  L_L71  0.0045
K_K9399  L_L54  L_L72  0.0042
K_K9400  L_L54  L_L73  0.0040
K_K9401  L_L54  L_L74  0.0038
K_K9402  L_L54  L_L75  0.0036
K_K9403  L_L54  L_L76  0.0034
K_K9404  L_L54  L_L77  0.0033
K_K9405  L_L54  L_L78  0.0032
K_K9406  L_L54  L_L79  0.0030
K_K9407  L_L54  L_L80  0.0029
K_K9408  L_L54  L_L81  0.0028
K_K9409  L_L54  L_L82  0.0027
K_K9410  L_L54  L_L83  0.0026
K_K9411  L_L54  L_L84  0.0025
K_K9412  L_L54  L_L85  0.0024
K_K9413  L_L54  L_L86  0.0024
K_K9414  L_L54  L_L87  0.0023
K_K9415  L_L54  L_L88  0.0022
K_K9416  L_L54  L_L89  0.0022
K_K9417  L_L54  L_L90  0.0021
K_K9418  L_L54  L_L91  0.0020
K_K9419  L_L54  L_L92  0.0020
K_K9420  L_L54  L_L93  0.0019
K_K9421  L_L54  L_L94  0.0019
K_K9422  L_L54  L_L95  0.0019
K_K9423  L_L54  L_L96  0.0018
K_K9424  L_L54  L_L97  0.0018
K_K9425  L_L54  L_L98  0.0017
K_K9426  L_L54  L_L99  0.0017
K_K9427  L_L54  L_L100  0.0017
K_K9428  L_L54  L_L101  0.0016
K_K9429  L_L54  L_L102  0.0016
K_K9430  L_L54  L_L103  0.0015
K_K9431  L_L54  L_L104  0.0015
K_K9432  L_L54  L_L105  0.0015
K_K9433  L_L54  L_L106  0.0015
K_K9434  L_L54  L_L107  0.0014
K_K9435  L_L54  L_L108  0.0014
K_K9436  L_L54  L_L109  0.0014
K_K9437  L_L54  L_L110  0.0014
K_K9438  L_L54  L_L111  0.0013
K_K9439  L_L54  L_L112  0.0013
K_K9440  L_L54  L_L113  0.0013
K_K9441  L_L54  L_L114  0.0013
K_K9442  L_L54  L_L115  0.0013
K_K9443  L_L54  L_L116  0.0012
K_K9444  L_L54  L_L117  0.0012
K_K9445  L_L54  L_L118  0.0012
K_K9446  L_L54  L_L119  0.0012
K_K9447  L_L54  L_L120  0.0011
K_K9448  L_L54  L_L121  0.0011
K_K9449  L_L54  L_L122  0.0011
K_K9450  L_L54  L_L123  0.0011
K_K9451  L_L54  L_L124  0.0011
K_K9452  L_L54  L_L125  0.0011
K_K9453  L_L54  L_L126  0.0011
K_K9454  L_L54  L_L127  0.0010
K_K9455  L_L54  L_L128  0.0010
K_K9456  L_L54  L_L129  0.0010
K_K9457  L_L54  L_L139  0.0014
K_K9458  L_L54  L_L140  0.0015
K_K9459  L_L54  L_L141  0.0015
K_K9460  L_L54  L_L142  0.0015
K_K9461  L_L54  L_L143  0.0015
K_K9462  L_L54  L_L144  0.0016
K_K9463  L_L54  L_L145  0.0016
K_K9464  L_L54  L_L146  0.0016
K_K9465  L_L54  L_L147  0.0017
K_K9466  L_L54  L_L148  0.0017
K_K9467  L_L54  L_L149  0.0018
K_K9468  L_L54  L_L150  0.0018
K_K9469  L_L54  L_L151  0.0018
K_K9470  L_L54  L_L152  0.0019
K_K9471  L_L54  L_L153  0.0019
K_K9472  L_L54  L_L154  0.0020
K_K9473  L_L54  L_L155  0.0020
K_K9474  L_L54  L_L156  0.0021
K_K9475  L_L54  L_L157  0.0022
K_K9476  L_L54  L_L158  0.0022
K_K9477  L_L54  L_L159  0.0023
K_K9478  L_L54  L_L160  0.0024
K_K9479  L_L54  L_L161  0.0024
K_K9480  L_L54  L_L162  0.0025
K_K9481  L_L54  L_L163  0.0026
K_K9482  L_L54  L_L164  0.0027
K_K9483  L_L54  L_L165  0.0028
K_K9484  L_L54  L_L166  0.0029
K_K9485  L_L54  L_L167  0.0030
K_K9486  L_L54  L_L168  0.0032
K_K9487  L_L54  L_L169  0.0033
K_K9488  L_L54  L_L170  0.0034
K_K9489  L_L54  L_L171  0.0036
K_K9490  L_L54  L_L172  0.0038
K_K9491  L_L54  L_L173  0.0040
K_K9492  L_L54  L_L174  0.0042
K_K9493  L_L54  L_L175  0.0045
K_K9494  L_L54  L_L176  0.0047
K_K9495  L_L54  L_L177  0.0051
K_K9496  L_L54  L_L178  0.0054
K_K9497  L_L54  L_L179  0.0058
K_K9498  L_L54  L_L180  0.0063
K_K9499  L_L54  L_L181  0.0069
K_K9500  L_L54  L_L182  0.0076
K_K9501  L_L54  L_L183  0.0084
K_K9502  L_L54  L_L184  0.0095
K_K9503  L_L54  L_L185  0.0109
K_K9504  L_L54  L_L186  0.0127
K_K9505  L_L54  L_L187  0.0152
K_K9506  L_L54  L_L188  0.0191
K_K9507  L_L54  L_L189  0.0256
K_K9508  L_L54  L_L190  0.0389
K_K9509  L_L54  L_L191  0.0812
K_K9510  L_L54  L_L192  0.1569
K_K9511  L_L54  L_L193  0.0812
K_K9512  L_L54  L_L194  0.0389
K_K9513  L_L54  L_L195  0.0256
K_K9514  L_L54  L_L196  0.0191
K_K9515  L_L54  L_L197  0.0152
K_K9516  L_L54  L_L198  0.0127
K_K9517  L_L54  L_L199  0.0109
K_K9518  L_L54  L_L200  0.0095
K_K9519  L_L54  L_L201  0.0084
K_K9520  L_L54  L_L202  0.0076
K_K9521  L_L54  L_L203  0.0069
K_K9522  L_L54  L_L204  0.0063
K_K9523  L_L54  L_L205  0.0058
K_K9524  L_L54  L_L206  0.0054
K_K9525  L_L54  L_L207  0.0051
K_K9526  L_L54  L_L208  0.0047
K_K9527  L_L54  L_L209  0.0045
K_K9528  L_L54  L_L210  0.0042
K_K9529  L_L54  L_L211  0.0040
K_K9530  L_L54  L_L212  0.0038
K_K9531  L_L54  L_L213  0.0036
K_K9532  L_L54  L_L214  0.0034
K_K9533  L_L54  L_L215  0.0033
K_K9534  L_L54  L_L216  0.0032
K_K9535  L_L54  L_L217  0.0030
K_K9536  L_L54  L_L218  0.0029
K_K9537  L_L54  L_L219  0.0028
K_K9538  L_L54  L_L220  0.0027
K_K9539  L_L54  L_L221  0.0026
K_K9540  L_L54  L_L222  0.0025
K_K9541  L_L54  L_L223  0.0024
K_K9542  L_L54  L_L224  0.0024
K_K9543  L_L54  L_L225  0.0023
K_K9544  L_L54  L_L226  0.0022
K_K9545  L_L54  L_L227  0.0022
K_K9546  L_L54  L_L228  0.0021
K_K9547  L_L54  L_L229  0.0020
K_K9548  L_L54  L_L230  0.0020
K_K9549  L_L54  L_L231  0.0019
K_K9550  L_L54  L_L232  0.0019
K_K9551  L_L54  L_L233  0.0018
K_K9552  L_L54  L_L234  0.0018
K_K9553  L_L54  L_L235  0.0018
K_K9554  L_L54  L_L236  0.0017
K_K9555  L_L54  L_L237  0.0017
K_K9556  L_L54  L_L238  0.0016
K_K9557  L_L54  L_L239  0.0016
K_K9558  L_L54  L_L240  0.0016
K_K9559  L_L54  L_L241  0.0015
K_K9560  L_L54  L_L242  0.0015
K_K9561  L_L54  L_L243  0.0015
K_K9562  L_L54  L_L244  0.0015
K_K9563  L_L54  L_L245  0.0014
K_K9564  L_L54  L_L246  0.0014
K_K9565  L_L54  L_L247  0.0014
K_K9566  L_L54  L_L248  0.0014
K_K9567  L_L54  L_L249  0.0013
K_K9568  L_L54  L_L250  0.0013
K_K9569  L_L54  L_L251  0.0013
K_K9570  L_L54  L_L252  0.0013
K_K9571  L_L54  L_L253  0.0012
K_K9572  L_L54  L_L254  0.0012
K_K9573  L_L54  L_L255  0.0012
K_K9574  L_L54  L_L256  0.0012
K_K9575  L_L54  L_L257  0.0012
K_K9576  L_L54  L_L258  0.0011
K_K9577  L_L54  L_L259  0.0011
K_K9578  L_L54  L_L260  0.0011
K_K9579  L_L54  L_L261  0.0011
K_K9580  L_L54  L_L262  0.0011
K_K9581  L_L54  L_L263  0.0011
K_K9582  L_L54  L_L264  0.0011
K_K9583  L_L54  L_L265  0.0010
K_K9584  L_L54  L_L266  0.0010
K_K9585  L_L54  L_L267  0.0010
* *  Branch  NTMP0000000054 - NTMP0000000055
R_R55  NTMP0000000054  nU_55  32.914993m  TC=0,0
V_Ui55  nU_55  nR_55  STIMULUS=U_IND_0000000055
R_V109  nR_55  nV_109  23.280268m  TC=0,0
L_V109  nR_55  nV_109  0.014646uH
R_V110  nV_109  nV_110  7.852787m  TC=0,0
L_V110  nV_109  nV_110  0.073723uH
L_L55  nV_110  NTMP0000000055  6.519695uH
K_K9586  L_L55  L_L56  0.1050
K_K9587  L_L55  L_L57  0.0397
K_K9588  L_L55  L_L58  0.0258
K_K9589  L_L55  L_L59  0.0192
K_K9590  L_L55  L_L60  0.0153
K_K9591  L_L55  L_L61  0.0127
K_K9592  L_L55  L_L62  0.0109
K_K9593  L_L55  L_L63  0.0095
K_K9594  L_L55  L_L64  0.0084
K_K9595  L_L55  L_L65  0.0076
K_K9596  L_L55  L_L66  0.0069
K_K9597  L_L55  L_L67  0.0063
K_K9598  L_L55  L_L68  0.0058
K_K9599  L_L55  L_L69  0.0054
K_K9600  L_L55  L_L70  0.0051
K_K9601  L_L55  L_L71  0.0047
K_K9602  L_L55  L_L72  0.0045
K_K9603  L_L55  L_L73  0.0042
K_K9604  L_L55  L_L74  0.0040
K_K9605  L_L55  L_L75  0.0038
K_K9606  L_L55  L_L76  0.0036
K_K9607  L_L55  L_L77  0.0034
K_K9608  L_L55  L_L78  0.0033
K_K9609  L_L55  L_L79  0.0032
K_K9610  L_L55  L_L80  0.0030
K_K9611  L_L55  L_L81  0.0029
K_K9612  L_L55  L_L82  0.0028
K_K9613  L_L55  L_L83  0.0027
K_K9614  L_L55  L_L84  0.0026
K_K9615  L_L55  L_L85  0.0025
K_K9616  L_L55  L_L86  0.0024
K_K9617  L_L55  L_L87  0.0024
K_K9618  L_L55  L_L88  0.0023
K_K9619  L_L55  L_L89  0.0022
K_K9620  L_L55  L_L90  0.0022
K_K9621  L_L55  L_L91  0.0021
K_K9622  L_L55  L_L92  0.0020
K_K9623  L_L55  L_L93  0.0020
K_K9624  L_L55  L_L94  0.0019
K_K9625  L_L55  L_L95  0.0019
K_K9626  L_L55  L_L96  0.0019
K_K9627  L_L55  L_L97  0.0018
K_K9628  L_L55  L_L98  0.0018
K_K9629  L_L55  L_L99  0.0017
K_K9630  L_L55  L_L100  0.0017
K_K9631  L_L55  L_L101  0.0017
K_K9632  L_L55  L_L102  0.0016
K_K9633  L_L55  L_L103  0.0016
K_K9634  L_L55  L_L104  0.0015
K_K9635  L_L55  L_L105  0.0015
K_K9636  L_L55  L_L106  0.0015
K_K9637  L_L55  L_L107  0.0015
K_K9638  L_L55  L_L108  0.0014
K_K9639  L_L55  L_L109  0.0014
K_K9640  L_L55  L_L110  0.0014
K_K9641  L_L55  L_L111  0.0014
K_K9642  L_L55  L_L112  0.0013
K_K9643  L_L55  L_L113  0.0013
K_K9644  L_L55  L_L114  0.0013
K_K9645  L_L55  L_L115  0.0013
K_K9646  L_L55  L_L116  0.0013
K_K9647  L_L55  L_L117  0.0012
K_K9648  L_L55  L_L118  0.0012
K_K9649  L_L55  L_L119  0.0012
K_K9650  L_L55  L_L120  0.0012
K_K9651  L_L55  L_L121  0.0011
K_K9652  L_L55  L_L122  0.0011
K_K9653  L_L55  L_L123  0.0011
K_K9654  L_L55  L_L124  0.0011
K_K9655  L_L55  L_L125  0.0011
K_K9656  L_L55  L_L126  0.0011
K_K9657  L_L55  L_L127  0.0011
K_K9658  L_L55  L_L128  0.0010
K_K9659  L_L55  L_L129  0.0010
K_K9660  L_L55  L_L130  0.0010
K_K9661  L_L55  L_L139  0.0014
K_K9662  L_L55  L_L140  0.0014
K_K9663  L_L55  L_L141  0.0015
K_K9664  L_L55  L_L142  0.0015
K_K9665  L_L55  L_L143  0.0015
K_K9666  L_L55  L_L144  0.0015
K_K9667  L_L55  L_L145  0.0016
K_K9668  L_L55  L_L146  0.0016
K_K9669  L_L55  L_L147  0.0016
K_K9670  L_L55  L_L148  0.0017
K_K9671  L_L55  L_L149  0.0017
K_K9672  L_L55  L_L150  0.0018
K_K9673  L_L55  L_L151  0.0018
K_K9674  L_L55  L_L152  0.0018
K_K9675  L_L55  L_L153  0.0019
K_K9676  L_L55  L_L154  0.0019
K_K9677  L_L55  L_L155  0.0020
K_K9678  L_L55  L_L156  0.0020
K_K9679  L_L55  L_L157  0.0021
K_K9680  L_L55  L_L158  0.0022
K_K9681  L_L55  L_L159  0.0022
K_K9682  L_L55  L_L160  0.0023
K_K9683  L_L55  L_L161  0.0024
K_K9684  L_L55  L_L162  0.0024
K_K9685  L_L55  L_L163  0.0025
K_K9686  L_L55  L_L164  0.0026
K_K9687  L_L55  L_L165  0.0027
K_K9688  L_L55  L_L166  0.0028
K_K9689  L_L55  L_L167  0.0029
K_K9690  L_L55  L_L168  0.0030
K_K9691  L_L55  L_L169  0.0032
K_K9692  L_L55  L_L170  0.0033
K_K9693  L_L55  L_L171  0.0034
K_K9694  L_L55  L_L172  0.0036
K_K9695  L_L55  L_L173  0.0038
K_K9696  L_L55  L_L174  0.0040
K_K9697  L_L55  L_L175  0.0042
K_K9698  L_L55  L_L176  0.0045
K_K9699  L_L55  L_L177  0.0047
K_K9700  L_L55  L_L178  0.0051
K_K9701  L_L55  L_L179  0.0054
K_K9702  L_L55  L_L180  0.0058
K_K9703  L_L55  L_L181  0.0063
K_K9704  L_L55  L_L182  0.0069
K_K9705  L_L55  L_L183  0.0076
K_K9706  L_L55  L_L184  0.0084
K_K9707  L_L55  L_L185  0.0095
K_K9708  L_L55  L_L186  0.0109
K_K9709  L_L55  L_L187  0.0127
K_K9710  L_L55  L_L188  0.0152
K_K9711  L_L55  L_L189  0.0191
K_K9712  L_L55  L_L190  0.0256
K_K9713  L_L55  L_L191  0.0389
K_K9714  L_L55  L_L192  0.0812
K_K9715  L_L55  L_L193  0.1569
K_K9716  L_L55  L_L194  0.0812
K_K9717  L_L55  L_L195  0.0389
K_K9718  L_L55  L_L196  0.0256
K_K9719  L_L55  L_L197  0.0191
K_K9720  L_L55  L_L198  0.0152
K_K9721  L_L55  L_L199  0.0127
K_K9722  L_L55  L_L200  0.0109
K_K9723  L_L55  L_L201  0.0095
K_K9724  L_L55  L_L202  0.0084
K_K9725  L_L55  L_L203  0.0076
K_K9726  L_L55  L_L204  0.0069
K_K9727  L_L55  L_L205  0.0063
K_K9728  L_L55  L_L206  0.0058
K_K9729  L_L55  L_L207  0.0054
K_K9730  L_L55  L_L208  0.0051
K_K9731  L_L55  L_L209  0.0047
K_K9732  L_L55  L_L210  0.0045
K_K9733  L_L55  L_L211  0.0042
K_K9734  L_L55  L_L212  0.0040
K_K9735  L_L55  L_L213  0.0038
K_K9736  L_L55  L_L214  0.0036
K_K9737  L_L55  L_L215  0.0034
K_K9738  L_L55  L_L216  0.0033
K_K9739  L_L55  L_L217  0.0032
K_K9740  L_L55  L_L218  0.0030
K_K9741  L_L55  L_L219  0.0029
K_K9742  L_L55  L_L220  0.0028
K_K9743  L_L55  L_L221  0.0027
K_K9744  L_L55  L_L222  0.0026
K_K9745  L_L55  L_L223  0.0025
K_K9746  L_L55  L_L224  0.0024
K_K9747  L_L55  L_L225  0.0024
K_K9748  L_L55  L_L226  0.0023
K_K9749  L_L55  L_L227  0.0022
K_K9750  L_L55  L_L228  0.0022
K_K9751  L_L55  L_L229  0.0021
K_K9752  L_L55  L_L230  0.0020
K_K9753  L_L55  L_L231  0.0020
K_K9754  L_L55  L_L232  0.0019
K_K9755  L_L55  L_L233  0.0019
K_K9756  L_L55  L_L234  0.0018
K_K9757  L_L55  L_L235  0.0018
K_K9758  L_L55  L_L236  0.0018
K_K9759  L_L55  L_L237  0.0017
K_K9760  L_L55  L_L238  0.0017
K_K9761  L_L55  L_L239  0.0016
K_K9762  L_L55  L_L240  0.0016
K_K9763  L_L55  L_L241  0.0016
K_K9764  L_L55  L_L242  0.0015
K_K9765  L_L55  L_L243  0.0015
K_K9766  L_L55  L_L244  0.0015
K_K9767  L_L55  L_L245  0.0015
K_K9768  L_L55  L_L246  0.0014
K_K9769  L_L55  L_L247  0.0014
K_K9770  L_L55  L_L248  0.0014
K_K9771  L_L55  L_L249  0.0014
K_K9772  L_L55  L_L250  0.0013
K_K9773  L_L55  L_L251  0.0013
K_K9774  L_L55  L_L252  0.0013
K_K9775  L_L55  L_L253  0.0013
K_K9776  L_L55  L_L254  0.0012
K_K9777  L_L55  L_L255  0.0012
K_K9778  L_L55  L_L256  0.0012
K_K9779  L_L55  L_L257  0.0012
K_K9780  L_L55  L_L258  0.0012
K_K9781  L_L55  L_L259  0.0011
K_K9782  L_L55  L_L260  0.0011
K_K9783  L_L55  L_L261  0.0011
K_K9784  L_L55  L_L262  0.0011
K_K9785  L_L55  L_L263  0.0011
K_K9786  L_L55  L_L264  0.0011
K_K9787  L_L55  L_L265  0.0011
K_K9788  L_L55  L_L266  0.0010
K_K9789  L_L55  L_L267  0.0010
K_K9790  L_L55  L_L268  0.0010
* *  Branch  NTMP0000000055 - NTMP0000000056
R_R56  NTMP0000000055  nU_56  32.914993m  TC=0,0
V_Ui56  nU_56  nR_56  STIMULUS=U_IND_0000000056
R_V111  nR_56  nV_111  23.280268m  TC=0,0
L_V111  nR_56  nV_111  0.014646uH
R_V112  nV_111  nV_112  7.852787m  TC=0,0
L_V112  nV_111  nV_112  0.073723uH
L_L56  nV_112  NTMP0000000056  6.519695uH
K_K9791  L_L56  L_L57  0.1050
K_K9792  L_L56  L_L58  0.0397
K_K9793  L_L56  L_L59  0.0258
K_K9794  L_L56  L_L60  0.0192
K_K9795  L_L56  L_L61  0.0153
K_K9796  L_L56  L_L62  0.0127
K_K9797  L_L56  L_L63  0.0109
K_K9798  L_L56  L_L64  0.0095
K_K9799  L_L56  L_L65  0.0084
K_K9800  L_L56  L_L66  0.0076
K_K9801  L_L56  L_L67  0.0069
K_K9802  L_L56  L_L68  0.0063
K_K9803  L_L56  L_L69  0.0058
K_K9804  L_L56  L_L70  0.0054
K_K9805  L_L56  L_L71  0.0051
K_K9806  L_L56  L_L72  0.0047
K_K9807  L_L56  L_L73  0.0045
K_K9808  L_L56  L_L74  0.0042
K_K9809  L_L56  L_L75  0.0040
K_K9810  L_L56  L_L76  0.0038
K_K9811  L_L56  L_L77  0.0036
K_K9812  L_L56  L_L78  0.0034
K_K9813  L_L56  L_L79  0.0033
K_K9814  L_L56  L_L80  0.0032
K_K9815  L_L56  L_L81  0.0030
K_K9816  L_L56  L_L82  0.0029
K_K9817  L_L56  L_L83  0.0028
K_K9818  L_L56  L_L84  0.0027
K_K9819  L_L56  L_L85  0.0026
K_K9820  L_L56  L_L86  0.0025
K_K9821  L_L56  L_L87  0.0024
K_K9822  L_L56  L_L88  0.0024
K_K9823  L_L56  L_L89  0.0023
K_K9824  L_L56  L_L90  0.0022
K_K9825  L_L56  L_L91  0.0022
K_K9826  L_L56  L_L92  0.0021
K_K9827  L_L56  L_L93  0.0020
K_K9828  L_L56  L_L94  0.0020
K_K9829  L_L56  L_L95  0.0019
K_K9830  L_L56  L_L96  0.0019
K_K9831  L_L56  L_L97  0.0019
K_K9832  L_L56  L_L98  0.0018
K_K9833  L_L56  L_L99  0.0018
K_K9834  L_L56  L_L100  0.0017
K_K9835  L_L56  L_L101  0.0017
K_K9836  L_L56  L_L102  0.0017
K_K9837  L_L56  L_L103  0.0016
K_K9838  L_L56  L_L104  0.0016
K_K9839  L_L56  L_L105  0.0015
K_K9840  L_L56  L_L106  0.0015
K_K9841  L_L56  L_L107  0.0015
K_K9842  L_L56  L_L108  0.0015
K_K9843  L_L56  L_L109  0.0014
K_K9844  L_L56  L_L110  0.0014
K_K9845  L_L56  L_L111  0.0014
K_K9846  L_L56  L_L112  0.0014
K_K9847  L_L56  L_L113  0.0013
K_K9848  L_L56  L_L114  0.0013
K_K9849  L_L56  L_L115  0.0013
K_K9850  L_L56  L_L116  0.0013
K_K9851  L_L56  L_L117  0.0013
K_K9852  L_L56  L_L118  0.0012
K_K9853  L_L56  L_L119  0.0012
K_K9854  L_L56  L_L120  0.0012
K_K9855  L_L56  L_L121  0.0012
K_K9856  L_L56  L_L122  0.0011
K_K9857  L_L56  L_L123  0.0011
K_K9858  L_L56  L_L124  0.0011
K_K9859  L_L56  L_L125  0.0011
K_K9860  L_L56  L_L126  0.0011
K_K9861  L_L56  L_L127  0.0011
K_K9862  L_L56  L_L128  0.0011
K_K9863  L_L56  L_L129  0.0010
K_K9864  L_L56  L_L130  0.0010
K_K9865  L_L56  L_L131  0.0010
K_K9866  L_L56  L_L139  0.0014
K_K9867  L_L56  L_L140  0.0014
K_K9868  L_L56  L_L141  0.0014
K_K9869  L_L56  L_L142  0.0015
K_K9870  L_L56  L_L143  0.0015
K_K9871  L_L56  L_L144  0.0015
K_K9872  L_L56  L_L145  0.0015
K_K9873  L_L56  L_L146  0.0016
K_K9874  L_L56  L_L147  0.0016
K_K9875  L_L56  L_L148  0.0016
K_K9876  L_L56  L_L149  0.0017
K_K9877  L_L56  L_L150  0.0017
K_K9878  L_L56  L_L151  0.0018
K_K9879  L_L56  L_L152  0.0018
K_K9880  L_L56  L_L153  0.0018
K_K9881  L_L56  L_L154  0.0019
K_K9882  L_L56  L_L155  0.0019
K_K9883  L_L56  L_L156  0.0020
K_K9884  L_L56  L_L157  0.0020
K_K9885  L_L56  L_L158  0.0021
K_K9886  L_L56  L_L159  0.0022
K_K9887  L_L56  L_L160  0.0022
K_K9888  L_L56  L_L161  0.0023
K_K9889  L_L56  L_L162  0.0024
K_K9890  L_L56  L_L163  0.0024
K_K9891  L_L56  L_L164  0.0025
K_K9892  L_L56  L_L165  0.0026
K_K9893  L_L56  L_L166  0.0027
K_K9894  L_L56  L_L167  0.0028
K_K9895  L_L56  L_L168  0.0029
K_K9896  L_L56  L_L169  0.0030
K_K9897  L_L56  L_L170  0.0032
K_K9898  L_L56  L_L171  0.0033
K_K9899  L_L56  L_L172  0.0034
K_K9900  L_L56  L_L173  0.0036
K_K9901  L_L56  L_L174  0.0038
K_K9902  L_L56  L_L175  0.0040
K_K9903  L_L56  L_L176  0.0042
K_K9904  L_L56  L_L177  0.0045
K_K9905  L_L56  L_L178  0.0047
K_K9906  L_L56  L_L179  0.0051
K_K9907  L_L56  L_L180  0.0054
K_K9908  L_L56  L_L181  0.0058
K_K9909  L_L56  L_L182  0.0063
K_K9910  L_L56  L_L183  0.0069
K_K9911  L_L56  L_L184  0.0076
K_K9912  L_L56  L_L185  0.0084
K_K9913  L_L56  L_L186  0.0095
K_K9914  L_L56  L_L187  0.0109
K_K9915  L_L56  L_L188  0.0127
K_K9916  L_L56  L_L189  0.0152
K_K9917  L_L56  L_L190  0.0191
K_K9918  L_L56  L_L191  0.0256
K_K9919  L_L56  L_L192  0.0389
K_K9920  L_L56  L_L193  0.0812
K_K9921  L_L56  L_L194  0.1569
K_K9922  L_L56  L_L195  0.0812
K_K9923  L_L56  L_L196  0.0389
K_K9924  L_L56  L_L197  0.0256
K_K9925  L_L56  L_L198  0.0191
K_K9926  L_L56  L_L199  0.0152
K_K9927  L_L56  L_L200  0.0127
K_K9928  L_L56  L_L201  0.0109
K_K9929  L_L56  L_L202  0.0095
K_K9930  L_L56  L_L203  0.0084
K_K9931  L_L56  L_L204  0.0076
K_K9932  L_L56  L_L205  0.0069
K_K9933  L_L56  L_L206  0.0063
K_K9934  L_L56  L_L207  0.0058
K_K9935  L_L56  L_L208  0.0054
K_K9936  L_L56  L_L209  0.0051
K_K9937  L_L56  L_L210  0.0047
K_K9938  L_L56  L_L211  0.0045
K_K9939  L_L56  L_L212  0.0042
K_K9940  L_L56  L_L213  0.0040
K_K9941  L_L56  L_L214  0.0038
K_K9942  L_L56  L_L215  0.0036
K_K9943  L_L56  L_L216  0.0034
K_K9944  L_L56  L_L217  0.0033
K_K9945  L_L56  L_L218  0.0032
K_K9946  L_L56  L_L219  0.0030
K_K9947  L_L56  L_L220  0.0029
K_K9948  L_L56  L_L221  0.0028
K_K9949  L_L56  L_L222  0.0027
K_K9950  L_L56  L_L223  0.0026
K_K9951  L_L56  L_L224  0.0025
K_K9952  L_L56  L_L225  0.0024
K_K9953  L_L56  L_L226  0.0024
K_K9954  L_L56  L_L227  0.0023
K_K9955  L_L56  L_L228  0.0022
K_K9956  L_L56  L_L229  0.0022
K_K9957  L_L56  L_L230  0.0021
K_K9958  L_L56  L_L231  0.0020
K_K9959  L_L56  L_L232  0.0020
K_K9960  L_L56  L_L233  0.0019
K_K9961  L_L56  L_L234  0.0019
K_K9962  L_L56  L_L235  0.0018
K_K9963  L_L56  L_L236  0.0018
K_K9964  L_L56  L_L237  0.0018
K_K9965  L_L56  L_L238  0.0017
K_K9966  L_L56  L_L239  0.0017
K_K9967  L_L56  L_L240  0.0016
K_K9968  L_L56  L_L241  0.0016
K_K9969  L_L56  L_L242  0.0016
K_K9970  L_L56  L_L243  0.0015
K_K9971  L_L56  L_L244  0.0015
K_K9972  L_L56  L_L245  0.0015
K_K9973  L_L56  L_L246  0.0015
K_K9974  L_L56  L_L247  0.0014
K_K9975  L_L56  L_L248  0.0014
K_K9976  L_L56  L_L249  0.0014
K_K9977  L_L56  L_L250  0.0014
K_K9978  L_L56  L_L251  0.0013
K_K9979  L_L56  L_L252  0.0013
K_K9980  L_L56  L_L253  0.0013
K_K9981  L_L56  L_L254  0.0013
K_K9982  L_L56  L_L255  0.0012
K_K9983  L_L56  L_L256  0.0012
K_K9984  L_L56  L_L257  0.0012
K_K9985  L_L56  L_L258  0.0012
K_K9986  L_L56  L_L259  0.0012
K_K9987  L_L56  L_L260  0.0011
K_K9988  L_L56  L_L261  0.0011
K_K9989  L_L56  L_L262  0.0011
K_K9990  L_L56  L_L263  0.0011
K_K9991  L_L56  L_L264  0.0011
K_K9992  L_L56  L_L265  0.0011
K_K9993  L_L56  L_L266  0.0011
K_K9994  L_L56  L_L267  0.0010
K_K9995  L_L56  L_L268  0.0010
K_K9996  L_L56  L_L269  0.0010
* *  Branch  NTMP0000000056 - NTMP0000000057
R_R57  NTMP0000000056  nU_57  32.914993m  TC=0,0
V_Ui57  nU_57  nR_57  STIMULUS=U_IND_0000000057
R_V113  nR_57  nV_113  23.280268m  TC=0,0
L_V113  nR_57  nV_113  0.014646uH
R_V114  nV_113  nV_114  7.852787m  TC=0,0
L_V114  nV_113  nV_114  0.073723uH
L_L57  nV_114  NTMP0000000057  6.519695uH
K_K9997  L_L57  L_L58  0.1050
K_K9998  L_L57  L_L59  0.0397
K_K9999  L_L57  L_L60  0.0258
K_K10000  L_L57  L_L61  0.0192
K_K10001  L_L57  L_L62  0.0153
K_K10002  L_L57  L_L63  0.0127
K_K10003  L_L57  L_L64  0.0109
K_K10004  L_L57  L_L65  0.0095
K_K10005  L_L57  L_L66  0.0084
K_K10006  L_L57  L_L67  0.0076
K_K10007  L_L57  L_L68  0.0069
K_K10008  L_L57  L_L69  0.0063
K_K10009  L_L57  L_L70  0.0058
K_K10010  L_L57  L_L71  0.0054
K_K10011  L_L57  L_L72  0.0051
K_K10012  L_L57  L_L73  0.0047
K_K10013  L_L57  L_L74  0.0045
K_K10014  L_L57  L_L75  0.0042
K_K10015  L_L57  L_L76  0.0040
K_K10016  L_L57  L_L77  0.0038
K_K10017  L_L57  L_L78  0.0036
K_K10018  L_L57  L_L79  0.0034
K_K10019  L_L57  L_L80  0.0033
K_K10020  L_L57  L_L81  0.0032
K_K10021  L_L57  L_L82  0.0030
K_K10022  L_L57  L_L83  0.0029
K_K10023  L_L57  L_L84  0.0028
K_K10024  L_L57  L_L85  0.0027
K_K10025  L_L57  L_L86  0.0026
K_K10026  L_L57  L_L87  0.0025
K_K10027  L_L57  L_L88  0.0024
K_K10028  L_L57  L_L89  0.0024
K_K10029  L_L57  L_L90  0.0023
K_K10030  L_L57  L_L91  0.0022
K_K10031  L_L57  L_L92  0.0022
K_K10032  L_L57  L_L93  0.0021
K_K10033  L_L57  L_L94  0.0020
K_K10034  L_L57  L_L95  0.0020
K_K10035  L_L57  L_L96  0.0019
K_K10036  L_L57  L_L97  0.0019
K_K10037  L_L57  L_L98  0.0019
K_K10038  L_L57  L_L99  0.0018
K_K10039  L_L57  L_L100  0.0018
K_K10040  L_L57  L_L101  0.0017
K_K10041  L_L57  L_L102  0.0017
K_K10042  L_L57  L_L103  0.0017
K_K10043  L_L57  L_L104  0.0016
K_K10044  L_L57  L_L105  0.0016
K_K10045  L_L57  L_L106  0.0015
K_K10046  L_L57  L_L107  0.0015
K_K10047  L_L57  L_L108  0.0015
K_K10048  L_L57  L_L109  0.0015
K_K10049  L_L57  L_L110  0.0014
K_K10050  L_L57  L_L111  0.0014
K_K10051  L_L57  L_L112  0.0014
K_K10052  L_L57  L_L113  0.0014
K_K10053  L_L57  L_L114  0.0013
K_K10054  L_L57  L_L115  0.0013
K_K10055  L_L57  L_L116  0.0013
K_K10056  L_L57  L_L117  0.0013
K_K10057  L_L57  L_L118  0.0013
K_K10058  L_L57  L_L119  0.0012
K_K10059  L_L57  L_L120  0.0012
K_K10060  L_L57  L_L121  0.0012
K_K10061  L_L57  L_L122  0.0012
K_K10062  L_L57  L_L123  0.0011
K_K10063  L_L57  L_L124  0.0011
K_K10064  L_L57  L_L125  0.0011
K_K10065  L_L57  L_L126  0.0011
K_K10066  L_L57  L_L127  0.0011
K_K10067  L_L57  L_L128  0.0011
K_K10068  L_L57  L_L129  0.0011
K_K10069  L_L57  L_L130  0.0010
K_K10070  L_L57  L_L131  0.0010
K_K10071  L_L57  L_L132  0.0010
K_K10072  L_L57  L_L139  0.0014
K_K10073  L_L57  L_L140  0.0014
K_K10074  L_L57  L_L141  0.0014
K_K10075  L_L57  L_L142  0.0014
K_K10076  L_L57  L_L143  0.0015
K_K10077  L_L57  L_L144  0.0015
K_K10078  L_L57  L_L145  0.0015
K_K10079  L_L57  L_L146  0.0015
K_K10080  L_L57  L_L147  0.0016
K_K10081  L_L57  L_L148  0.0016
K_K10082  L_L57  L_L149  0.0016
K_K10083  L_L57  L_L150  0.0017
K_K10084  L_L57  L_L151  0.0017
K_K10085  L_L57  L_L152  0.0018
K_K10086  L_L57  L_L153  0.0018
K_K10087  L_L57  L_L154  0.0018
K_K10088  L_L57  L_L155  0.0019
K_K10089  L_L57  L_L156  0.0019
K_K10090  L_L57  L_L157  0.0020
K_K10091  L_L57  L_L158  0.0020
K_K10092  L_L57  L_L159  0.0021
K_K10093  L_L57  L_L160  0.0022
K_K10094  L_L57  L_L161  0.0022
K_K10095  L_L57  L_L162  0.0023
K_K10096  L_L57  L_L163  0.0024
K_K10097  L_L57  L_L164  0.0024
K_K10098  L_L57  L_L165  0.0025
K_K10099  L_L57  L_L166  0.0026
K_K10100  L_L57  L_L167  0.0027
K_K10101  L_L57  L_L168  0.0028
K_K10102  L_L57  L_L169  0.0029
K_K10103  L_L57  L_L170  0.0030
K_K10104  L_L57  L_L171  0.0032
K_K10105  L_L57  L_L172  0.0033
K_K10106  L_L57  L_L173  0.0034
K_K10107  L_L57  L_L174  0.0036
K_K10108  L_L57  L_L175  0.0038
K_K10109  L_L57  L_L176  0.0040
K_K10110  L_L57  L_L177  0.0042
K_K10111  L_L57  L_L178  0.0045
K_K10112  L_L57  L_L179  0.0047
K_K10113  L_L57  L_L180  0.0051
K_K10114  L_L57  L_L181  0.0054
K_K10115  L_L57  L_L182  0.0058
K_K10116  L_L57  L_L183  0.0063
K_K10117  L_L57  L_L184  0.0069
K_K10118  L_L57  L_L185  0.0076
K_K10119  L_L57  L_L186  0.0084
K_K10120  L_L57  L_L187  0.0095
K_K10121  L_L57  L_L188  0.0109
K_K10122  L_L57  L_L189  0.0127
K_K10123  L_L57  L_L190  0.0152
K_K10124  L_L57  L_L191  0.0191
K_K10125  L_L57  L_L192  0.0256
K_K10126  L_L57  L_L193  0.0389
K_K10127  L_L57  L_L194  0.0812
K_K10128  L_L57  L_L195  0.1569
K_K10129  L_L57  L_L196  0.0812
K_K10130  L_L57  L_L197  0.0389
K_K10131  L_L57  L_L198  0.0256
K_K10132  L_L57  L_L199  0.0191
K_K10133  L_L57  L_L200  0.0152
K_K10134  L_L57  L_L201  0.0127
K_K10135  L_L57  L_L202  0.0109
K_K10136  L_L57  L_L203  0.0095
K_K10137  L_L57  L_L204  0.0084
K_K10138  L_L57  L_L205  0.0076
K_K10139  L_L57  L_L206  0.0069
K_K10140  L_L57  L_L207  0.0063
K_K10141  L_L57  L_L208  0.0058
K_K10142  L_L57  L_L209  0.0054
K_K10143  L_L57  L_L210  0.0051
K_K10144  L_L57  L_L211  0.0047
K_K10145  L_L57  L_L212  0.0045
K_K10146  L_L57  L_L213  0.0042
K_K10147  L_L57  L_L214  0.0040
K_K10148  L_L57  L_L215  0.0038
K_K10149  L_L57  L_L216  0.0036
K_K10150  L_L57  L_L217  0.0034
K_K10151  L_L57  L_L218  0.0033
K_K10152  L_L57  L_L219  0.0032
K_K10153  L_L57  L_L220  0.0030
K_K10154  L_L57  L_L221  0.0029
K_K10155  L_L57  L_L222  0.0028
K_K10156  L_L57  L_L223  0.0027
K_K10157  L_L57  L_L224  0.0026
K_K10158  L_L57  L_L225  0.0025
K_K10159  L_L57  L_L226  0.0024
K_K10160  L_L57  L_L227  0.0024
K_K10161  L_L57  L_L228  0.0023
K_K10162  L_L57  L_L229  0.0022
K_K10163  L_L57  L_L230  0.0022
K_K10164  L_L57  L_L231  0.0021
K_K10165  L_L57  L_L232  0.0020
K_K10166  L_L57  L_L233  0.0020
K_K10167  L_L57  L_L234  0.0019
K_K10168  L_L57  L_L235  0.0019
K_K10169  L_L57  L_L236  0.0018
K_K10170  L_L57  L_L237  0.0018
K_K10171  L_L57  L_L238  0.0018
K_K10172  L_L57  L_L239  0.0017
K_K10173  L_L57  L_L240  0.0017
K_K10174  L_L57  L_L241  0.0016
K_K10175  L_L57  L_L242  0.0016
K_K10176  L_L57  L_L243  0.0016
K_K10177  L_L57  L_L244  0.0015
K_K10178  L_L57  L_L245  0.0015
K_K10179  L_L57  L_L246  0.0015
K_K10180  L_L57  L_L247  0.0015
K_K10181  L_L57  L_L248  0.0014
K_K10182  L_L57  L_L249  0.0014
K_K10183  L_L57  L_L250  0.0014
K_K10184  L_L57  L_L251  0.0014
K_K10185  L_L57  L_L252  0.0013
K_K10186  L_L57  L_L253  0.0013
K_K10187  L_L57  L_L254  0.0013
K_K10188  L_L57  L_L255  0.0013
K_K10189  L_L57  L_L256  0.0012
K_K10190  L_L57  L_L257  0.0012
K_K10191  L_L57  L_L258  0.0012
K_K10192  L_L57  L_L259  0.0012
K_K10193  L_L57  L_L260  0.0012
K_K10194  L_L57  L_L261  0.0011
K_K10195  L_L57  L_L262  0.0011
K_K10196  L_L57  L_L263  0.0011
K_K10197  L_L57  L_L264  0.0011
K_K10198  L_L57  L_L265  0.0011
K_K10199  L_L57  L_L266  0.0011
K_K10200  L_L57  L_L267  0.0011
K_K10201  L_L57  L_L268  0.0010
K_K10202  L_L57  L_L269  0.0010
K_K10203  L_L57  L_L270  0.0010
* *  Branch  NTMP0000000057 - NTMP0000000058
R_R58  NTMP0000000057  nU_58  32.914993m  TC=0,0
V_Ui58  nU_58  nR_58  STIMULUS=U_IND_0000000058
R_V115  nR_58  nV_115  23.280268m  TC=0,0
L_V115  nR_58  nV_115  0.014646uH
R_V116  nV_115  nV_116  7.852787m  TC=0,0
L_V116  nV_115  nV_116  0.073723uH
L_L58  nV_116  NTMP0000000058  6.519695uH
K_K10204  L_L58  L_L59  0.1050
K_K10205  L_L58  L_L60  0.0397
K_K10206  L_L58  L_L61  0.0258
K_K10207  L_L58  L_L62  0.0192
K_K10208  L_L58  L_L63  0.0153
K_K10209  L_L58  L_L64  0.0127
K_K10210  L_L58  L_L65  0.0109
K_K10211  L_L58  L_L66  0.0095
K_K10212  L_L58  L_L67  0.0084
K_K10213  L_L58  L_L68  0.0076
K_K10214  L_L58  L_L69  0.0069
K_K10215  L_L58  L_L70  0.0063
K_K10216  L_L58  L_L71  0.0058
K_K10217  L_L58  L_L72  0.0054
K_K10218  L_L58  L_L73  0.0051
K_K10219  L_L58  L_L74  0.0047
K_K10220  L_L58  L_L75  0.0045
K_K10221  L_L58  L_L76  0.0042
K_K10222  L_L58  L_L77  0.0040
K_K10223  L_L58  L_L78  0.0038
K_K10224  L_L58  L_L79  0.0036
K_K10225  L_L58  L_L80  0.0034
K_K10226  L_L58  L_L81  0.0033
K_K10227  L_L58  L_L82  0.0032
K_K10228  L_L58  L_L83  0.0030
K_K10229  L_L58  L_L84  0.0029
K_K10230  L_L58  L_L85  0.0028
K_K10231  L_L58  L_L86  0.0027
K_K10232  L_L58  L_L87  0.0026
K_K10233  L_L58  L_L88  0.0025
K_K10234  L_L58  L_L89  0.0024
K_K10235  L_L58  L_L90  0.0024
K_K10236  L_L58  L_L91  0.0023
K_K10237  L_L58  L_L92  0.0022
K_K10238  L_L58  L_L93  0.0022
K_K10239  L_L58  L_L94  0.0021
K_K10240  L_L58  L_L95  0.0020
K_K10241  L_L58  L_L96  0.0020
K_K10242  L_L58  L_L97  0.0019
K_K10243  L_L58  L_L98  0.0019
K_K10244  L_L58  L_L99  0.0019
K_K10245  L_L58  L_L100  0.0018
K_K10246  L_L58  L_L101  0.0018
K_K10247  L_L58  L_L102  0.0017
K_K10248  L_L58  L_L103  0.0017
K_K10249  L_L58  L_L104  0.0017
K_K10250  L_L58  L_L105  0.0016
K_K10251  L_L58  L_L106  0.0016
K_K10252  L_L58  L_L107  0.0015
K_K10253  L_L58  L_L108  0.0015
K_K10254  L_L58  L_L109  0.0015
K_K10255  L_L58  L_L110  0.0015
K_K10256  L_L58  L_L111  0.0014
K_K10257  L_L58  L_L112  0.0014
K_K10258  L_L58  L_L113  0.0014
K_K10259  L_L58  L_L114  0.0014
K_K10260  L_L58  L_L115  0.0013
K_K10261  L_L58  L_L116  0.0013
K_K10262  L_L58  L_L117  0.0013
K_K10263  L_L58  L_L118  0.0013
K_K10264  L_L58  L_L119  0.0013
K_K10265  L_L58  L_L120  0.0012
K_K10266  L_L58  L_L121  0.0012
K_K10267  L_L58  L_L122  0.0012
K_K10268  L_L58  L_L123  0.0012
K_K10269  L_L58  L_L124  0.0011
K_K10270  L_L58  L_L125  0.0011
K_K10271  L_L58  L_L126  0.0011
K_K10272  L_L58  L_L127  0.0011
K_K10273  L_L58  L_L128  0.0011
K_K10274  L_L58  L_L129  0.0011
K_K10275  L_L58  L_L130  0.0011
K_K10276  L_L58  L_L131  0.0010
K_K10277  L_L58  L_L132  0.0010
K_K10278  L_L58  L_L133  0.0010
K_K10279  L_L58  L_L139  0.0013
K_K10280  L_L58  L_L140  0.0014
K_K10281  L_L58  L_L141  0.0014
K_K10282  L_L58  L_L142  0.0014
K_K10283  L_L58  L_L143  0.0014
K_K10284  L_L58  L_L144  0.0015
K_K10285  L_L58  L_L145  0.0015
K_K10286  L_L58  L_L146  0.0015
K_K10287  L_L58  L_L147  0.0015
K_K10288  L_L58  L_L148  0.0016
K_K10289  L_L58  L_L149  0.0016
K_K10290  L_L58  L_L150  0.0016
K_K10291  L_L58  L_L151  0.0017
K_K10292  L_L58  L_L152  0.0017
K_K10293  L_L58  L_L153  0.0018
K_K10294  L_L58  L_L154  0.0018
K_K10295  L_L58  L_L155  0.0018
K_K10296  L_L58  L_L156  0.0019
K_K10297  L_L58  L_L157  0.0019
K_K10298  L_L58  L_L158  0.0020
K_K10299  L_L58  L_L159  0.0020
K_K10300  L_L58  L_L160  0.0021
K_K10301  L_L58  L_L161  0.0022
K_K10302  L_L58  L_L162  0.0022
K_K10303  L_L58  L_L163  0.0023
K_K10304  L_L58  L_L164  0.0024
K_K10305  L_L58  L_L165  0.0024
K_K10306  L_L58  L_L166  0.0025
K_K10307  L_L58  L_L167  0.0026
K_K10308  L_L58  L_L168  0.0027
K_K10309  L_L58  L_L169  0.0028
K_K10310  L_L58  L_L170  0.0029
K_K10311  L_L58  L_L171  0.0030
K_K10312  L_L58  L_L172  0.0032
K_K10313  L_L58  L_L173  0.0033
K_K10314  L_L58  L_L174  0.0034
K_K10315  L_L58  L_L175  0.0036
K_K10316  L_L58  L_L176  0.0038
K_K10317  L_L58  L_L177  0.0040
K_K10318  L_L58  L_L178  0.0042
K_K10319  L_L58  L_L179  0.0045
K_K10320  L_L58  L_L180  0.0047
K_K10321  L_L58  L_L181  0.0051
K_K10322  L_L58  L_L182  0.0054
K_K10323  L_L58  L_L183  0.0058
K_K10324  L_L58  L_L184  0.0063
K_K10325  L_L58  L_L185  0.0069
K_K10326  L_L58  L_L186  0.0076
K_K10327  L_L58  L_L187  0.0084
K_K10328  L_L58  L_L188  0.0095
K_K10329  L_L58  L_L189  0.0109
K_K10330  L_L58  L_L190  0.0127
K_K10331  L_L58  L_L191  0.0152
K_K10332  L_L58  L_L192  0.0191
K_K10333  L_L58  L_L193  0.0256
K_K10334  L_L58  L_L194  0.0389
K_K10335  L_L58  L_L195  0.0812
K_K10336  L_L58  L_L196  0.1569
K_K10337  L_L58  L_L197  0.0812
K_K10338  L_L58  L_L198  0.0389
K_K10339  L_L58  L_L199  0.0256
K_K10340  L_L58  L_L200  0.0191
K_K10341  L_L58  L_L201  0.0152
K_K10342  L_L58  L_L202  0.0127
K_K10343  L_L58  L_L203  0.0109
K_K10344  L_L58  L_L204  0.0095
K_K10345  L_L58  L_L205  0.0084
K_K10346  L_L58  L_L206  0.0076
K_K10347  L_L58  L_L207  0.0069
K_K10348  L_L58  L_L208  0.0063
K_K10349  L_L58  L_L209  0.0058
K_K10350  L_L58  L_L210  0.0054
K_K10351  L_L58  L_L211  0.0051
K_K10352  L_L58  L_L212  0.0047
K_K10353  L_L58  L_L213  0.0045
K_K10354  L_L58  L_L214  0.0042
K_K10355  L_L58  L_L215  0.0040
K_K10356  L_L58  L_L216  0.0038
K_K10357  L_L58  L_L217  0.0036
K_K10358  L_L58  L_L218  0.0034
K_K10359  L_L58  L_L219  0.0033
K_K10360  L_L58  L_L220  0.0032
K_K10361  L_L58  L_L221  0.0030
K_K10362  L_L58  L_L222  0.0029
K_K10363  L_L58  L_L223  0.0028
K_K10364  L_L58  L_L224  0.0027
K_K10365  L_L58  L_L225  0.0026
K_K10366  L_L58  L_L226  0.0025
K_K10367  L_L58  L_L227  0.0024
K_K10368  L_L58  L_L228  0.0024
K_K10369  L_L58  L_L229  0.0023
K_K10370  L_L58  L_L230  0.0022
K_K10371  L_L58  L_L231  0.0022
K_K10372  L_L58  L_L232  0.0021
K_K10373  L_L58  L_L233  0.0020
K_K10374  L_L58  L_L234  0.0020
K_K10375  L_L58  L_L235  0.0019
K_K10376  L_L58  L_L236  0.0019
K_K10377  L_L58  L_L237  0.0018
K_K10378  L_L58  L_L238  0.0018
K_K10379  L_L58  L_L239  0.0018
K_K10380  L_L58  L_L240  0.0017
K_K10381  L_L58  L_L241  0.0017
K_K10382  L_L58  L_L242  0.0016
K_K10383  L_L58  L_L243  0.0016
K_K10384  L_L58  L_L244  0.0016
K_K10385  L_L58  L_L245  0.0015
K_K10386  L_L58  L_L246  0.0015
K_K10387  L_L58  L_L247  0.0015
K_K10388  L_L58  L_L248  0.0015
K_K10389  L_L58  L_L249  0.0014
K_K10390  L_L58  L_L250  0.0014
K_K10391  L_L58  L_L251  0.0014
K_K10392  L_L58  L_L252  0.0014
K_K10393  L_L58  L_L253  0.0013
K_K10394  L_L58  L_L254  0.0013
K_K10395  L_L58  L_L255  0.0013
K_K10396  L_L58  L_L256  0.0013
K_K10397  L_L58  L_L257  0.0012
K_K10398  L_L58  L_L258  0.0012
K_K10399  L_L58  L_L259  0.0012
K_K10400  L_L58  L_L260  0.0012
K_K10401  L_L58  L_L261  0.0012
K_K10402  L_L58  L_L262  0.0011
K_K10403  L_L58  L_L263  0.0011
K_K10404  L_L58  L_L264  0.0011
K_K10405  L_L58  L_L265  0.0011
K_K10406  L_L58  L_L266  0.0011
K_K10407  L_L58  L_L267  0.0011
K_K10408  L_L58  L_L268  0.0011
K_K10409  L_L58  L_L269  0.0010
K_K10410  L_L58  L_L270  0.0010
K_K10411  L_L58  L_L271  0.0010
* *  Branch  NTMP0000000058 - NTMP0000000059
R_R59  NTMP0000000058  nU_59  32.914993m  TC=0,0
V_Ui59  nU_59  nR_59  STIMULUS=U_IND_0000000059
R_V117  nR_59  nV_117  23.280268m  TC=0,0
L_V117  nR_59  nV_117  0.014646uH
R_V118  nV_117  nV_118  7.852787m  TC=0,0
L_V118  nV_117  nV_118  0.073723uH
L_L59  nV_118  NTMP0000000059  6.519695uH
K_K10412  L_L59  L_L60  0.1050
K_K10413  L_L59  L_L61  0.0397
K_K10414  L_L59  L_L62  0.0258
K_K10415  L_L59  L_L63  0.0192
K_K10416  L_L59  L_L64  0.0153
K_K10417  L_L59  L_L65  0.0127
K_K10418  L_L59  L_L66  0.0109
K_K10419  L_L59  L_L67  0.0095
K_K10420  L_L59  L_L68  0.0084
K_K10421  L_L59  L_L69  0.0076
K_K10422  L_L59  L_L70  0.0069
K_K10423  L_L59  L_L71  0.0063
K_K10424  L_L59  L_L72  0.0058
K_K10425  L_L59  L_L73  0.0054
K_K10426  L_L59  L_L74  0.0051
K_K10427  L_L59  L_L75  0.0047
K_K10428  L_L59  L_L76  0.0045
K_K10429  L_L59  L_L77  0.0042
K_K10430  L_L59  L_L78  0.0040
K_K10431  L_L59  L_L79  0.0038
K_K10432  L_L59  L_L80  0.0036
K_K10433  L_L59  L_L81  0.0034
K_K10434  L_L59  L_L82  0.0033
K_K10435  L_L59  L_L83  0.0032
K_K10436  L_L59  L_L84  0.0030
K_K10437  L_L59  L_L85  0.0029
K_K10438  L_L59  L_L86  0.0028
K_K10439  L_L59  L_L87  0.0027
K_K10440  L_L59  L_L88  0.0026
K_K10441  L_L59  L_L89  0.0025
K_K10442  L_L59  L_L90  0.0024
K_K10443  L_L59  L_L91  0.0024
K_K10444  L_L59  L_L92  0.0023
K_K10445  L_L59  L_L93  0.0022
K_K10446  L_L59  L_L94  0.0022
K_K10447  L_L59  L_L95  0.0021
K_K10448  L_L59  L_L96  0.0020
K_K10449  L_L59  L_L97  0.0020
K_K10450  L_L59  L_L98  0.0019
K_K10451  L_L59  L_L99  0.0019
K_K10452  L_L59  L_L100  0.0019
K_K10453  L_L59  L_L101  0.0018
K_K10454  L_L59  L_L102  0.0018
K_K10455  L_L59  L_L103  0.0017
K_K10456  L_L59  L_L104  0.0017
K_K10457  L_L59  L_L105  0.0017
K_K10458  L_L59  L_L106  0.0016
K_K10459  L_L59  L_L107  0.0016
K_K10460  L_L59  L_L108  0.0015
K_K10461  L_L59  L_L109  0.0015
K_K10462  L_L59  L_L110  0.0015
K_K10463  L_L59  L_L111  0.0015
K_K10464  L_L59  L_L112  0.0014
K_K10465  L_L59  L_L113  0.0014
K_K10466  L_L59  L_L114  0.0014
K_K10467  L_L59  L_L115  0.0014
K_K10468  L_L59  L_L116  0.0013
K_K10469  L_L59  L_L117  0.0013
K_K10470  L_L59  L_L118  0.0013
K_K10471  L_L59  L_L119  0.0013
K_K10472  L_L59  L_L120  0.0013
K_K10473  L_L59  L_L121  0.0012
K_K10474  L_L59  L_L122  0.0012
K_K10475  L_L59  L_L123  0.0012
K_K10476  L_L59  L_L124  0.0012
K_K10477  L_L59  L_L125  0.0011
K_K10478  L_L59  L_L126  0.0011
K_K10479  L_L59  L_L127  0.0011
K_K10480  L_L59  L_L128  0.0011
K_K10481  L_L59  L_L129  0.0011
K_K10482  L_L59  L_L130  0.0011
K_K10483  L_L59  L_L131  0.0011
K_K10484  L_L59  L_L132  0.0010
K_K10485  L_L59  L_L133  0.0010
K_K10486  L_L59  L_L134  0.0010
K_K10487  L_L59  L_L139  0.0013
K_K10488  L_L59  L_L140  0.0013
K_K10489  L_L59  L_L141  0.0014
K_K10490  L_L59  L_L142  0.0014
K_K10491  L_L59  L_L143  0.0014
K_K10492  L_L59  L_L144  0.0014
K_K10493  L_L59  L_L145  0.0015
K_K10494  L_L59  L_L146  0.0015
K_K10495  L_L59  L_L147  0.0015
K_K10496  L_L59  L_L148  0.0015
K_K10497  L_L59  L_L149  0.0016
K_K10498  L_L59  L_L150  0.0016
K_K10499  L_L59  L_L151  0.0016
K_K10500  L_L59  L_L152  0.0017
K_K10501  L_L59  L_L153  0.0017
K_K10502  L_L59  L_L154  0.0018
K_K10503  L_L59  L_L155  0.0018
K_K10504  L_L59  L_L156  0.0018
K_K10505  L_L59  L_L157  0.0019
K_K10506  L_L59  L_L158  0.0019
K_K10507  L_L59  L_L159  0.0020
K_K10508  L_L59  L_L160  0.0020
K_K10509  L_L59  L_L161  0.0021
K_K10510  L_L59  L_L162  0.0022
K_K10511  L_L59  L_L163  0.0022
K_K10512  L_L59  L_L164  0.0023
K_K10513  L_L59  L_L165  0.0024
K_K10514  L_L59  L_L166  0.0024
K_K10515  L_L59  L_L167  0.0025
K_K10516  L_L59  L_L168  0.0026
K_K10517  L_L59  L_L169  0.0027
K_K10518  L_L59  L_L170  0.0028
K_K10519  L_L59  L_L171  0.0029
K_K10520  L_L59  L_L172  0.0030
K_K10521  L_L59  L_L173  0.0032
K_K10522  L_L59  L_L174  0.0033
K_K10523  L_L59  L_L175  0.0034
K_K10524  L_L59  L_L176  0.0036
K_K10525  L_L59  L_L177  0.0038
K_K10526  L_L59  L_L178  0.0040
K_K10527  L_L59  L_L179  0.0042
K_K10528  L_L59  L_L180  0.0045
K_K10529  L_L59  L_L181  0.0047
K_K10530  L_L59  L_L182  0.0051
K_K10531  L_L59  L_L183  0.0054
K_K10532  L_L59  L_L184  0.0058
K_K10533  L_L59  L_L185  0.0063
K_K10534  L_L59  L_L186  0.0069
K_K10535  L_L59  L_L187  0.0076
K_K10536  L_L59  L_L188  0.0084
K_K10537  L_L59  L_L189  0.0095
K_K10538  L_L59  L_L190  0.0109
K_K10539  L_L59  L_L191  0.0127
K_K10540  L_L59  L_L192  0.0152
K_K10541  L_L59  L_L193  0.0191
K_K10542  L_L59  L_L194  0.0256
K_K10543  L_L59  L_L195  0.0389
K_K10544  L_L59  L_L196  0.0812
K_K10545  L_L59  L_L197  0.1569
K_K10546  L_L59  L_L198  0.0812
K_K10547  L_L59  L_L199  0.0389
K_K10548  L_L59  L_L200  0.0256
K_K10549  L_L59  L_L201  0.0191
K_K10550  L_L59  L_L202  0.0152
K_K10551  L_L59  L_L203  0.0127
K_K10552  L_L59  L_L204  0.0109
K_K10553  L_L59  L_L205  0.0095
K_K10554  L_L59  L_L206  0.0084
K_K10555  L_L59  L_L207  0.0076
K_K10556  L_L59  L_L208  0.0069
K_K10557  L_L59  L_L209  0.0063
K_K10558  L_L59  L_L210  0.0058
K_K10559  L_L59  L_L211  0.0054
K_K10560  L_L59  L_L212  0.0051
K_K10561  L_L59  L_L213  0.0047
K_K10562  L_L59  L_L214  0.0045
K_K10563  L_L59  L_L215  0.0042
K_K10564  L_L59  L_L216  0.0040
K_K10565  L_L59  L_L217  0.0038
K_K10566  L_L59  L_L218  0.0036
K_K10567  L_L59  L_L219  0.0034
K_K10568  L_L59  L_L220  0.0033
K_K10569  L_L59  L_L221  0.0032
K_K10570  L_L59  L_L222  0.0030
K_K10571  L_L59  L_L223  0.0029
K_K10572  L_L59  L_L224  0.0028
K_K10573  L_L59  L_L225  0.0027
K_K10574  L_L59  L_L226  0.0026
K_K10575  L_L59  L_L227  0.0025
K_K10576  L_L59  L_L228  0.0024
K_K10577  L_L59  L_L229  0.0024
K_K10578  L_L59  L_L230  0.0023
K_K10579  L_L59  L_L231  0.0022
K_K10580  L_L59  L_L232  0.0022
K_K10581  L_L59  L_L233  0.0021
K_K10582  L_L59  L_L234  0.0020
K_K10583  L_L59  L_L235  0.0020
K_K10584  L_L59  L_L236  0.0019
K_K10585  L_L59  L_L237  0.0019
K_K10586  L_L59  L_L238  0.0018
K_K10587  L_L59  L_L239  0.0018
K_K10588  L_L59  L_L240  0.0018
K_K10589  L_L59  L_L241  0.0017
K_K10590  L_L59  L_L242  0.0017
K_K10591  L_L59  L_L243  0.0016
K_K10592  L_L59  L_L244  0.0016
K_K10593  L_L59  L_L245  0.0016
K_K10594  L_L59  L_L246  0.0015
K_K10595  L_L59  L_L247  0.0015
K_K10596  L_L59  L_L248  0.0015
K_K10597  L_L59  L_L249  0.0015
K_K10598  L_L59  L_L250  0.0014
K_K10599  L_L59  L_L251  0.0014
K_K10600  L_L59  L_L252  0.0014
K_K10601  L_L59  L_L253  0.0014
K_K10602  L_L59  L_L254  0.0013
K_K10603  L_L59  L_L255  0.0013
K_K10604  L_L59  L_L256  0.0013
K_K10605  L_L59  L_L257  0.0013
K_K10606  L_L59  L_L258  0.0012
K_K10607  L_L59  L_L259  0.0012
K_K10608  L_L59  L_L260  0.0012
K_K10609  L_L59  L_L261  0.0012
K_K10610  L_L59  L_L262  0.0012
K_K10611  L_L59  L_L263  0.0011
K_K10612  L_L59  L_L264  0.0011
K_K10613  L_L59  L_L265  0.0011
K_K10614  L_L59  L_L266  0.0011
K_K10615  L_L59  L_L267  0.0011
K_K10616  L_L59  L_L268  0.0011
K_K10617  L_L59  L_L269  0.0011
K_K10618  L_L59  L_L270  0.0010
K_K10619  L_L59  L_L271  0.0010
K_K10620  L_L59  L_L272  0.0010
* *  Branch  NTMP0000000059 - NTMP0000000060
R_R60  NTMP0000000059  nU_60  32.914993m  TC=0,0
V_Ui60  nU_60  nR_60  STIMULUS=U_IND_0000000060
R_V119  nR_60  nV_119  23.280268m  TC=0,0
L_V119  nR_60  nV_119  0.014646uH
R_V120  nV_119  nV_120  7.852787m  TC=0,0
L_V120  nV_119  nV_120  0.073723uH
L_L60  nV_120  NTMP0000000060  6.519695uH
K_K10621  L_L60  L_L61  0.1050
K_K10622  L_L60  L_L62  0.0397
K_K10623  L_L60  L_L63  0.0258
K_K10624  L_L60  L_L64  0.0192
K_K10625  L_L60  L_L65  0.0153
K_K10626  L_L60  L_L66  0.0127
K_K10627  L_L60  L_L67  0.0109
K_K10628  L_L60  L_L68  0.0095
K_K10629  L_L60  L_L69  0.0084
K_K10630  L_L60  L_L70  0.0076
K_K10631  L_L60  L_L71  0.0069
K_K10632  L_L60  L_L72  0.0063
K_K10633  L_L60  L_L73  0.0058
K_K10634  L_L60  L_L74  0.0054
K_K10635  L_L60  L_L75  0.0051
K_K10636  L_L60  L_L76  0.0047
K_K10637  L_L60  L_L77  0.0045
K_K10638  L_L60  L_L78  0.0042
K_K10639  L_L60  L_L79  0.0040
K_K10640  L_L60  L_L80  0.0038
K_K10641  L_L60  L_L81  0.0036
K_K10642  L_L60  L_L82  0.0034
K_K10643  L_L60  L_L83  0.0033
K_K10644  L_L60  L_L84  0.0032
K_K10645  L_L60  L_L85  0.0030
K_K10646  L_L60  L_L86  0.0029
K_K10647  L_L60  L_L87  0.0028
K_K10648  L_L60  L_L88  0.0027
K_K10649  L_L60  L_L89  0.0026
K_K10650  L_L60  L_L90  0.0025
K_K10651  L_L60  L_L91  0.0024
K_K10652  L_L60  L_L92  0.0024
K_K10653  L_L60  L_L93  0.0023
K_K10654  L_L60  L_L94  0.0022
K_K10655  L_L60  L_L95  0.0022
K_K10656  L_L60  L_L96  0.0021
K_K10657  L_L60  L_L97  0.0020
K_K10658  L_L60  L_L98  0.0020
K_K10659  L_L60  L_L99  0.0019
K_K10660  L_L60  L_L100  0.0019
K_K10661  L_L60  L_L101  0.0019
K_K10662  L_L60  L_L102  0.0018
K_K10663  L_L60  L_L103  0.0018
K_K10664  L_L60  L_L104  0.0017
K_K10665  L_L60  L_L105  0.0017
K_K10666  L_L60  L_L106  0.0017
K_K10667  L_L60  L_L107  0.0016
K_K10668  L_L60  L_L108  0.0016
K_K10669  L_L60  L_L109  0.0015
K_K10670  L_L60  L_L110  0.0015
K_K10671  L_L60  L_L111  0.0015
K_K10672  L_L60  L_L112  0.0015
K_K10673  L_L60  L_L113  0.0014
K_K10674  L_L60  L_L114  0.0014
K_K10675  L_L60  L_L115  0.0014
K_K10676  L_L60  L_L116  0.0014
K_K10677  L_L60  L_L117  0.0013
K_K10678  L_L60  L_L118  0.0013
K_K10679  L_L60  L_L119  0.0013
K_K10680  L_L60  L_L120  0.0013
K_K10681  L_L60  L_L121  0.0013
K_K10682  L_L60  L_L122  0.0012
K_K10683  L_L60  L_L123  0.0012
K_K10684  L_L60  L_L124  0.0012
K_K10685  L_L60  L_L125  0.0012
K_K10686  L_L60  L_L126  0.0011
K_K10687  L_L60  L_L127  0.0011
K_K10688  L_L60  L_L128  0.0011
K_K10689  L_L60  L_L129  0.0011
K_K10690  L_L60  L_L130  0.0011
K_K10691  L_L60  L_L131  0.0011
K_K10692  L_L60  L_L132  0.0011
K_K10693  L_L60  L_L133  0.0010
K_K10694  L_L60  L_L134  0.0010
K_K10695  L_L60  L_L135  0.0010
K_K10696  L_L60  L_L139  0.0013
K_K10697  L_L60  L_L140  0.0013
K_K10698  L_L60  L_L141  0.0013
K_K10699  L_L60  L_L142  0.0014
K_K10700  L_L60  L_L143  0.0014
K_K10701  L_L60  L_L144  0.0014
K_K10702  L_L60  L_L145  0.0014
K_K10703  L_L60  L_L146  0.0015
K_K10704  L_L60  L_L147  0.0015
K_K10705  L_L60  L_L148  0.0015
K_K10706  L_L60  L_L149  0.0015
K_K10707  L_L60  L_L150  0.0016
K_K10708  L_L60  L_L151  0.0016
K_K10709  L_L60  L_L152  0.0016
K_K10710  L_L60  L_L153  0.0017
K_K10711  L_L60  L_L154  0.0017
K_K10712  L_L60  L_L155  0.0018
K_K10713  L_L60  L_L156  0.0018
K_K10714  L_L60  L_L157  0.0018
K_K10715  L_L60  L_L158  0.0019
K_K10716  L_L60  L_L159  0.0019
K_K10717  L_L60  L_L160  0.0020
K_K10718  L_L60  L_L161  0.0020
K_K10719  L_L60  L_L162  0.0021
K_K10720  L_L60  L_L163  0.0022
K_K10721  L_L60  L_L164  0.0022
K_K10722  L_L60  L_L165  0.0023
K_K10723  L_L60  L_L166  0.0024
K_K10724  L_L60  L_L167  0.0024
K_K10725  L_L60  L_L168  0.0025
K_K10726  L_L60  L_L169  0.0026
K_K10727  L_L60  L_L170  0.0027
K_K10728  L_L60  L_L171  0.0028
K_K10729  L_L60  L_L172  0.0029
K_K10730  L_L60  L_L173  0.0030
K_K10731  L_L60  L_L174  0.0032
K_K10732  L_L60  L_L175  0.0033
K_K10733  L_L60  L_L176  0.0034
K_K10734  L_L60  L_L177  0.0036
K_K10735  L_L60  L_L178  0.0038
K_K10736  L_L60  L_L179  0.0040
K_K10737  L_L60  L_L180  0.0042
K_K10738  L_L60  L_L181  0.0045
K_K10739  L_L60  L_L182  0.0047
K_K10740  L_L60  L_L183  0.0051
K_K10741  L_L60  L_L184  0.0054
K_K10742  L_L60  L_L185  0.0058
K_K10743  L_L60  L_L186  0.0063
K_K10744  L_L60  L_L187  0.0069
K_K10745  L_L60  L_L188  0.0076
K_K10746  L_L60  L_L189  0.0084
K_K10747  L_L60  L_L190  0.0095
K_K10748  L_L60  L_L191  0.0109
K_K10749  L_L60  L_L192  0.0127
K_K10750  L_L60  L_L193  0.0152
K_K10751  L_L60  L_L194  0.0191
K_K10752  L_L60  L_L195  0.0256
K_K10753  L_L60  L_L196  0.0389
K_K10754  L_L60  L_L197  0.0812
K_K10755  L_L60  L_L198  0.1569
K_K10756  L_L60  L_L199  0.0812
K_K10757  L_L60  L_L200  0.0389
K_K10758  L_L60  L_L201  0.0256
K_K10759  L_L60  L_L202  0.0191
K_K10760  L_L60  L_L203  0.0152
K_K10761  L_L60  L_L204  0.0127
K_K10762  L_L60  L_L205  0.0109
K_K10763  L_L60  L_L206  0.0095
K_K10764  L_L60  L_L207  0.0084
K_K10765  L_L60  L_L208  0.0076
K_K10766  L_L60  L_L209  0.0069
K_K10767  L_L60  L_L210  0.0063
K_K10768  L_L60  L_L211  0.0058
K_K10769  L_L60  L_L212  0.0054
K_K10770  L_L60  L_L213  0.0051
K_K10771  L_L60  L_L214  0.0047
K_K10772  L_L60  L_L215  0.0045
K_K10773  L_L60  L_L216  0.0042
K_K10774  L_L60  L_L217  0.0040
K_K10775  L_L60  L_L218  0.0038
K_K10776  L_L60  L_L219  0.0036
K_K10777  L_L60  L_L220  0.0034
K_K10778  L_L60  L_L221  0.0033
K_K10779  L_L60  L_L222  0.0032
K_K10780  L_L60  L_L223  0.0030
K_K10781  L_L60  L_L224  0.0029
K_K10782  L_L60  L_L225  0.0028
K_K10783  L_L60  L_L226  0.0027
K_K10784  L_L60  L_L227  0.0026
K_K10785  L_L60  L_L228  0.0025
K_K10786  L_L60  L_L229  0.0024
K_K10787  L_L60  L_L230  0.0024
K_K10788  L_L60  L_L231  0.0023
K_K10789  L_L60  L_L232  0.0022
K_K10790  L_L60  L_L233  0.0022
K_K10791  L_L60  L_L234  0.0021
K_K10792  L_L60  L_L235  0.0020
K_K10793  L_L60  L_L236  0.0020
K_K10794  L_L60  L_L237  0.0019
K_K10795  L_L60  L_L238  0.0019
K_K10796  L_L60  L_L239  0.0018
K_K10797  L_L60  L_L240  0.0018
K_K10798  L_L60  L_L241  0.0018
K_K10799  L_L60  L_L242  0.0017
K_K10800  L_L60  L_L243  0.0017
K_K10801  L_L60  L_L244  0.0016
K_K10802  L_L60  L_L245  0.0016
K_K10803  L_L60  L_L246  0.0016
K_K10804  L_L60  L_L247  0.0015
K_K10805  L_L60  L_L248  0.0015
K_K10806  L_L60  L_L249  0.0015
K_K10807  L_L60  L_L250  0.0015
K_K10808  L_L60  L_L251  0.0014
K_K10809  L_L60  L_L252  0.0014
K_K10810  L_L60  L_L253  0.0014
K_K10811  L_L60  L_L254  0.0014
K_K10812  L_L60  L_L255  0.0013
K_K10813  L_L60  L_L256  0.0013
K_K10814  L_L60  L_L257  0.0013
K_K10815  L_L60  L_L258  0.0013
K_K10816  L_L60  L_L259  0.0012
K_K10817  L_L60  L_L260  0.0012
K_K10818  L_L60  L_L261  0.0012
K_K10819  L_L60  L_L262  0.0012
K_K10820  L_L60  L_L263  0.0012
K_K10821  L_L60  L_L264  0.0011
K_K10822  L_L60  L_L265  0.0011
K_K10823  L_L60  L_L266  0.0011
K_K10824  L_L60  L_L267  0.0011
K_K10825  L_L60  L_L268  0.0011
K_K10826  L_L60  L_L269  0.0011
K_K10827  L_L60  L_L270  0.0011
K_K10828  L_L60  L_L271  0.0010
K_K10829  L_L60  L_L272  0.0010
K_K10830  L_L60  L_L273  0.0010
* *  Branch  NTMP0000000060 - NTMP0000000061
R_R61  NTMP0000000060  nU_61  32.914993m  TC=0,0
V_Ui61  nU_61  nR_61  STIMULUS=U_IND_0000000061
R_V121  nR_61  nV_121  23.280268m  TC=0,0
L_V121  nR_61  nV_121  0.014646uH
R_V122  nV_121  nV_122  7.852787m  TC=0,0
L_V122  nV_121  nV_122  0.073723uH
L_L61  nV_122  NTMP0000000061  6.519695uH
K_K10831  L_L61  L_L62  0.1050
K_K10832  L_L61  L_L63  0.0397
K_K10833  L_L61  L_L64  0.0258
K_K10834  L_L61  L_L65  0.0192
K_K10835  L_L61  L_L66  0.0153
K_K10836  L_L61  L_L67  0.0127
K_K10837  L_L61  L_L68  0.0109
K_K10838  L_L61  L_L69  0.0095
K_K10839  L_L61  L_L70  0.0084
K_K10840  L_L61  L_L71  0.0076
K_K10841  L_L61  L_L72  0.0069
K_K10842  L_L61  L_L73  0.0063
K_K10843  L_L61  L_L74  0.0058
K_K10844  L_L61  L_L75  0.0054
K_K10845  L_L61  L_L76  0.0051
K_K10846  L_L61  L_L77  0.0047
K_K10847  L_L61  L_L78  0.0045
K_K10848  L_L61  L_L79  0.0042
K_K10849  L_L61  L_L80  0.0040
K_K10850  L_L61  L_L81  0.0038
K_K10851  L_L61  L_L82  0.0036
K_K10852  L_L61  L_L83  0.0034
K_K10853  L_L61  L_L84  0.0033
K_K10854  L_L61  L_L85  0.0032
K_K10855  L_L61  L_L86  0.0030
K_K10856  L_L61  L_L87  0.0029
K_K10857  L_L61  L_L88  0.0028
K_K10858  L_L61  L_L89  0.0027
K_K10859  L_L61  L_L90  0.0026
K_K10860  L_L61  L_L91  0.0025
K_K10861  L_L61  L_L92  0.0024
K_K10862  L_L61  L_L93  0.0024
K_K10863  L_L61  L_L94  0.0023
K_K10864  L_L61  L_L95  0.0022
K_K10865  L_L61  L_L96  0.0022
K_K10866  L_L61  L_L97  0.0021
K_K10867  L_L61  L_L98  0.0020
K_K10868  L_L61  L_L99  0.0020
K_K10869  L_L61  L_L100  0.0019
K_K10870  L_L61  L_L101  0.0019
K_K10871  L_L61  L_L102  0.0019
K_K10872  L_L61  L_L103  0.0018
K_K10873  L_L61  L_L104  0.0018
K_K10874  L_L61  L_L105  0.0017
K_K10875  L_L61  L_L106  0.0017
K_K10876  L_L61  L_L107  0.0017
K_K10877  L_L61  L_L108  0.0016
K_K10878  L_L61  L_L109  0.0016
K_K10879  L_L61  L_L110  0.0015
K_K10880  L_L61  L_L111  0.0015
K_K10881  L_L61  L_L112  0.0015
K_K10882  L_L61  L_L113  0.0015
K_K10883  L_L61  L_L114  0.0014
K_K10884  L_L61  L_L115  0.0014
K_K10885  L_L61  L_L116  0.0014
K_K10886  L_L61  L_L117  0.0014
K_K10887  L_L61  L_L118  0.0013
K_K10888  L_L61  L_L119  0.0013
K_K10889  L_L61  L_L120  0.0013
K_K10890  L_L61  L_L121  0.0013
K_K10891  L_L61  L_L122  0.0013
K_K10892  L_L61  L_L123  0.0012
K_K10893  L_L61  L_L124  0.0012
K_K10894  L_L61  L_L125  0.0012
K_K10895  L_L61  L_L126  0.0012
K_K10896  L_L61  L_L127  0.0011
K_K10897  L_L61  L_L128  0.0011
K_K10898  L_L61  L_L129  0.0011
K_K10899  L_L61  L_L130  0.0011
K_K10900  L_L61  L_L131  0.0011
K_K10901  L_L61  L_L132  0.0011
K_K10902  L_L61  L_L133  0.0011
K_K10903  L_L61  L_L134  0.0010
K_K10904  L_L61  L_L135  0.0010
K_K10905  L_L61  L_L136  0.0010
K_K10906  L_L61  L_L139  0.0013
K_K10907  L_L61  L_L140  0.0013
K_K10908  L_L61  L_L141  0.0013
K_K10909  L_L61  L_L142  0.0013
K_K10910  L_L61  L_L143  0.0014
K_K10911  L_L61  L_L144  0.0014
K_K10912  L_L61  L_L145  0.0014
K_K10913  L_L61  L_L146  0.0014
K_K10914  L_L61  L_L147  0.0015
K_K10915  L_L61  L_L148  0.0015
K_K10916  L_L61  L_L149  0.0015
K_K10917  L_L61  L_L150  0.0015
K_K10918  L_L61  L_L151  0.0016
K_K10919  L_L61  L_L152  0.0016
K_K10920  L_L61  L_L153  0.0016
K_K10921  L_L61  L_L154  0.0017
K_K10922  L_L61  L_L155  0.0017
K_K10923  L_L61  L_L156  0.0018
K_K10924  L_L61  L_L157  0.0018
K_K10925  L_L61  L_L158  0.0018
K_K10926  L_L61  L_L159  0.0019
K_K10927  L_L61  L_L160  0.0019
K_K10928  L_L61  L_L161  0.0020
K_K10929  L_L61  L_L162  0.0020
K_K10930  L_L61  L_L163  0.0021
K_K10931  L_L61  L_L164  0.0022
K_K10932  L_L61  L_L165  0.0022
K_K10933  L_L61  L_L166  0.0023
K_K10934  L_L61  L_L167  0.0024
K_K10935  L_L61  L_L168  0.0024
K_K10936  L_L61  L_L169  0.0025
K_K10937  L_L61  L_L170  0.0026
K_K10938  L_L61  L_L171  0.0027
K_K10939  L_L61  L_L172  0.0028
K_K10940  L_L61  L_L173  0.0029
K_K10941  L_L61  L_L174  0.0030
K_K10942  L_L61  L_L175  0.0032
K_K10943  L_L61  L_L176  0.0033
K_K10944  L_L61  L_L177  0.0034
K_K10945  L_L61  L_L178  0.0036
K_K10946  L_L61  L_L179  0.0038
K_K10947  L_L61  L_L180  0.0040
K_K10948  L_L61  L_L181  0.0042
K_K10949  L_L61  L_L182  0.0045
K_K10950  L_L61  L_L183  0.0047
K_K10951  L_L61  L_L184  0.0051
K_K10952  L_L61  L_L185  0.0054
K_K10953  L_L61  L_L186  0.0058
K_K10954  L_L61  L_L187  0.0063
K_K10955  L_L61  L_L188  0.0069
K_K10956  L_L61  L_L189  0.0076
K_K10957  L_L61  L_L190  0.0084
K_K10958  L_L61  L_L191  0.0095
K_K10959  L_L61  L_L192  0.0109
K_K10960  L_L61  L_L193  0.0127
K_K10961  L_L61  L_L194  0.0152
K_K10962  L_L61  L_L195  0.0191
K_K10963  L_L61  L_L196  0.0256
K_K10964  L_L61  L_L197  0.0389
K_K10965  L_L61  L_L198  0.0812
K_K10966  L_L61  L_L199  0.1569
K_K10967  L_L61  L_L200  0.0812
K_K10968  L_L61  L_L201  0.0389
K_K10969  L_L61  L_L202  0.0256
K_K10970  L_L61  L_L203  0.0191
K_K10971  L_L61  L_L204  0.0152
K_K10972  L_L61  L_L205  0.0127
K_K10973  L_L61  L_L206  0.0109
K_K10974  L_L61  L_L207  0.0095
K_K10975  L_L61  L_L208  0.0084
K_K10976  L_L61  L_L209  0.0076
K_K10977  L_L61  L_L210  0.0069
K_K10978  L_L61  L_L211  0.0063
K_K10979  L_L61  L_L212  0.0058
K_K10980  L_L61  L_L213  0.0054
K_K10981  L_L61  L_L214  0.0051
K_K10982  L_L61  L_L215  0.0047
K_K10983  L_L61  L_L216  0.0045
K_K10984  L_L61  L_L217  0.0042
K_K10985  L_L61  L_L218  0.0040
K_K10986  L_L61  L_L219  0.0038
K_K10987  L_L61  L_L220  0.0036
K_K10988  L_L61  L_L221  0.0034
K_K10989  L_L61  L_L222  0.0033
K_K10990  L_L61  L_L223  0.0032
K_K10991  L_L61  L_L224  0.0030
K_K10992  L_L61  L_L225  0.0029
K_K10993  L_L61  L_L226  0.0028
K_K10994  L_L61  L_L227  0.0027
K_K10995  L_L61  L_L228  0.0026
K_K10996  L_L61  L_L229  0.0025
K_K10997  L_L61  L_L230  0.0024
K_K10998  L_L61  L_L231  0.0024
K_K10999  L_L61  L_L232  0.0023
K_K11000  L_L61  L_L233  0.0022
K_K11001  L_L61  L_L234  0.0022
K_K11002  L_L61  L_L235  0.0021
K_K11003  L_L61  L_L236  0.0020
K_K11004  L_L61  L_L237  0.0020
K_K11005  L_L61  L_L238  0.0019
K_K11006  L_L61  L_L239  0.0019
K_K11007  L_L61  L_L240  0.0018
K_K11008  L_L61  L_L241  0.0018
K_K11009  L_L61  L_L242  0.0018
K_K11010  L_L61  L_L243  0.0017
K_K11011  L_L61  L_L244  0.0017
K_K11012  L_L61  L_L245  0.0016
K_K11013  L_L61  L_L246  0.0016
K_K11014  L_L61  L_L247  0.0016
K_K11015  L_L61  L_L248  0.0015
K_K11016  L_L61  L_L249  0.0015
K_K11017  L_L61  L_L250  0.0015
K_K11018  L_L61  L_L251  0.0015
K_K11019  L_L61  L_L252  0.0014
K_K11020  L_L61  L_L253  0.0014
K_K11021  L_L61  L_L254  0.0014
K_K11022  L_L61  L_L255  0.0014
K_K11023  L_L61  L_L256  0.0013
K_K11024  L_L61  L_L257  0.0013
K_K11025  L_L61  L_L258  0.0013
K_K11026  L_L61  L_L259  0.0013
K_K11027  L_L61  L_L260  0.0012
K_K11028  L_L61  L_L261  0.0012
K_K11029  L_L61  L_L262  0.0012
K_K11030  L_L61  L_L263  0.0012
K_K11031  L_L61  L_L264  0.0012
K_K11032  L_L61  L_L265  0.0011
K_K11033  L_L61  L_L266  0.0011
K_K11034  L_L61  L_L267  0.0011
K_K11035  L_L61  L_L268  0.0011
K_K11036  L_L61  L_L269  0.0011
K_K11037  L_L61  L_L270  0.0011
K_K11038  L_L61  L_L271  0.0011
K_K11039  L_L61  L_L272  0.0010
K_K11040  L_L61  L_L273  0.0010
K_K11041  L_L61  L_L274  0.0010
* *  Branch  NTMP0000000061 - NTMP0000000062
R_R62  NTMP0000000061  nU_62  32.914993m  TC=0,0
V_Ui62  nU_62  nR_62  STIMULUS=U_IND_0000000062
R_V123  nR_62  nV_123  23.280268m  TC=0,0
L_V123  nR_62  nV_123  0.014646uH
R_V124  nV_123  nV_124  7.852787m  TC=0,0
L_V124  nV_123  nV_124  0.073723uH
L_L62  nV_124  NTMP0000000062  6.519695uH
K_K11042  L_L62  L_L63  0.1050
K_K11043  L_L62  L_L64  0.0397
K_K11044  L_L62  L_L65  0.0258
K_K11045  L_L62  L_L66  0.0192
K_K11046  L_L62  L_L67  0.0153
K_K11047  L_L62  L_L68  0.0127
K_K11048  L_L62  L_L69  0.0109
K_K11049  L_L62  L_L70  0.0095
K_K11050  L_L62  L_L71  0.0084
K_K11051  L_L62  L_L72  0.0076
K_K11052  L_L62  L_L73  0.0069
K_K11053  L_L62  L_L74  0.0063
K_K11054  L_L62  L_L75  0.0058
K_K11055  L_L62  L_L76  0.0054
K_K11056  L_L62  L_L77  0.0051
K_K11057  L_L62  L_L78  0.0047
K_K11058  L_L62  L_L79  0.0045
K_K11059  L_L62  L_L80  0.0042
K_K11060  L_L62  L_L81  0.0040
K_K11061  L_L62  L_L82  0.0038
K_K11062  L_L62  L_L83  0.0036
K_K11063  L_L62  L_L84  0.0034
K_K11064  L_L62  L_L85  0.0033
K_K11065  L_L62  L_L86  0.0032
K_K11066  L_L62  L_L87  0.0030
K_K11067  L_L62  L_L88  0.0029
K_K11068  L_L62  L_L89  0.0028
K_K11069  L_L62  L_L90  0.0027
K_K11070  L_L62  L_L91  0.0026
K_K11071  L_L62  L_L92  0.0025
K_K11072  L_L62  L_L93  0.0024
K_K11073  L_L62  L_L94  0.0024
K_K11074  L_L62  L_L95  0.0023
K_K11075  L_L62  L_L96  0.0022
K_K11076  L_L62  L_L97  0.0022
K_K11077  L_L62  L_L98  0.0021
K_K11078  L_L62  L_L99  0.0020
K_K11079  L_L62  L_L100  0.0020
K_K11080  L_L62  L_L101  0.0019
K_K11081  L_L62  L_L102  0.0019
K_K11082  L_L62  L_L103  0.0019
K_K11083  L_L62  L_L104  0.0018
K_K11084  L_L62  L_L105  0.0018
K_K11085  L_L62  L_L106  0.0017
K_K11086  L_L62  L_L107  0.0017
K_K11087  L_L62  L_L108  0.0017
K_K11088  L_L62  L_L109  0.0016
K_K11089  L_L62  L_L110  0.0016
K_K11090  L_L62  L_L111  0.0015
K_K11091  L_L62  L_L112  0.0015
K_K11092  L_L62  L_L113  0.0015
K_K11093  L_L62  L_L114  0.0015
K_K11094  L_L62  L_L115  0.0014
K_K11095  L_L62  L_L116  0.0014
K_K11096  L_L62  L_L117  0.0014
K_K11097  L_L62  L_L118  0.0014
K_K11098  L_L62  L_L119  0.0013
K_K11099  L_L62  L_L120  0.0013
K_K11100  L_L62  L_L121  0.0013
K_K11101  L_L62  L_L122  0.0013
K_K11102  L_L62  L_L123  0.0013
K_K11103  L_L62  L_L124  0.0012
K_K11104  L_L62  L_L125  0.0012
K_K11105  L_L62  L_L126  0.0012
K_K11106  L_L62  L_L127  0.0012
K_K11107  L_L62  L_L128  0.0011
K_K11108  L_L62  L_L129  0.0011
K_K11109  L_L62  L_L130  0.0011
K_K11110  L_L62  L_L131  0.0011
K_K11111  L_L62  L_L132  0.0011
K_K11112  L_L62  L_L133  0.0011
K_K11113  L_L62  L_L134  0.0011
K_K11114  L_L62  L_L135  0.0010
K_K11115  L_L62  L_L136  0.0010
K_K11116  L_L62  L_L137  0.0010
K_K11117  L_L62  L_L139  0.0012
K_K11118  L_L62  L_L140  0.0013
K_K11119  L_L62  L_L141  0.0013
K_K11120  L_L62  L_L142  0.0013
K_K11121  L_L62  L_L143  0.0013
K_K11122  L_L62  L_L144  0.0014
K_K11123  L_L62  L_L145  0.0014
K_K11124  L_L62  L_L146  0.0014
K_K11125  L_L62  L_L147  0.0014
K_K11126  L_L62  L_L148  0.0015
K_K11127  L_L62  L_L149  0.0015
K_K11128  L_L62  L_L150  0.0015
K_K11129  L_L62  L_L151  0.0015
K_K11130  L_L62  L_L152  0.0016
K_K11131  L_L62  L_L153  0.0016
K_K11132  L_L62  L_L154  0.0016
K_K11133  L_L62  L_L155  0.0017
K_K11134  L_L62  L_L156  0.0017
K_K11135  L_L62  L_L157  0.0018
K_K11136  L_L62  L_L158  0.0018
K_K11137  L_L62  L_L159  0.0018
K_K11138  L_L62  L_L160  0.0019
K_K11139  L_L62  L_L161  0.0019
K_K11140  L_L62  L_L162  0.0020
K_K11141  L_L62  L_L163  0.0020
K_K11142  L_L62  L_L164  0.0021
K_K11143  L_L62  L_L165  0.0022
K_K11144  L_L62  L_L166  0.0022
K_K11145  L_L62  L_L167  0.0023
K_K11146  L_L62  L_L168  0.0024
K_K11147  L_L62  L_L169  0.0024
K_K11148  L_L62  L_L170  0.0025
K_K11149  L_L62  L_L171  0.0026
K_K11150  L_L62  L_L172  0.0027
K_K11151  L_L62  L_L173  0.0028
K_K11152  L_L62  L_L174  0.0029
K_K11153  L_L62  L_L175  0.0030
K_K11154  L_L62  L_L176  0.0032
K_K11155  L_L62  L_L177  0.0033
K_K11156  L_L62  L_L178  0.0034
K_K11157  L_L62  L_L179  0.0036
K_K11158  L_L62  L_L180  0.0038
K_K11159  L_L62  L_L181  0.0040
K_K11160  L_L62  L_L182  0.0042
K_K11161  L_L62  L_L183  0.0045
K_K11162  L_L62  L_L184  0.0047
K_K11163  L_L62  L_L185  0.0051
K_K11164  L_L62  L_L186  0.0054
K_K11165  L_L62  L_L187  0.0058
K_K11166  L_L62  L_L188  0.0063
K_K11167  L_L62  L_L189  0.0069
K_K11168  L_L62  L_L190  0.0076
K_K11169  L_L62  L_L191  0.0084
K_K11170  L_L62  L_L192  0.0095
K_K11171  L_L62  L_L193  0.0109
K_K11172  L_L62  L_L194  0.0127
K_K11173  L_L62  L_L195  0.0152
K_K11174  L_L62  L_L196  0.0191
K_K11175  L_L62  L_L197  0.0256
K_K11176  L_L62  L_L198  0.0389
K_K11177  L_L62  L_L199  0.0812
K_K11178  L_L62  L_L200  0.1569
K_K11179  L_L62  L_L201  0.0812
K_K11180  L_L62  L_L202  0.0389
K_K11181  L_L62  L_L203  0.0256
K_K11182  L_L62  L_L204  0.0191
K_K11183  L_L62  L_L205  0.0152
K_K11184  L_L62  L_L206  0.0127
K_K11185  L_L62  L_L207  0.0109
K_K11186  L_L62  L_L208  0.0095
K_K11187  L_L62  L_L209  0.0084
K_K11188  L_L62  L_L210  0.0076
K_K11189  L_L62  L_L211  0.0069
K_K11190  L_L62  L_L212  0.0063
K_K11191  L_L62  L_L213  0.0058
K_K11192  L_L62  L_L214  0.0054
K_K11193  L_L62  L_L215  0.0051
K_K11194  L_L62  L_L216  0.0047
K_K11195  L_L62  L_L217  0.0045
K_K11196  L_L62  L_L218  0.0042
K_K11197  L_L62  L_L219  0.0040
K_K11198  L_L62  L_L220  0.0038
K_K11199  L_L62  L_L221  0.0036
K_K11200  L_L62  L_L222  0.0034
K_K11201  L_L62  L_L223  0.0033
K_K11202  L_L62  L_L224  0.0032
K_K11203  L_L62  L_L225  0.0030
K_K11204  L_L62  L_L226  0.0029
K_K11205  L_L62  L_L227  0.0028
K_K11206  L_L62  L_L228  0.0027
K_K11207  L_L62  L_L229  0.0026
K_K11208  L_L62  L_L230  0.0025
K_K11209  L_L62  L_L231  0.0024
K_K11210  L_L62  L_L232  0.0024
K_K11211  L_L62  L_L233  0.0023
K_K11212  L_L62  L_L234  0.0022
K_K11213  L_L62  L_L235  0.0022
K_K11214  L_L62  L_L236  0.0021
K_K11215  L_L62  L_L237  0.0020
K_K11216  L_L62  L_L238  0.0020
K_K11217  L_L62  L_L239  0.0019
K_K11218  L_L62  L_L240  0.0019
K_K11219  L_L62  L_L241  0.0018
K_K11220  L_L62  L_L242  0.0018
K_K11221  L_L62  L_L243  0.0018
K_K11222  L_L62  L_L244  0.0017
K_K11223  L_L62  L_L245  0.0017
K_K11224  L_L62  L_L246  0.0016
K_K11225  L_L62  L_L247  0.0016
K_K11226  L_L62  L_L248  0.0016
K_K11227  L_L62  L_L249  0.0015
K_K11228  L_L62  L_L250  0.0015
K_K11229  L_L62  L_L251  0.0015
K_K11230  L_L62  L_L252  0.0015
K_K11231  L_L62  L_L253  0.0014
K_K11232  L_L62  L_L254  0.0014
K_K11233  L_L62  L_L255  0.0014
K_K11234  L_L62  L_L256  0.0014
K_K11235  L_L62  L_L257  0.0013
K_K11236  L_L62  L_L258  0.0013
K_K11237  L_L62  L_L259  0.0013
K_K11238  L_L62  L_L260  0.0013
K_K11239  L_L62  L_L261  0.0012
K_K11240  L_L62  L_L262  0.0012
K_K11241  L_L62  L_L263  0.0012
K_K11242  L_L62  L_L264  0.0012
K_K11243  L_L62  L_L265  0.0012
K_K11244  L_L62  L_L266  0.0011
K_K11245  L_L62  L_L267  0.0011
K_K11246  L_L62  L_L268  0.0011
K_K11247  L_L62  L_L269  0.0011
K_K11248  L_L62  L_L270  0.0011
K_K11249  L_L62  L_L271  0.0011
K_K11250  L_L62  L_L272  0.0011
K_K11251  L_L62  L_L273  0.0010
K_K11252  L_L62  L_L274  0.0010
K_K11253  L_L62  L_L275  0.0010
* *  Branch  NTMP0000000062 - NTMP0000000063
R_R63  NTMP0000000062  nU_63  32.914993m  TC=0,0
V_Ui63  nU_63  nR_63  STIMULUS=U_IND_0000000063
R_V125  nR_63  nV_125  23.280268m  TC=0,0
L_V125  nR_63  nV_125  0.014646uH
R_V126  nV_125  nV_126  7.852787m  TC=0,0
L_V126  nV_125  nV_126  0.073723uH
L_L63  nV_126  NTMP0000000063  6.519695uH
K_K11254  L_L63  L_L64  0.1050
K_K11255  L_L63  L_L65  0.0397
K_K11256  L_L63  L_L66  0.0258
K_K11257  L_L63  L_L67  0.0192
K_K11258  L_L63  L_L68  0.0153
K_K11259  L_L63  L_L69  0.0127
K_K11260  L_L63  L_L70  0.0109
K_K11261  L_L63  L_L71  0.0095
K_K11262  L_L63  L_L72  0.0084
K_K11263  L_L63  L_L73  0.0076
K_K11264  L_L63  L_L74  0.0069
K_K11265  L_L63  L_L75  0.0063
K_K11266  L_L63  L_L76  0.0058
K_K11267  L_L63  L_L77  0.0054
K_K11268  L_L63  L_L78  0.0051
K_K11269  L_L63  L_L79  0.0047
K_K11270  L_L63  L_L80  0.0045
K_K11271  L_L63  L_L81  0.0042
K_K11272  L_L63  L_L82  0.0040
K_K11273  L_L63  L_L83  0.0038
K_K11274  L_L63  L_L84  0.0036
K_K11275  L_L63  L_L85  0.0034
K_K11276  L_L63  L_L86  0.0033
K_K11277  L_L63  L_L87  0.0032
K_K11278  L_L63  L_L88  0.0030
K_K11279  L_L63  L_L89  0.0029
K_K11280  L_L63  L_L90  0.0028
K_K11281  L_L63  L_L91  0.0027
K_K11282  L_L63  L_L92  0.0026
K_K11283  L_L63  L_L93  0.0025
K_K11284  L_L63  L_L94  0.0024
K_K11285  L_L63  L_L95  0.0024
K_K11286  L_L63  L_L96  0.0023
K_K11287  L_L63  L_L97  0.0022
K_K11288  L_L63  L_L98  0.0022
K_K11289  L_L63  L_L99  0.0021
K_K11290  L_L63  L_L100  0.0020
K_K11291  L_L63  L_L101  0.0020
K_K11292  L_L63  L_L102  0.0019
K_K11293  L_L63  L_L103  0.0019
K_K11294  L_L63  L_L104  0.0019
K_K11295  L_L63  L_L105  0.0018
K_K11296  L_L63  L_L106  0.0018
K_K11297  L_L63  L_L107  0.0017
K_K11298  L_L63  L_L108  0.0017
K_K11299  L_L63  L_L109  0.0017
K_K11300  L_L63  L_L110  0.0016
K_K11301  L_L63  L_L111  0.0016
K_K11302  L_L63  L_L112  0.0015
K_K11303  L_L63  L_L113  0.0015
K_K11304  L_L63  L_L114  0.0015
K_K11305  L_L63  L_L115  0.0015
K_K11306  L_L63  L_L116  0.0014
K_K11307  L_L63  L_L117  0.0014
K_K11308  L_L63  L_L118  0.0014
K_K11309  L_L63  L_L119  0.0014
K_K11310  L_L63  L_L120  0.0013
K_K11311  L_L63  L_L121  0.0013
K_K11312  L_L63  L_L122  0.0013
K_K11313  L_L63  L_L123  0.0013
K_K11314  L_L63  L_L124  0.0013
K_K11315  L_L63  L_L125  0.0012
K_K11316  L_L63  L_L126  0.0012
K_K11317  L_L63  L_L127  0.0012
K_K11318  L_L63  L_L128  0.0012
K_K11319  L_L63  L_L129  0.0011
K_K11320  L_L63  L_L130  0.0011
K_K11321  L_L63  L_L131  0.0011
K_K11322  L_L63  L_L132  0.0011
K_K11323  L_L63  L_L133  0.0011
K_K11324  L_L63  L_L134  0.0011
K_K11325  L_L63  L_L135  0.0011
K_K11326  L_L63  L_L136  0.0010
K_K11327  L_L63  L_L137  0.0010
K_K11328  L_L63  L_L138  0.0010
K_K11329  L_L63  L_L139  0.0012
K_K11330  L_L63  L_L140  0.0012
K_K11331  L_L63  L_L141  0.0013
K_K11332  L_L63  L_L142  0.0013
K_K11333  L_L63  L_L143  0.0013
K_K11334  L_L63  L_L144  0.0013
K_K11335  L_L63  L_L145  0.0014
K_K11336  L_L63  L_L146  0.0014
K_K11337  L_L63  L_L147  0.0014
K_K11338  L_L63  L_L148  0.0014
K_K11339  L_L63  L_L149  0.0015
K_K11340  L_L63  L_L150  0.0015
K_K11341  L_L63  L_L151  0.0015
K_K11342  L_L63  L_L152  0.0015
K_K11343  L_L63  L_L153  0.0016
K_K11344  L_L63  L_L154  0.0016
K_K11345  L_L63  L_L155  0.0016
K_K11346  L_L63  L_L156  0.0017
K_K11347  L_L63  L_L157  0.0017
K_K11348  L_L63  L_L158  0.0018
K_K11349  L_L63  L_L159  0.0018
K_K11350  L_L63  L_L160  0.0018
K_K11351  L_L63  L_L161  0.0019
K_K11352  L_L63  L_L162  0.0019
K_K11353  L_L63  L_L163  0.0020
K_K11354  L_L63  L_L164  0.0020
K_K11355  L_L63  L_L165  0.0021
K_K11356  L_L63  L_L166  0.0022
K_K11357  L_L63  L_L167  0.0022
K_K11358  L_L63  L_L168  0.0023
K_K11359  L_L63  L_L169  0.0024
K_K11360  L_L63  L_L170  0.0024
K_K11361  L_L63  L_L171  0.0025
K_K11362  L_L63  L_L172  0.0026
K_K11363  L_L63  L_L173  0.0027
K_K11364  L_L63  L_L174  0.0028
K_K11365  L_L63  L_L175  0.0029
K_K11366  L_L63  L_L176  0.0030
K_K11367  L_L63  L_L177  0.0032
K_K11368  L_L63  L_L178  0.0033
K_K11369  L_L63  L_L179  0.0034
K_K11370  L_L63  L_L180  0.0036
K_K11371  L_L63  L_L181  0.0038
K_K11372  L_L63  L_L182  0.0040
K_K11373  L_L63  L_L183  0.0042
K_K11374  L_L63  L_L184  0.0045
K_K11375  L_L63  L_L185  0.0047
K_K11376  L_L63  L_L186  0.0051
K_K11377  L_L63  L_L187  0.0054
K_K11378  L_L63  L_L188  0.0058
K_K11379  L_L63  L_L189  0.0063
K_K11380  L_L63  L_L190  0.0069
K_K11381  L_L63  L_L191  0.0076
K_K11382  L_L63  L_L192  0.0084
K_K11383  L_L63  L_L193  0.0095
K_K11384  L_L63  L_L194  0.0109
K_K11385  L_L63  L_L195  0.0127
K_K11386  L_L63  L_L196  0.0152
K_K11387  L_L63  L_L197  0.0191
K_K11388  L_L63  L_L198  0.0256
K_K11389  L_L63  L_L199  0.0389
K_K11390  L_L63  L_L200  0.0812
K_K11391  L_L63  L_L201  0.1569
K_K11392  L_L63  L_L202  0.0812
K_K11393  L_L63  L_L203  0.0389
K_K11394  L_L63  L_L204  0.0256
K_K11395  L_L63  L_L205  0.0191
K_K11396  L_L63  L_L206  0.0152
K_K11397  L_L63  L_L207  0.0127
K_K11398  L_L63  L_L208  0.0109
K_K11399  L_L63  L_L209  0.0095
K_K11400  L_L63  L_L210  0.0084
K_K11401  L_L63  L_L211  0.0076
K_K11402  L_L63  L_L212  0.0069
K_K11403  L_L63  L_L213  0.0063
K_K11404  L_L63  L_L214  0.0058
K_K11405  L_L63  L_L215  0.0054
K_K11406  L_L63  L_L216  0.0051
K_K11407  L_L63  L_L217  0.0047
K_K11408  L_L63  L_L218  0.0045
K_K11409  L_L63  L_L219  0.0042
K_K11410  L_L63  L_L220  0.0040
K_K11411  L_L63  L_L221  0.0038
K_K11412  L_L63  L_L222  0.0036
K_K11413  L_L63  L_L223  0.0034
K_K11414  L_L63  L_L224  0.0033
K_K11415  L_L63  L_L225  0.0032
K_K11416  L_L63  L_L226  0.0030
K_K11417  L_L63  L_L227  0.0029
K_K11418  L_L63  L_L228  0.0028
K_K11419  L_L63  L_L229  0.0027
K_K11420  L_L63  L_L230  0.0026
K_K11421  L_L63  L_L231  0.0025
K_K11422  L_L63  L_L232  0.0024
K_K11423  L_L63  L_L233  0.0024
K_K11424  L_L63  L_L234  0.0023
K_K11425  L_L63  L_L235  0.0022
K_K11426  L_L63  L_L236  0.0022
K_K11427  L_L63  L_L237  0.0021
K_K11428  L_L63  L_L238  0.0020
K_K11429  L_L63  L_L239  0.0020
K_K11430  L_L63  L_L240  0.0019
K_K11431  L_L63  L_L241  0.0019
K_K11432  L_L63  L_L242  0.0018
K_K11433  L_L63  L_L243  0.0018
K_K11434  L_L63  L_L244  0.0018
K_K11435  L_L63  L_L245  0.0017
K_K11436  L_L63  L_L246  0.0017
K_K11437  L_L63  L_L247  0.0016
K_K11438  L_L63  L_L248  0.0016
K_K11439  L_L63  L_L249  0.0016
K_K11440  L_L63  L_L250  0.0015
K_K11441  L_L63  L_L251  0.0015
K_K11442  L_L63  L_L252  0.0015
K_K11443  L_L63  L_L253  0.0015
K_K11444  L_L63  L_L254  0.0014
K_K11445  L_L63  L_L255  0.0014
K_K11446  L_L63  L_L256  0.0014
K_K11447  L_L63  L_L257  0.0014
K_K11448  L_L63  L_L258  0.0013
K_K11449  L_L63  L_L259  0.0013
K_K11450  L_L63  L_L260  0.0013
K_K11451  L_L63  L_L261  0.0013
K_K11452  L_L63  L_L262  0.0012
K_K11453  L_L63  L_L263  0.0012
K_K11454  L_L63  L_L264  0.0012
K_K11455  L_L63  L_L265  0.0012
K_K11456  L_L63  L_L266  0.0012
K_K11457  L_L63  L_L267  0.0011
K_K11458  L_L63  L_L268  0.0011
K_K11459  L_L63  L_L269  0.0011
K_K11460  L_L63  L_L270  0.0011
K_K11461  L_L63  L_L271  0.0011
K_K11462  L_L63  L_L272  0.0011
K_K11463  L_L63  L_L273  0.0011
K_K11464  L_L63  L_L274  0.0010
K_K11465  L_L63  L_L275  0.0010
K_K11466  L_L63  L_L276  0.0010
* *  Branch  NTMP0000000063 - NTMP0000000064
R_R64  NTMP0000000063  nU_64  32.914993m  TC=0,0
V_Ui64  nU_64  nR_64  STIMULUS=U_IND_0000000064
R_V127  nR_64  nV_127  23.280268m  TC=0,0
L_V127  nR_64  nV_127  0.014646uH
R_V128  nV_127  nV_128  7.852787m  TC=0,0
L_V128  nV_127  nV_128  0.073723uH
L_L64  nV_128  NTMP0000000064  6.519695uH
K_K11467  L_L64  L_L65  0.1050
K_K11468  L_L64  L_L66  0.0397
K_K11469  L_L64  L_L67  0.0258
K_K11470  L_L64  L_L68  0.0192
K_K11471  L_L64  L_L69  0.0153
K_K11472  L_L64  L_L70  0.0127
K_K11473  L_L64  L_L71  0.0109
K_K11474  L_L64  L_L72  0.0095
K_K11475  L_L64  L_L73  0.0084
K_K11476  L_L64  L_L74  0.0076
K_K11477  L_L64  L_L75  0.0069
K_K11478  L_L64  L_L76  0.0063
K_K11479  L_L64  L_L77  0.0058
K_K11480  L_L64  L_L78  0.0054
K_K11481  L_L64  L_L79  0.0051
K_K11482  L_L64  L_L80  0.0047
K_K11483  L_L64  L_L81  0.0045
K_K11484  L_L64  L_L82  0.0042
K_K11485  L_L64  L_L83  0.0040
K_K11486  L_L64  L_L84  0.0038
K_K11487  L_L64  L_L85  0.0036
K_K11488  L_L64  L_L86  0.0034
K_K11489  L_L64  L_L87  0.0033
K_K11490  L_L64  L_L88  0.0032
K_K11491  L_L64  L_L89  0.0030
K_K11492  L_L64  L_L90  0.0029
K_K11493  L_L64  L_L91  0.0028
K_K11494  L_L64  L_L92  0.0027
K_K11495  L_L64  L_L93  0.0026
K_K11496  L_L64  L_L94  0.0025
K_K11497  L_L64  L_L95  0.0024
K_K11498  L_L64  L_L96  0.0024
K_K11499  L_L64  L_L97  0.0023
K_K11500  L_L64  L_L98  0.0022
K_K11501  L_L64  L_L99  0.0022
K_K11502  L_L64  L_L100  0.0021
K_K11503  L_L64  L_L101  0.0020
K_K11504  L_L64  L_L102  0.0020
K_K11505  L_L64  L_L103  0.0019
K_K11506  L_L64  L_L104  0.0019
K_K11507  L_L64  L_L105  0.0019
K_K11508  L_L64  L_L106  0.0018
K_K11509  L_L64  L_L107  0.0018
K_K11510  L_L64  L_L108  0.0017
K_K11511  L_L64  L_L109  0.0017
K_K11512  L_L64  L_L110  0.0017
K_K11513  L_L64  L_L111  0.0016
K_K11514  L_L64  L_L112  0.0016
K_K11515  L_L64  L_L113  0.0015
K_K11516  L_L64  L_L114  0.0015
K_K11517  L_L64  L_L115  0.0015
K_K11518  L_L64  L_L116  0.0015
K_K11519  L_L64  L_L117  0.0014
K_K11520  L_L64  L_L118  0.0014
K_K11521  L_L64  L_L119  0.0014
K_K11522  L_L64  L_L120  0.0014
K_K11523  L_L64  L_L121  0.0013
K_K11524  L_L64  L_L122  0.0013
K_K11525  L_L64  L_L123  0.0013
K_K11526  L_L64  L_L124  0.0013
K_K11527  L_L64  L_L125  0.0013
K_K11528  L_L64  L_L126  0.0012
K_K11529  L_L64  L_L127  0.0012
K_K11530  L_L64  L_L128  0.0012
K_K11531  L_L64  L_L129  0.0012
K_K11532  L_L64  L_L130  0.0011
K_K11533  L_L64  L_L131  0.0011
K_K11534  L_L64  L_L132  0.0011
K_K11535  L_L64  L_L133  0.0011
K_K11536  L_L64  L_L134  0.0011
K_K11537  L_L64  L_L135  0.0011
K_K11538  L_L64  L_L136  0.0011
K_K11539  L_L64  L_L137  0.0010
K_K11540  L_L64  L_L138  0.0010
K_K11541  L_L64  L_L139  0.0012
K_K11542  L_L64  L_L140  0.0012
K_K11543  L_L64  L_L141  0.0012
K_K11544  L_L64  L_L142  0.0013
K_K11545  L_L64  L_L143  0.0013
K_K11546  L_L64  L_L144  0.0013
K_K11547  L_L64  L_L145  0.0013
K_K11548  L_L64  L_L146  0.0014
K_K11549  L_L64  L_L147  0.0014
K_K11550  L_L64  L_L148  0.0014
K_K11551  L_L64  L_L149  0.0014
K_K11552  L_L64  L_L150  0.0015
K_K11553  L_L64  L_L151  0.0015
K_K11554  L_L64  L_L152  0.0015
K_K11555  L_L64  L_L153  0.0015
K_K11556  L_L64  L_L154  0.0016
K_K11557  L_L64  L_L155  0.0016
K_K11558  L_L64  L_L156  0.0016
K_K11559  L_L64  L_L157  0.0017
K_K11560  L_L64  L_L158  0.0017
K_K11561  L_L64  L_L159  0.0018
K_K11562  L_L64  L_L160  0.0018
K_K11563  L_L64  L_L161  0.0018
K_K11564  L_L64  L_L162  0.0019
K_K11565  L_L64  L_L163  0.0019
K_K11566  L_L64  L_L164  0.0020
K_K11567  L_L64  L_L165  0.0020
K_K11568  L_L64  L_L166  0.0021
K_K11569  L_L64  L_L167  0.0022
K_K11570  L_L64  L_L168  0.0022
K_K11571  L_L64  L_L169  0.0023
K_K11572  L_L64  L_L170  0.0024
K_K11573  L_L64  L_L171  0.0024
K_K11574  L_L64  L_L172  0.0025
K_K11575  L_L64  L_L173  0.0026
K_K11576  L_L64  L_L174  0.0027
K_K11577  L_L64  L_L175  0.0028
K_K11578  L_L64  L_L176  0.0029
K_K11579  L_L64  L_L177  0.0030
K_K11580  L_L64  L_L178  0.0032
K_K11581  L_L64  L_L179  0.0033
K_K11582  L_L64  L_L180  0.0034
K_K11583  L_L64  L_L181  0.0036
K_K11584  L_L64  L_L182  0.0038
K_K11585  L_L64  L_L183  0.0040
K_K11586  L_L64  L_L184  0.0042
K_K11587  L_L64  L_L185  0.0045
K_K11588  L_L64  L_L186  0.0047
K_K11589  L_L64  L_L187  0.0051
K_K11590  L_L64  L_L188  0.0054
K_K11591  L_L64  L_L189  0.0058
K_K11592  L_L64  L_L190  0.0063
K_K11593  L_L64  L_L191  0.0069
K_K11594  L_L64  L_L192  0.0076
K_K11595  L_L64  L_L193  0.0084
K_K11596  L_L64  L_L194  0.0095
K_K11597  L_L64  L_L195  0.0109
K_K11598  L_L64  L_L196  0.0127
K_K11599  L_L64  L_L197  0.0152
K_K11600  L_L64  L_L198  0.0191
K_K11601  L_L64  L_L199  0.0256
K_K11602  L_L64  L_L200  0.0389
K_K11603  L_L64  L_L201  0.0812
K_K11604  L_L64  L_L202  0.1569
K_K11605  L_L64  L_L203  0.0812
K_K11606  L_L64  L_L204  0.0389
K_K11607  L_L64  L_L205  0.0256
K_K11608  L_L64  L_L206  0.0191
K_K11609  L_L64  L_L207  0.0152
K_K11610  L_L64  L_L208  0.0127
K_K11611  L_L64  L_L209  0.0109
K_K11612  L_L64  L_L210  0.0095
K_K11613  L_L64  L_L211  0.0084
K_K11614  L_L64  L_L212  0.0076
K_K11615  L_L64  L_L213  0.0069
K_K11616  L_L64  L_L214  0.0063
K_K11617  L_L64  L_L215  0.0058
K_K11618  L_L64  L_L216  0.0054
K_K11619  L_L64  L_L217  0.0051
K_K11620  L_L64  L_L218  0.0047
K_K11621  L_L64  L_L219  0.0045
K_K11622  L_L64  L_L220  0.0042
K_K11623  L_L64  L_L221  0.0040
K_K11624  L_L64  L_L222  0.0038
K_K11625  L_L64  L_L223  0.0036
K_K11626  L_L64  L_L224  0.0034
K_K11627  L_L64  L_L225  0.0033
K_K11628  L_L64  L_L226  0.0032
K_K11629  L_L64  L_L227  0.0030
K_K11630  L_L64  L_L228  0.0029
K_K11631  L_L64  L_L229  0.0028
K_K11632  L_L64  L_L230  0.0027
K_K11633  L_L64  L_L231  0.0026
K_K11634  L_L64  L_L232  0.0025
K_K11635  L_L64  L_L233  0.0024
K_K11636  L_L64  L_L234  0.0024
K_K11637  L_L64  L_L235  0.0023
K_K11638  L_L64  L_L236  0.0022
K_K11639  L_L64  L_L237  0.0022
K_K11640  L_L64  L_L238  0.0021
K_K11641  L_L64  L_L239  0.0020
K_K11642  L_L64  L_L240  0.0020
K_K11643  L_L64  L_L241  0.0019
K_K11644  L_L64  L_L242  0.0019
K_K11645  L_L64  L_L243  0.0018
K_K11646  L_L64  L_L244  0.0018
K_K11647  L_L64  L_L245  0.0018
K_K11648  L_L64  L_L246  0.0017
K_K11649  L_L64  L_L247  0.0017
K_K11650  L_L64  L_L248  0.0016
K_K11651  L_L64  L_L249  0.0016
K_K11652  L_L64  L_L250  0.0016
K_K11653  L_L64  L_L251  0.0015
K_K11654  L_L64  L_L252  0.0015
K_K11655  L_L64  L_L253  0.0015
K_K11656  L_L64  L_L254  0.0015
K_K11657  L_L64  L_L255  0.0014
K_K11658  L_L64  L_L256  0.0014
K_K11659  L_L64  L_L257  0.0014
K_K11660  L_L64  L_L258  0.0014
K_K11661  L_L64  L_L259  0.0013
K_K11662  L_L64  L_L260  0.0013
K_K11663  L_L64  L_L261  0.0013
K_K11664  L_L64  L_L262  0.0013
K_K11665  L_L64  L_L263  0.0012
K_K11666  L_L64  L_L264  0.0012
K_K11667  L_L64  L_L265  0.0012
K_K11668  L_L64  L_L266  0.0012
K_K11669  L_L64  L_L267  0.0012
K_K11670  L_L64  L_L268  0.0011
K_K11671  L_L64  L_L269  0.0011
K_K11672  L_L64  L_L270  0.0011
K_K11673  L_L64  L_L271  0.0011
K_K11674  L_L64  L_L272  0.0011
K_K11675  L_L64  L_L273  0.0011
K_K11676  L_L64  L_L274  0.0011
K_K11677  L_L64  L_L275  0.0010
K_K11678  L_L64  L_L276  0.0010
* *  Branch  NTMP0000000064 - NTMP0000000065
R_R65  NTMP0000000064  nU_65  32.914993m  TC=0,0
V_Ui65  nU_65  nR_65  STIMULUS=U_IND_0000000065
R_V129  nR_65  nV_129  23.280268m  TC=0,0
L_V129  nR_65  nV_129  0.014646uH
R_V130  nV_129  nV_130  7.852787m  TC=0,0
L_V130  nV_129  nV_130  0.073723uH
L_L65  nV_130  NTMP0000000065  6.519695uH
K_K11679  L_L65  L_L66  0.1050
K_K11680  L_L65  L_L67  0.0397
K_K11681  L_L65  L_L68  0.0258
K_K11682  L_L65  L_L69  0.0192
K_K11683  L_L65  L_L70  0.0153
K_K11684  L_L65  L_L71  0.0127
K_K11685  L_L65  L_L72  0.0109
K_K11686  L_L65  L_L73  0.0095
K_K11687  L_L65  L_L74  0.0084
K_K11688  L_L65  L_L75  0.0076
K_K11689  L_L65  L_L76  0.0069
K_K11690  L_L65  L_L77  0.0063
K_K11691  L_L65  L_L78  0.0058
K_K11692  L_L65  L_L79  0.0054
K_K11693  L_L65  L_L80  0.0051
K_K11694  L_L65  L_L81  0.0047
K_K11695  L_L65  L_L82  0.0045
K_K11696  L_L65  L_L83  0.0042
K_K11697  L_L65  L_L84  0.0040
K_K11698  L_L65  L_L85  0.0038
K_K11699  L_L65  L_L86  0.0036
K_K11700  L_L65  L_L87  0.0034
K_K11701  L_L65  L_L88  0.0033
K_K11702  L_L65  L_L89  0.0032
K_K11703  L_L65  L_L90  0.0030
K_K11704  L_L65  L_L91  0.0029
K_K11705  L_L65  L_L92  0.0028
K_K11706  L_L65  L_L93  0.0027
K_K11707  L_L65  L_L94  0.0026
K_K11708  L_L65  L_L95  0.0025
K_K11709  L_L65  L_L96  0.0024
K_K11710  L_L65  L_L97  0.0024
K_K11711  L_L65  L_L98  0.0023
K_K11712  L_L65  L_L99  0.0022
K_K11713  L_L65  L_L100  0.0022
K_K11714  L_L65  L_L101  0.0021
K_K11715  L_L65  L_L102  0.0020
K_K11716  L_L65  L_L103  0.0020
K_K11717  L_L65  L_L104  0.0019
K_K11718  L_L65  L_L105  0.0019
K_K11719  L_L65  L_L106  0.0019
K_K11720  L_L65  L_L107  0.0018
K_K11721  L_L65  L_L108  0.0018
K_K11722  L_L65  L_L109  0.0017
K_K11723  L_L65  L_L110  0.0017
K_K11724  L_L65  L_L111  0.0017
K_K11725  L_L65  L_L112  0.0016
K_K11726  L_L65  L_L113  0.0016
K_K11727  L_L65  L_L114  0.0015
K_K11728  L_L65  L_L115  0.0015
K_K11729  L_L65  L_L116  0.0015
K_K11730  L_L65  L_L117  0.0015
K_K11731  L_L65  L_L118  0.0014
K_K11732  L_L65  L_L119  0.0014
K_K11733  L_L65  L_L120  0.0014
K_K11734  L_L65  L_L121  0.0014
K_K11735  L_L65  L_L122  0.0013
K_K11736  L_L65  L_L123  0.0013
K_K11737  L_L65  L_L124  0.0013
K_K11738  L_L65  L_L125  0.0013
K_K11739  L_L65  L_L126  0.0013
K_K11740  L_L65  L_L127  0.0012
K_K11741  L_L65  L_L128  0.0012
K_K11742  L_L65  L_L129  0.0012
K_K11743  L_L65  L_L130  0.0012
K_K11744  L_L65  L_L131  0.0011
K_K11745  L_L65  L_L132  0.0011
K_K11746  L_L65  L_L133  0.0011
K_K11747  L_L65  L_L134  0.0011
K_K11748  L_L65  L_L135  0.0011
K_K11749  L_L65  L_L136  0.0011
K_K11750  L_L65  L_L137  0.0011
K_K11751  L_L65  L_L138  0.0010
K_K11752  L_L65  L_L139  0.0012
K_K11753  L_L65  L_L140  0.0012
K_K11754  L_L65  L_L141  0.0012
K_K11755  L_L65  L_L142  0.0012
K_K11756  L_L65  L_L143  0.0013
K_K11757  L_L65  L_L144  0.0013
K_K11758  L_L65  L_L145  0.0013
K_K11759  L_L65  L_L146  0.0013
K_K11760  L_L65  L_L147  0.0014
K_K11761  L_L65  L_L148  0.0014
K_K11762  L_L65  L_L149  0.0014
K_K11763  L_L65  L_L150  0.0014
K_K11764  L_L65  L_L151  0.0015
K_K11765  L_L65  L_L152  0.0015
K_K11766  L_L65  L_L153  0.0015
K_K11767  L_L65  L_L154  0.0015
K_K11768  L_L65  L_L155  0.0016
K_K11769  L_L65  L_L156  0.0016
K_K11770  L_L65  L_L157  0.0016
K_K11771  L_L65  L_L158  0.0017
K_K11772  L_L65  L_L159  0.0017
K_K11773  L_L65  L_L160  0.0018
K_K11774  L_L65  L_L161  0.0018
K_K11775  L_L65  L_L162  0.0018
K_K11776  L_L65  L_L163  0.0019
K_K11777  L_L65  L_L164  0.0019
K_K11778  L_L65  L_L165  0.0020
K_K11779  L_L65  L_L166  0.0020
K_K11780  L_L65  L_L167  0.0021
K_K11781  L_L65  L_L168  0.0022
K_K11782  L_L65  L_L169  0.0022
K_K11783  L_L65  L_L170  0.0023
K_K11784  L_L65  L_L171  0.0024
K_K11785  L_L65  L_L172  0.0024
K_K11786  L_L65  L_L173  0.0025
K_K11787  L_L65  L_L174  0.0026
K_K11788  L_L65  L_L175  0.0027
K_K11789  L_L65  L_L176  0.0028
K_K11790  L_L65  L_L177  0.0029
K_K11791  L_L65  L_L178  0.0030
K_K11792  L_L65  L_L179  0.0032
K_K11793  L_L65  L_L180  0.0033
K_K11794  L_L65  L_L181  0.0034
K_K11795  L_L65  L_L182  0.0036
K_K11796  L_L65  L_L183  0.0038
K_K11797  L_L65  L_L184  0.0040
K_K11798  L_L65  L_L185  0.0042
K_K11799  L_L65  L_L186  0.0045
K_K11800  L_L65  L_L187  0.0047
K_K11801  L_L65  L_L188  0.0051
K_K11802  L_L65  L_L189  0.0054
K_K11803  L_L65  L_L190  0.0058
K_K11804  L_L65  L_L191  0.0063
K_K11805  L_L65  L_L192  0.0069
K_K11806  L_L65  L_L193  0.0076
K_K11807  L_L65  L_L194  0.0084
K_K11808  L_L65  L_L195  0.0095
K_K11809  L_L65  L_L196  0.0109
K_K11810  L_L65  L_L197  0.0127
K_K11811  L_L65  L_L198  0.0152
K_K11812  L_L65  L_L199  0.0191
K_K11813  L_L65  L_L200  0.0256
K_K11814  L_L65  L_L201  0.0389
K_K11815  L_L65  L_L202  0.0812
K_K11816  L_L65  L_L203  0.1569
K_K11817  L_L65  L_L204  0.0812
K_K11818  L_L65  L_L205  0.0389
K_K11819  L_L65  L_L206  0.0256
K_K11820  L_L65  L_L207  0.0191
K_K11821  L_L65  L_L208  0.0152
K_K11822  L_L65  L_L209  0.0127
K_K11823  L_L65  L_L210  0.0109
K_K11824  L_L65  L_L211  0.0095
K_K11825  L_L65  L_L212  0.0084
K_K11826  L_L65  L_L213  0.0076
K_K11827  L_L65  L_L214  0.0069
K_K11828  L_L65  L_L215  0.0063
K_K11829  L_L65  L_L216  0.0058
K_K11830  L_L65  L_L217  0.0054
K_K11831  L_L65  L_L218  0.0051
K_K11832  L_L65  L_L219  0.0047
K_K11833  L_L65  L_L220  0.0045
K_K11834  L_L65  L_L221  0.0042
K_K11835  L_L65  L_L222  0.0040
K_K11836  L_L65  L_L223  0.0038
K_K11837  L_L65  L_L224  0.0036
K_K11838  L_L65  L_L225  0.0034
K_K11839  L_L65  L_L226  0.0033
K_K11840  L_L65  L_L227  0.0032
K_K11841  L_L65  L_L228  0.0030
K_K11842  L_L65  L_L229  0.0029
K_K11843  L_L65  L_L230  0.0028
K_K11844  L_L65  L_L231  0.0027
K_K11845  L_L65  L_L232  0.0026
K_K11846  L_L65  L_L233  0.0025
K_K11847  L_L65  L_L234  0.0024
K_K11848  L_L65  L_L235  0.0024
K_K11849  L_L65  L_L236  0.0023
K_K11850  L_L65  L_L237  0.0022
K_K11851  L_L65  L_L238  0.0022
K_K11852  L_L65  L_L239  0.0021
K_K11853  L_L65  L_L240  0.0020
K_K11854  L_L65  L_L241  0.0020
K_K11855  L_L65  L_L242  0.0019
K_K11856  L_L65  L_L243  0.0019
K_K11857  L_L65  L_L244  0.0018
K_K11858  L_L65  L_L245  0.0018
K_K11859  L_L65  L_L246  0.0018
K_K11860  L_L65  L_L247  0.0017
K_K11861  L_L65  L_L248  0.0017
K_K11862  L_L65  L_L249  0.0016
K_K11863  L_L65  L_L250  0.0016
K_K11864  L_L65  L_L251  0.0016
K_K11865  L_L65  L_L252  0.0015
K_K11866  L_L65  L_L253  0.0015
K_K11867  L_L65  L_L254  0.0015
K_K11868  L_L65  L_L255  0.0015
K_K11869  L_L65  L_L256  0.0014
K_K11870  L_L65  L_L257  0.0014
K_K11871  L_L65  L_L258  0.0014
K_K11872  L_L65  L_L259  0.0014
K_K11873  L_L65  L_L260  0.0013
K_K11874  L_L65  L_L261  0.0013
K_K11875  L_L65  L_L262  0.0013
K_K11876  L_L65  L_L263  0.0013
K_K11877  L_L65  L_L264  0.0012
K_K11878  L_L65  L_L265  0.0012
K_K11879  L_L65  L_L266  0.0012
K_K11880  L_L65  L_L267  0.0012
K_K11881  L_L65  L_L268  0.0012
K_K11882  L_L65  L_L269  0.0011
K_K11883  L_L65  L_L270  0.0011
K_K11884  L_L65  L_L271  0.0011
K_K11885  L_L65  L_L272  0.0011
K_K11886  L_L65  L_L273  0.0011
K_K11887  L_L65  L_L274  0.0011
K_K11888  L_L65  L_L275  0.0011
K_K11889  L_L65  L_L276  0.0010
* *  Branch  NTMP0000000065 - NTMP0000000066
R_R66  NTMP0000000065  nU_66  32.914993m  TC=0,0
V_Ui66  nU_66  nR_66  STIMULUS=U_IND_0000000066
R_V131  nR_66  nV_131  23.280268m  TC=0,0
L_V131  nR_66  nV_131  0.014646uH
R_V132  nV_131  nV_132  7.852787m  TC=0,0
L_V132  nV_131  nV_132  0.073723uH
L_L66  nV_132  NTMP0000000066  6.519695uH
K_K11890  L_L66  L_L67  0.1050
K_K11891  L_L66  L_L68  0.0397
K_K11892  L_L66  L_L69  0.0258
K_K11893  L_L66  L_L70  0.0192
K_K11894  L_L66  L_L71  0.0153
K_K11895  L_L66  L_L72  0.0127
K_K11896  L_L66  L_L73  0.0109
K_K11897  L_L66  L_L74  0.0095
K_K11898  L_L66  L_L75  0.0084
K_K11899  L_L66  L_L76  0.0076
K_K11900  L_L66  L_L77  0.0069
K_K11901  L_L66  L_L78  0.0063
K_K11902  L_L66  L_L79  0.0058
K_K11903  L_L66  L_L80  0.0054
K_K11904  L_L66  L_L81  0.0051
K_K11905  L_L66  L_L82  0.0047
K_K11906  L_L66  L_L83  0.0045
K_K11907  L_L66  L_L84  0.0042
K_K11908  L_L66  L_L85  0.0040
K_K11909  L_L66  L_L86  0.0038
K_K11910  L_L66  L_L87  0.0036
K_K11911  L_L66  L_L88  0.0034
K_K11912  L_L66  L_L89  0.0033
K_K11913  L_L66  L_L90  0.0032
K_K11914  L_L66  L_L91  0.0030
K_K11915  L_L66  L_L92  0.0029
K_K11916  L_L66  L_L93  0.0028
K_K11917  L_L66  L_L94  0.0027
K_K11918  L_L66  L_L95  0.0026
K_K11919  L_L66  L_L96  0.0025
K_K11920  L_L66  L_L97  0.0024
K_K11921  L_L66  L_L98  0.0024
K_K11922  L_L66  L_L99  0.0023
K_K11923  L_L66  L_L100  0.0022
K_K11924  L_L66  L_L101  0.0022
K_K11925  L_L66  L_L102  0.0021
K_K11926  L_L66  L_L103  0.0020
K_K11927  L_L66  L_L104  0.0020
K_K11928  L_L66  L_L105  0.0019
K_K11929  L_L66  L_L106  0.0019
K_K11930  L_L66  L_L107  0.0019
K_K11931  L_L66  L_L108  0.0018
K_K11932  L_L66  L_L109  0.0018
K_K11933  L_L66  L_L110  0.0017
K_K11934  L_L66  L_L111  0.0017
K_K11935  L_L66  L_L112  0.0017
K_K11936  L_L66  L_L113  0.0016
K_K11937  L_L66  L_L114  0.0016
K_K11938  L_L66  L_L115  0.0015
K_K11939  L_L66  L_L116  0.0015
K_K11940  L_L66  L_L117  0.0015
K_K11941  L_L66  L_L118  0.0015
K_K11942  L_L66  L_L119  0.0014
K_K11943  L_L66  L_L120  0.0014
K_K11944  L_L66  L_L121  0.0014
K_K11945  L_L66  L_L122  0.0014
K_K11946  L_L66  L_L123  0.0013
K_K11947  L_L66  L_L124  0.0013
K_K11948  L_L66  L_L125  0.0013
K_K11949  L_L66  L_L126  0.0013
K_K11950  L_L66  L_L127  0.0013
K_K11951  L_L66  L_L128  0.0012
K_K11952  L_L66  L_L129  0.0012
K_K11953  L_L66  L_L130  0.0012
K_K11954  L_L66  L_L131  0.0012
K_K11955  L_L66  L_L132  0.0011
K_K11956  L_L66  L_L133  0.0011
K_K11957  L_L66  L_L134  0.0011
K_K11958  L_L66  L_L135  0.0011
K_K11959  L_L66  L_L136  0.0011
K_K11960  L_L66  L_L137  0.0011
K_K11961  L_L66  L_L138  0.0011
K_K11962  L_L66  L_L139  0.0012
K_K11963  L_L66  L_L140  0.0012
K_K11964  L_L66  L_L141  0.0012
K_K11965  L_L66  L_L142  0.0012
K_K11966  L_L66  L_L143  0.0012
K_K11967  L_L66  L_L144  0.0013
K_K11968  L_L66  L_L145  0.0013
K_K11969  L_L66  L_L146  0.0013
K_K11970  L_L66  L_L147  0.0013
K_K11971  L_L66  L_L148  0.0014
K_K11972  L_L66  L_L149  0.0014
K_K11973  L_L66  L_L150  0.0014
K_K11974  L_L66  L_L151  0.0014
K_K11975  L_L66  L_L152  0.0015
K_K11976  L_L66  L_L153  0.0015
K_K11977  L_L66  L_L154  0.0015
K_K11978  L_L66  L_L155  0.0015
K_K11979  L_L66  L_L156  0.0016
K_K11980  L_L66  L_L157  0.0016
K_K11981  L_L66  L_L158  0.0016
K_K11982  L_L66  L_L159  0.0017
K_K11983  L_L66  L_L160  0.0017
K_K11984  L_L66  L_L161  0.0018
K_K11985  L_L66  L_L162  0.0018
K_K11986  L_L66  L_L163  0.0018
K_K11987  L_L66  L_L164  0.0019
K_K11988  L_L66  L_L165  0.0019
K_K11989  L_L66  L_L166  0.0020
K_K11990  L_L66  L_L167  0.0020
K_K11991  L_L66  L_L168  0.0021
K_K11992  L_L66  L_L169  0.0022
K_K11993  L_L66  L_L170  0.0022
K_K11994  L_L66  L_L171  0.0023
K_K11995  L_L66  L_L172  0.0024
K_K11996  L_L66  L_L173  0.0024
K_K11997  L_L66  L_L174  0.0025
K_K11998  L_L66  L_L175  0.0026
K_K11999  L_L66  L_L176  0.0027
K_K12000  L_L66  L_L177  0.0028
K_K12001  L_L66  L_L178  0.0029
K_K12002  L_L66  L_L179  0.0030
K_K12003  L_L66  L_L180  0.0032
K_K12004  L_L66  L_L181  0.0033
K_K12005  L_L66  L_L182  0.0034
K_K12006  L_L66  L_L183  0.0036
K_K12007  L_L66  L_L184  0.0038
K_K12008  L_L66  L_L185  0.0040
K_K12009  L_L66  L_L186  0.0042
K_K12010  L_L66  L_L187  0.0045
K_K12011  L_L66  L_L188  0.0047
K_K12012  L_L66  L_L189  0.0051
K_K12013  L_L66  L_L190  0.0054
K_K12014  L_L66  L_L191  0.0058
K_K12015  L_L66  L_L192  0.0063
K_K12016  L_L66  L_L193  0.0069
K_K12017  L_L66  L_L194  0.0076
K_K12018  L_L66  L_L195  0.0084
K_K12019  L_L66  L_L196  0.0095
K_K12020  L_L66  L_L197  0.0109
K_K12021  L_L66  L_L198  0.0127
K_K12022  L_L66  L_L199  0.0152
K_K12023  L_L66  L_L200  0.0191
K_K12024  L_L66  L_L201  0.0256
K_K12025  L_L66  L_L202  0.0389
K_K12026  L_L66  L_L203  0.0812
K_K12027  L_L66  L_L204  0.1569
K_K12028  L_L66  L_L205  0.0812
K_K12029  L_L66  L_L206  0.0389
K_K12030  L_L66  L_L207  0.0256
K_K12031  L_L66  L_L208  0.0191
K_K12032  L_L66  L_L209  0.0152
K_K12033  L_L66  L_L210  0.0127
K_K12034  L_L66  L_L211  0.0109
K_K12035  L_L66  L_L212  0.0095
K_K12036  L_L66  L_L213  0.0084
K_K12037  L_L66  L_L214  0.0076
K_K12038  L_L66  L_L215  0.0069
K_K12039  L_L66  L_L216  0.0063
K_K12040  L_L66  L_L217  0.0058
K_K12041  L_L66  L_L218  0.0054
K_K12042  L_L66  L_L219  0.0051
K_K12043  L_L66  L_L220  0.0047
K_K12044  L_L66  L_L221  0.0045
K_K12045  L_L66  L_L222  0.0042
K_K12046  L_L66  L_L223  0.0040
K_K12047  L_L66  L_L224  0.0038
K_K12048  L_L66  L_L225  0.0036
K_K12049  L_L66  L_L226  0.0034
K_K12050  L_L66  L_L227  0.0033
K_K12051  L_L66  L_L228  0.0032
K_K12052  L_L66  L_L229  0.0030
K_K12053  L_L66  L_L230  0.0029
K_K12054  L_L66  L_L231  0.0028
K_K12055  L_L66  L_L232  0.0027
K_K12056  L_L66  L_L233  0.0026
K_K12057  L_L66  L_L234  0.0025
K_K12058  L_L66  L_L235  0.0024
K_K12059  L_L66  L_L236  0.0024
K_K12060  L_L66  L_L237  0.0023
K_K12061  L_L66  L_L238  0.0022
K_K12062  L_L66  L_L239  0.0022
K_K12063  L_L66  L_L240  0.0021
K_K12064  L_L66  L_L241  0.0020
K_K12065  L_L66  L_L242  0.0020
K_K12066  L_L66  L_L243  0.0019
K_K12067  L_L66  L_L244  0.0019
K_K12068  L_L66  L_L245  0.0018
K_K12069  L_L66  L_L246  0.0018
K_K12070  L_L66  L_L247  0.0018
K_K12071  L_L66  L_L248  0.0017
K_K12072  L_L66  L_L249  0.0017
K_K12073  L_L66  L_L250  0.0016
K_K12074  L_L66  L_L251  0.0016
K_K12075  L_L66  L_L252  0.0016
K_K12076  L_L66  L_L253  0.0015
K_K12077  L_L66  L_L254  0.0015
K_K12078  L_L66  L_L255  0.0015
K_K12079  L_L66  L_L256  0.0015
K_K12080  L_L66  L_L257  0.0014
K_K12081  L_L66  L_L258  0.0014
K_K12082  L_L66  L_L259  0.0014
K_K12083  L_L66  L_L260  0.0014
K_K12084  L_L66  L_L261  0.0013
K_K12085  L_L66  L_L262  0.0013
K_K12086  L_L66  L_L263  0.0013
K_K12087  L_L66  L_L264  0.0013
K_K12088  L_L66  L_L265  0.0012
K_K12089  L_L66  L_L266  0.0012
K_K12090  L_L66  L_L267  0.0012
K_K12091  L_L66  L_L268  0.0012
K_K12092  L_L66  L_L269  0.0012
K_K12093  L_L66  L_L270  0.0011
K_K12094  L_L66  L_L271  0.0011
K_K12095  L_L66  L_L272  0.0011
K_K12096  L_L66  L_L273  0.0011
K_K12097  L_L66  L_L274  0.0011
K_K12098  L_L66  L_L275  0.0011
K_K12099  L_L66  L_L276  0.0011
* *  Branch  NTMP0000000066 - NTMP0000000067
R_R67  NTMP0000000066  nU_67  32.914993m  TC=0,0
V_Ui67  nU_67  nR_67  STIMULUS=U_IND_0000000067
R_V133  nR_67  nV_133  23.280268m  TC=0,0
L_V133  nR_67  nV_133  0.014646uH
R_V134  nV_133  nV_134  7.852787m  TC=0,0
L_V134  nV_133  nV_134  0.073723uH
L_L67  nV_134  NTMP0000000067  6.519695uH
K_K12100  L_L67  L_L68  0.1050
K_K12101  L_L67  L_L69  0.0397
K_K12102  L_L67  L_L70  0.0258
K_K12103  L_L67  L_L71  0.0192
K_K12104  L_L67  L_L72  0.0153
K_K12105  L_L67  L_L73  0.0127
K_K12106  L_L67  L_L74  0.0109
K_K12107  L_L67  L_L75  0.0095
K_K12108  L_L67  L_L76  0.0084
K_K12109  L_L67  L_L77  0.0076
K_K12110  L_L67  L_L78  0.0069
K_K12111  L_L67  L_L79  0.0063
K_K12112  L_L67  L_L80  0.0058
K_K12113  L_L67  L_L81  0.0054
K_K12114  L_L67  L_L82  0.0051
K_K12115  L_L67  L_L83  0.0047
K_K12116  L_L67  L_L84  0.0045
K_K12117  L_L67  L_L85  0.0042
K_K12118  L_L67  L_L86  0.0040
K_K12119  L_L67  L_L87  0.0038
K_K12120  L_L67  L_L88  0.0036
K_K12121  L_L67  L_L89  0.0034
K_K12122  L_L67  L_L90  0.0033
K_K12123  L_L67  L_L91  0.0032
K_K12124  L_L67  L_L92  0.0030
K_K12125  L_L67  L_L93  0.0029
K_K12126  L_L67  L_L94  0.0028
K_K12127  L_L67  L_L95  0.0027
K_K12128  L_L67  L_L96  0.0026
K_K12129  L_L67  L_L97  0.0025
K_K12130  L_L67  L_L98  0.0024
K_K12131  L_L67  L_L99  0.0024
K_K12132  L_L67  L_L100  0.0023
K_K12133  L_L67  L_L101  0.0022
K_K12134  L_L67  L_L102  0.0022
K_K12135  L_L67  L_L103  0.0021
K_K12136  L_L67  L_L104  0.0020
K_K12137  L_L67  L_L105  0.0020
K_K12138  L_L67  L_L106  0.0019
K_K12139  L_L67  L_L107  0.0019
K_K12140  L_L67  L_L108  0.0019
K_K12141  L_L67  L_L109  0.0018
K_K12142  L_L67  L_L110  0.0018
K_K12143  L_L67  L_L111  0.0017
K_K12144  L_L67  L_L112  0.0017
K_K12145  L_L67  L_L113  0.0016
K_K12146  L_L67  L_L114  0.0016
K_K12147  L_L67  L_L115  0.0016
K_K12148  L_L67  L_L116  0.0015
K_K12149  L_L67  L_L117  0.0015
K_K12150  L_L67  L_L118  0.0015
K_K12151  L_L67  L_L119  0.0015
K_K12152  L_L67  L_L120  0.0014
K_K12153  L_L67  L_L121  0.0014
K_K12154  L_L67  L_L122  0.0014
K_K12155  L_L67  L_L123  0.0014
K_K12156  L_L67  L_L124  0.0013
K_K12157  L_L67  L_L125  0.0013
K_K12158  L_L67  L_L126  0.0013
K_K12159  L_L67  L_L127  0.0013
K_K12160  L_L67  L_L128  0.0013
K_K12161  L_L67  L_L129  0.0012
K_K12162  L_L67  L_L130  0.0012
K_K12163  L_L67  L_L131  0.0012
K_K12164  L_L67  L_L132  0.0012
K_K12165  L_L67  L_L133  0.0011
K_K12166  L_L67  L_L134  0.0011
K_K12167  L_L67  L_L135  0.0011
K_K12168  L_L67  L_L136  0.0011
K_K12169  L_L67  L_L137  0.0011
K_K12170  L_L67  L_L138  0.0011
K_K12171  L_L67  L_L139  0.0011
K_K12172  L_L67  L_L140  0.0012
K_K12173  L_L67  L_L141  0.0012
K_K12174  L_L67  L_L142  0.0012
K_K12175  L_L67  L_L143  0.0012
K_K12176  L_L67  L_L144  0.0012
K_K12177  L_L67  L_L145  0.0013
K_K12178  L_L67  L_L146  0.0013
K_K12179  L_L67  L_L147  0.0013
K_K12180  L_L67  L_L148  0.0013
K_K12181  L_L67  L_L149  0.0014
K_K12182  L_L67  L_L150  0.0014
K_K12183  L_L67  L_L151  0.0014
K_K12184  L_L67  L_L152  0.0014
K_K12185  L_L67  L_L153  0.0015
K_K12186  L_L67  L_L154  0.0015
K_K12187  L_L67  L_L155  0.0015
K_K12188  L_L67  L_L156  0.0015
K_K12189  L_L67  L_L157  0.0016
K_K12190  L_L67  L_L158  0.0016
K_K12191  L_L67  L_L159  0.0016
K_K12192  L_L67  L_L160  0.0017
K_K12193  L_L67  L_L161  0.0017
K_K12194  L_L67  L_L162  0.0018
K_K12195  L_L67  L_L163  0.0018
K_K12196  L_L67  L_L164  0.0018
K_K12197  L_L67  L_L165  0.0019
K_K12198  L_L67  L_L166  0.0019
K_K12199  L_L67  L_L167  0.0020
K_K12200  L_L67  L_L168  0.0020
K_K12201  L_L67  L_L169  0.0021
K_K12202  L_L67  L_L170  0.0022
K_K12203  L_L67  L_L171  0.0022
K_K12204  L_L67  L_L172  0.0023
K_K12205  L_L67  L_L173  0.0024
K_K12206  L_L67  L_L174  0.0024
K_K12207  L_L67  L_L175  0.0025
K_K12208  L_L67  L_L176  0.0026
K_K12209  L_L67  L_L177  0.0027
K_K12210  L_L67  L_L178  0.0028
K_K12211  L_L67  L_L179  0.0029
K_K12212  L_L67  L_L180  0.0030
K_K12213  L_L67  L_L181  0.0032
K_K12214  L_L67  L_L182  0.0033
K_K12215  L_L67  L_L183  0.0034
K_K12216  L_L67  L_L184  0.0036
K_K12217  L_L67  L_L185  0.0038
K_K12218  L_L67  L_L186  0.0040
K_K12219  L_L67  L_L187  0.0042
K_K12220  L_L67  L_L188  0.0045
K_K12221  L_L67  L_L189  0.0047
K_K12222  L_L67  L_L190  0.0051
K_K12223  L_L67  L_L191  0.0054
K_K12224  L_L67  L_L192  0.0058
K_K12225  L_L67  L_L193  0.0063
K_K12226  L_L67  L_L194  0.0069
K_K12227  L_L67  L_L195  0.0076
K_K12228  L_L67  L_L196  0.0084
K_K12229  L_L67  L_L197  0.0095
K_K12230  L_L67  L_L198  0.0109
K_K12231  L_L67  L_L199  0.0127
K_K12232  L_L67  L_L200  0.0152
K_K12233  L_L67  L_L201  0.0191
K_K12234  L_L67  L_L202  0.0256
K_K12235  L_L67  L_L203  0.0389
K_K12236  L_L67  L_L204  0.0812
K_K12237  L_L67  L_L205  0.1569
K_K12238  L_L67  L_L206  0.0812
K_K12239  L_L67  L_L207  0.0389
K_K12240  L_L67  L_L208  0.0256
K_K12241  L_L67  L_L209  0.0191
K_K12242  L_L67  L_L210  0.0152
K_K12243  L_L67  L_L211  0.0127
K_K12244  L_L67  L_L212  0.0109
K_K12245  L_L67  L_L213  0.0095
K_K12246  L_L67  L_L214  0.0084
K_K12247  L_L67  L_L215  0.0076
K_K12248  L_L67  L_L216  0.0069
K_K12249  L_L67  L_L217  0.0063
K_K12250  L_L67  L_L218  0.0058
K_K12251  L_L67  L_L219  0.0054
K_K12252  L_L67  L_L220  0.0051
K_K12253  L_L67  L_L221  0.0047
K_K12254  L_L67  L_L222  0.0045
K_K12255  L_L67  L_L223  0.0042
K_K12256  L_L67  L_L224  0.0040
K_K12257  L_L67  L_L225  0.0038
K_K12258  L_L67  L_L226  0.0036
K_K12259  L_L67  L_L227  0.0034
K_K12260  L_L67  L_L228  0.0033
K_K12261  L_L67  L_L229  0.0032
K_K12262  L_L67  L_L230  0.0030
K_K12263  L_L67  L_L231  0.0029
K_K12264  L_L67  L_L232  0.0028
K_K12265  L_L67  L_L233  0.0027
K_K12266  L_L67  L_L234  0.0026
K_K12267  L_L67  L_L235  0.0025
K_K12268  L_L67  L_L236  0.0024
K_K12269  L_L67  L_L237  0.0024
K_K12270  L_L67  L_L238  0.0023
K_K12271  L_L67  L_L239  0.0022
K_K12272  L_L67  L_L240  0.0022
K_K12273  L_L67  L_L241  0.0021
K_K12274  L_L67  L_L242  0.0020
K_K12275  L_L67  L_L243  0.0020
K_K12276  L_L67  L_L244  0.0019
K_K12277  L_L67  L_L245  0.0019
K_K12278  L_L67  L_L246  0.0018
K_K12279  L_L67  L_L247  0.0018
K_K12280  L_L67  L_L248  0.0018
K_K12281  L_L67  L_L249  0.0017
K_K12282  L_L67  L_L250  0.0017
K_K12283  L_L67  L_L251  0.0016
K_K12284  L_L67  L_L252  0.0016
K_K12285  L_L67  L_L253  0.0016
K_K12286  L_L67  L_L254  0.0015
K_K12287  L_L67  L_L255  0.0015
K_K12288  L_L67  L_L256  0.0015
K_K12289  L_L67  L_L257  0.0015
K_K12290  L_L67  L_L258  0.0014
K_K12291  L_L67  L_L259  0.0014
K_K12292  L_L67  L_L260  0.0014
K_K12293  L_L67  L_L261  0.0014
K_K12294  L_L67  L_L262  0.0013
K_K12295  L_L67  L_L263  0.0013
K_K12296  L_L67  L_L264  0.0013
K_K12297  L_L67  L_L265  0.0013
K_K12298  L_L67  L_L266  0.0012
K_K12299  L_L67  L_L267  0.0012
K_K12300  L_L67  L_L268  0.0012
K_K12301  L_L67  L_L269  0.0012
K_K12302  L_L67  L_L270  0.0012
K_K12303  L_L67  L_L271  0.0011
K_K12304  L_L67  L_L272  0.0011
K_K12305  L_L67  L_L273  0.0011
K_K12306  L_L67  L_L274  0.0011
K_K12307  L_L67  L_L275  0.0011
K_K12308  L_L67  L_L276  0.0011
* *  Branch  NTMP0000000067 - NTMP0000000068
R_R68  NTMP0000000067  nU_68  32.914993m  TC=0,0
V_Ui68  nU_68  nR_68  STIMULUS=U_IND_0000000068
R_V135  nR_68  nV_135  23.280268m  TC=0,0
L_V135  nR_68  nV_135  0.014646uH
R_V136  nV_135  nV_136  7.852787m  TC=0,0
L_V136  nV_135  nV_136  0.073723uH
L_L68  nV_136  NTMP0000000068  6.519695uH
K_K12309  L_L68  L_L69  0.1050
K_K12310  L_L68  L_L70  0.0397
K_K12311  L_L68  L_L71  0.0258
K_K12312  L_L68  L_L72  0.0192
K_K12313  L_L68  L_L73  0.0153
K_K12314  L_L68  L_L74  0.0127
K_K12315  L_L68  L_L75  0.0109
K_K12316  L_L68  L_L76  0.0095
K_K12317  L_L68  L_L77  0.0084
K_K12318  L_L68  L_L78  0.0076
K_K12319  L_L68  L_L79  0.0069
K_K12320  L_L68  L_L80  0.0063
K_K12321  L_L68  L_L81  0.0058
K_K12322  L_L68  L_L82  0.0054
K_K12323  L_L68  L_L83  0.0051
K_K12324  L_L68  L_L84  0.0047
K_K12325  L_L68  L_L85  0.0045
K_K12326  L_L68  L_L86  0.0042
K_K12327  L_L68  L_L87  0.0040
K_K12328  L_L68  L_L88  0.0038
K_K12329  L_L68  L_L89  0.0036
K_K12330  L_L68  L_L90  0.0034
K_K12331  L_L68  L_L91  0.0033
K_K12332  L_L68  L_L92  0.0032
K_K12333  L_L68  L_L93  0.0030
K_K12334  L_L68  L_L94  0.0029
K_K12335  L_L68  L_L95  0.0028
K_K12336  L_L68  L_L96  0.0027
K_K12337  L_L68  L_L97  0.0026
K_K12338  L_L68  L_L98  0.0025
K_K12339  L_L68  L_L99  0.0024
K_K12340  L_L68  L_L100  0.0024
K_K12341  L_L68  L_L101  0.0023
K_K12342  L_L68  L_L102  0.0022
K_K12343  L_L68  L_L103  0.0022
K_K12344  L_L68  L_L104  0.0021
K_K12345  L_L68  L_L105  0.0020
K_K12346  L_L68  L_L106  0.0020
K_K12347  L_L68  L_L107  0.0019
K_K12348  L_L68  L_L108  0.0019
K_K12349  L_L68  L_L109  0.0019
K_K12350  L_L68  L_L110  0.0018
K_K12351  L_L68  L_L111  0.0018
K_K12352  L_L68  L_L112  0.0017
K_K12353  L_L68  L_L113  0.0017
K_K12354  L_L68  L_L114  0.0016
K_K12355  L_L68  L_L115  0.0016
K_K12356  L_L68  L_L116  0.0016
K_K12357  L_L68  L_L117  0.0015
K_K12358  L_L68  L_L118  0.0015
K_K12359  L_L68  L_L119  0.0015
K_K12360  L_L68  L_L120  0.0015
K_K12361  L_L68  L_L121  0.0014
K_K12362  L_L68  L_L122  0.0014
K_K12363  L_L68  L_L123  0.0014
K_K12364  L_L68  L_L124  0.0014
K_K12365  L_L68  L_L125  0.0013
K_K12366  L_L68  L_L126  0.0013
K_K12367  L_L68  L_L127  0.0013
K_K12368  L_L68  L_L128  0.0013
K_K12369  L_L68  L_L129  0.0013
K_K12370  L_L68  L_L130  0.0012
K_K12371  L_L68  L_L131  0.0012
K_K12372  L_L68  L_L132  0.0012
K_K12373  L_L68  L_L133  0.0012
K_K12374  L_L68  L_L134  0.0011
K_K12375  L_L68  L_L135  0.0011
K_K12376  L_L68  L_L136  0.0011
K_K12377  L_L68  L_L137  0.0011
K_K12378  L_L68  L_L138  0.0011
K_K12379  L_L68  L_L139  0.0011
K_K12380  L_L68  L_L140  0.0011
K_K12381  L_L68  L_L141  0.0012
K_K12382  L_L68  L_L142  0.0012
K_K12383  L_L68  L_L143  0.0012
K_K12384  L_L68  L_L144  0.0012
K_K12385  L_L68  L_L145  0.0012
K_K12386  L_L68  L_L146  0.0013
K_K12387  L_L68  L_L147  0.0013
K_K12388  L_L68  L_L148  0.0013
K_K12389  L_L68  L_L149  0.0013
K_K12390  L_L68  L_L150  0.0014
K_K12391  L_L68  L_L151  0.0014
K_K12392  L_L68  L_L152  0.0014
K_K12393  L_L68  L_L153  0.0014
K_K12394  L_L68  L_L154  0.0015
K_K12395  L_L68  L_L155  0.0015
K_K12396  L_L68  L_L156  0.0015
K_K12397  L_L68  L_L157  0.0015
K_K12398  L_L68  L_L158  0.0016
K_K12399  L_L68  L_L159  0.0016
K_K12400  L_L68  L_L160  0.0016
K_K12401  L_L68  L_L161  0.0017
K_K12402  L_L68  L_L162  0.0017
K_K12403  L_L68  L_L163  0.0018
K_K12404  L_L68  L_L164  0.0018
K_K12405  L_L68  L_L165  0.0018
K_K12406  L_L68  L_L166  0.0019
K_K12407  L_L68  L_L167  0.0019
K_K12408  L_L68  L_L168  0.0020
K_K12409  L_L68  L_L169  0.0020
K_K12410  L_L68  L_L170  0.0021
K_K12411  L_L68  L_L171  0.0022
K_K12412  L_L68  L_L172  0.0022
K_K12413  L_L68  L_L173  0.0023
K_K12414  L_L68  L_L174  0.0024
K_K12415  L_L68  L_L175  0.0024
K_K12416  L_L68  L_L176  0.0025
K_K12417  L_L68  L_L177  0.0026
K_K12418  L_L68  L_L178  0.0027
K_K12419  L_L68  L_L179  0.0028
K_K12420  L_L68  L_L180  0.0029
K_K12421  L_L68  L_L181  0.0030
K_K12422  L_L68  L_L182  0.0032
K_K12423  L_L68  L_L183  0.0033
K_K12424  L_L68  L_L184  0.0034
K_K12425  L_L68  L_L185  0.0036
K_K12426  L_L68  L_L186  0.0038
K_K12427  L_L68  L_L187  0.0040
K_K12428  L_L68  L_L188  0.0042
K_K12429  L_L68  L_L189  0.0045
K_K12430  L_L68  L_L190  0.0047
K_K12431  L_L68  L_L191  0.0051
K_K12432  L_L68  L_L192  0.0054
K_K12433  L_L68  L_L193  0.0058
K_K12434  L_L68  L_L194  0.0063
K_K12435  L_L68  L_L195  0.0069
K_K12436  L_L68  L_L196  0.0076
K_K12437  L_L68  L_L197  0.0084
K_K12438  L_L68  L_L198  0.0095
K_K12439  L_L68  L_L199  0.0109
K_K12440  L_L68  L_L200  0.0127
K_K12441  L_L68  L_L201  0.0152
K_K12442  L_L68  L_L202  0.0191
K_K12443  L_L68  L_L203  0.0256
K_K12444  L_L68  L_L204  0.0389
K_K12445  L_L68  L_L205  0.0812
K_K12446  L_L68  L_L206  0.1569
K_K12447  L_L68  L_L207  0.0812
K_K12448  L_L68  L_L208  0.0389
K_K12449  L_L68  L_L209  0.0256
K_K12450  L_L68  L_L210  0.0191
K_K12451  L_L68  L_L211  0.0152
K_K12452  L_L68  L_L212  0.0127
K_K12453  L_L68  L_L213  0.0109
K_K12454  L_L68  L_L214  0.0095
K_K12455  L_L68  L_L215  0.0084
K_K12456  L_L68  L_L216  0.0076
K_K12457  L_L68  L_L217  0.0069
K_K12458  L_L68  L_L218  0.0063
K_K12459  L_L68  L_L219  0.0058
K_K12460  L_L68  L_L220  0.0054
K_K12461  L_L68  L_L221  0.0051
K_K12462  L_L68  L_L222  0.0047
K_K12463  L_L68  L_L223  0.0045
K_K12464  L_L68  L_L224  0.0042
K_K12465  L_L68  L_L225  0.0040
K_K12466  L_L68  L_L226  0.0038
K_K12467  L_L68  L_L227  0.0036
K_K12468  L_L68  L_L228  0.0034
K_K12469  L_L68  L_L229  0.0033
K_K12470  L_L68  L_L230  0.0032
K_K12471  L_L68  L_L231  0.0030
K_K12472  L_L68  L_L232  0.0029
K_K12473  L_L68  L_L233  0.0028
K_K12474  L_L68  L_L234  0.0027
K_K12475  L_L68  L_L235  0.0026
K_K12476  L_L68  L_L236  0.0025
K_K12477  L_L68  L_L237  0.0024
K_K12478  L_L68  L_L238  0.0024
K_K12479  L_L68  L_L239  0.0023
K_K12480  L_L68  L_L240  0.0022
K_K12481  L_L68  L_L241  0.0022
K_K12482  L_L68  L_L242  0.0021
K_K12483  L_L68  L_L243  0.0020
K_K12484  L_L68  L_L244  0.0020
K_K12485  L_L68  L_L245  0.0019
K_K12486  L_L68  L_L246  0.0019
K_K12487  L_L68  L_L247  0.0018
K_K12488  L_L68  L_L248  0.0018
K_K12489  L_L68  L_L249  0.0018
K_K12490  L_L68  L_L250  0.0017
K_K12491  L_L68  L_L251  0.0017
K_K12492  L_L68  L_L252  0.0016
K_K12493  L_L68  L_L253  0.0016
K_K12494  L_L68  L_L254  0.0016
K_K12495  L_L68  L_L255  0.0015
K_K12496  L_L68  L_L256  0.0015
K_K12497  L_L68  L_L257  0.0015
K_K12498  L_L68  L_L258  0.0015
K_K12499  L_L68  L_L259  0.0014
K_K12500  L_L68  L_L260  0.0014
K_K12501  L_L68  L_L261  0.0014
K_K12502  L_L68  L_L262  0.0014
K_K12503  L_L68  L_L263  0.0013
K_K12504  L_L68  L_L264  0.0013
K_K12505  L_L68  L_L265  0.0013
K_K12506  L_L68  L_L266  0.0013
K_K12507  L_L68  L_L267  0.0012
K_K12508  L_L68  L_L268  0.0012
K_K12509  L_L68  L_L269  0.0012
K_K12510  L_L68  L_L270  0.0012
K_K12511  L_L68  L_L271  0.0012
K_K12512  L_L68  L_L272  0.0011
K_K12513  L_L68  L_L273  0.0011
K_K12514  L_L68  L_L274  0.0011
K_K12515  L_L68  L_L275  0.0011
K_K12516  L_L68  L_L276  0.0011
* *  Branch  NTMP0000000068 - NP09
R_R69  NTMP0000000068  nU_69  32.914993m  TC=0,0
V_Ui69  nU_69  nR_69  STIMULUS=U_IND_0000000069
R_V137  nR_69  nV_137  23.280268m  TC=0,0
L_V137  nR_69  nV_137  0.014646uH
R_V138  nV_137  nV_138  7.852787m  TC=0,0
L_V138  nV_137  nV_138  0.073723uH
L_L69  nV_138  NP09  6.519695uH
K_K12517  L_L69  L_L70  0.1050
K_K12518  L_L69  L_L71  0.0397
K_K12519  L_L69  L_L72  0.0258
K_K12520  L_L69  L_L73  0.0192
K_K12521  L_L69  L_L74  0.0153
K_K12522  L_L69  L_L75  0.0127
K_K12523  L_L69  L_L76  0.0109
K_K12524  L_L69  L_L77  0.0095
K_K12525  L_L69  L_L78  0.0084
K_K12526  L_L69  L_L79  0.0076
K_K12527  L_L69  L_L80  0.0069
K_K12528  L_L69  L_L81  0.0063
K_K12529  L_L69  L_L82  0.0058
K_K12530  L_L69  L_L83  0.0054
K_K12531  L_L69  L_L84  0.0051
K_K12532  L_L69  L_L85  0.0047
K_K12533  L_L69  L_L86  0.0045
K_K12534  L_L69  L_L87  0.0042
K_K12535  L_L69  L_L88  0.0040
K_K12536  L_L69  L_L89  0.0038
K_K12537  L_L69  L_L90  0.0036
K_K12538  L_L69  L_L91  0.0034
K_K12539  L_L69  L_L92  0.0033
K_K12540  L_L69  L_L93  0.0032
K_K12541  L_L69  L_L94  0.0030
K_K12542  L_L69  L_L95  0.0029
K_K12543  L_L69  L_L96  0.0028
K_K12544  L_L69  L_L97  0.0027
K_K12545  L_L69  L_L98  0.0026
K_K12546  L_L69  L_L99  0.0025
K_K12547  L_L69  L_L100  0.0024
K_K12548  L_L69  L_L101  0.0024
K_K12549  L_L69  L_L102  0.0023
K_K12550  L_L69  L_L103  0.0022
K_K12551  L_L69  L_L104  0.0022
K_K12552  L_L69  L_L105  0.0021
K_K12553  L_L69  L_L106  0.0020
K_K12554  L_L69  L_L107  0.0020
K_K12555  L_L69  L_L108  0.0019
K_K12556  L_L69  L_L109  0.0019
K_K12557  L_L69  L_L110  0.0019
K_K12558  L_L69  L_L111  0.0018
K_K12559  L_L69  L_L112  0.0018
K_K12560  L_L69  L_L113  0.0017
K_K12561  L_L69  L_L114  0.0017
K_K12562  L_L69  L_L115  0.0016
K_K12563  L_L69  L_L116  0.0016
K_K12564  L_L69  L_L117  0.0016
K_K12565  L_L69  L_L118  0.0015
K_K12566  L_L69  L_L119  0.0015
K_K12567  L_L69  L_L120  0.0015
K_K12568  L_L69  L_L121  0.0015
K_K12569  L_L69  L_L122  0.0014
K_K12570  L_L69  L_L123  0.0014
K_K12571  L_L69  L_L124  0.0014
K_K12572  L_L69  L_L125  0.0014
K_K12573  L_L69  L_L126  0.0013
K_K12574  L_L69  L_L127  0.0013
K_K12575  L_L69  L_L128  0.0013
K_K12576  L_L69  L_L129  0.0013
K_K12577  L_L69  L_L130  0.0013
K_K12578  L_L69  L_L131  0.0012
K_K12579  L_L69  L_L132  0.0012
K_K12580  L_L69  L_L133  0.0012
K_K12581  L_L69  L_L134  0.0012
K_K12582  L_L69  L_L135  0.0011
K_K12583  L_L69  L_L136  0.0011
K_K12584  L_L69  L_L137  0.0011
K_K12585  L_L69  L_L138  0.0011
K_K12586  L_L69  L_L139  0.0011
K_K12587  L_L69  L_L140  0.0011
K_K12588  L_L69  L_L141  0.0011
K_K12589  L_L69  L_L142  0.0012
K_K12590  L_L69  L_L143  0.0012
K_K12591  L_L69  L_L144  0.0012
K_K12592  L_L69  L_L145  0.0012
K_K12593  L_L69  L_L146  0.0012
K_K12594  L_L69  L_L147  0.0013
K_K12595  L_L69  L_L148  0.0013
K_K12596  L_L69  L_L149  0.0013
K_K12597  L_L69  L_L150  0.0013
K_K12598  L_L69  L_L151  0.0014
K_K12599  L_L69  L_L152  0.0014
K_K12600  L_L69  L_L153  0.0014
K_K12601  L_L69  L_L154  0.0014
K_K12602  L_L69  L_L155  0.0015
K_K12603  L_L69  L_L156  0.0015
K_K12604  L_L69  L_L157  0.0015
K_K12605  L_L69  L_L158  0.0015
K_K12606  L_L69  L_L159  0.0016
K_K12607  L_L69  L_L160  0.0016
K_K12608  L_L69  L_L161  0.0016
K_K12609  L_L69  L_L162  0.0017
K_K12610  L_L69  L_L163  0.0017
K_K12611  L_L69  L_L164  0.0018
K_K12612  L_L69  L_L165  0.0018
K_K12613  L_L69  L_L166  0.0018
K_K12614  L_L69  L_L167  0.0019
K_K12615  L_L69  L_L168  0.0019
K_K12616  L_L69  L_L169  0.0020
K_K12617  L_L69  L_L170  0.0020
K_K12618  L_L69  L_L171  0.0021
K_K12619  L_L69  L_L172  0.0022
K_K12620  L_L69  L_L173  0.0022
K_K12621  L_L69  L_L174  0.0023
K_K12622  L_L69  L_L175  0.0024
K_K12623  L_L69  L_L176  0.0024
K_K12624  L_L69  L_L177  0.0025
K_K12625  L_L69  L_L178  0.0026
K_K12626  L_L69  L_L179  0.0027
K_K12627  L_L69  L_L180  0.0028
K_K12628  L_L69  L_L181  0.0029
K_K12629  L_L69  L_L182  0.0030
K_K12630  L_L69  L_L183  0.0032
K_K12631  L_L69  L_L184  0.0033
K_K12632  L_L69  L_L185  0.0034
K_K12633  L_L69  L_L186  0.0036
K_K12634  L_L69  L_L187  0.0038
K_K12635  L_L69  L_L188  0.0040
K_K12636  L_L69  L_L189  0.0042
K_K12637  L_L69  L_L190  0.0045
K_K12638  L_L69  L_L191  0.0047
K_K12639  L_L69  L_L192  0.0051
K_K12640  L_L69  L_L193  0.0054
K_K12641  L_L69  L_L194  0.0058
K_K12642  L_L69  L_L195  0.0063
K_K12643  L_L69  L_L196  0.0069
K_K12644  L_L69  L_L197  0.0076
K_K12645  L_L69  L_L198  0.0084
K_K12646  L_L69  L_L199  0.0095
K_K12647  L_L69  L_L200  0.0109
K_K12648  L_L69  L_L201  0.0127
K_K12649  L_L69  L_L202  0.0152
K_K12650  L_L69  L_L203  0.0191
K_K12651  L_L69  L_L204  0.0256
K_K12652  L_L69  L_L205  0.0389
K_K12653  L_L69  L_L206  0.0812
K_K12654  L_L69  L_L207  0.1569
K_K12655  L_L69  L_L208  0.0812
K_K12656  L_L69  L_L209  0.0389
K_K12657  L_L69  L_L210  0.0256
K_K12658  L_L69  L_L211  0.0191
K_K12659  L_L69  L_L212  0.0152
K_K12660  L_L69  L_L213  0.0127
K_K12661  L_L69  L_L214  0.0109
K_K12662  L_L69  L_L215  0.0095
K_K12663  L_L69  L_L216  0.0084
K_K12664  L_L69  L_L217  0.0076
K_K12665  L_L69  L_L218  0.0069
K_K12666  L_L69  L_L219  0.0063
K_K12667  L_L69  L_L220  0.0058
K_K12668  L_L69  L_L221  0.0054
K_K12669  L_L69  L_L222  0.0051
K_K12670  L_L69  L_L223  0.0047
K_K12671  L_L69  L_L224  0.0045
K_K12672  L_L69  L_L225  0.0042
K_K12673  L_L69  L_L226  0.0040
K_K12674  L_L69  L_L227  0.0038
K_K12675  L_L69  L_L228  0.0036
K_K12676  L_L69  L_L229  0.0034
K_K12677  L_L69  L_L230  0.0033
K_K12678  L_L69  L_L231  0.0032
K_K12679  L_L69  L_L232  0.0030
K_K12680  L_L69  L_L233  0.0029
K_K12681  L_L69  L_L234  0.0028
K_K12682  L_L69  L_L235  0.0027
K_K12683  L_L69  L_L236  0.0026
K_K12684  L_L69  L_L237  0.0025
K_K12685  L_L69  L_L238  0.0024
K_K12686  L_L69  L_L239  0.0024
K_K12687  L_L69  L_L240  0.0023
K_K12688  L_L69  L_L241  0.0022
K_K12689  L_L69  L_L242  0.0022
K_K12690  L_L69  L_L243  0.0021
K_K12691  L_L69  L_L244  0.0020
K_K12692  L_L69  L_L245  0.0020
K_K12693  L_L69  L_L246  0.0019
K_K12694  L_L69  L_L247  0.0019
K_K12695  L_L69  L_L248  0.0018
K_K12696  L_L69  L_L249  0.0018
K_K12697  L_L69  L_L250  0.0018
K_K12698  L_L69  L_L251  0.0017
K_K12699  L_L69  L_L252  0.0017
K_K12700  L_L69  L_L253  0.0016
K_K12701  L_L69  L_L254  0.0016
K_K12702  L_L69  L_L255  0.0016
K_K12703  L_L69  L_L256  0.0015
K_K12704  L_L69  L_L257  0.0015
K_K12705  L_L69  L_L258  0.0015
K_K12706  L_L69  L_L259  0.0015
K_K12707  L_L69  L_L260  0.0014
K_K12708  L_L69  L_L261  0.0014
K_K12709  L_L69  L_L262  0.0014
K_K12710  L_L69  L_L263  0.0014
K_K12711  L_L69  L_L264  0.0013
K_K12712  L_L69  L_L265  0.0013
K_K12713  L_L69  L_L266  0.0013
K_K12714  L_L69  L_L267  0.0013
K_K12715  L_L69  L_L268  0.0012
K_K12716  L_L69  L_L269  0.0012
K_K12717  L_L69  L_L270  0.0012
K_K12718  L_L69  L_L271  0.0012
K_K12719  L_L69  L_L272  0.0012
K_K12720  L_L69  L_L273  0.0011
K_K12721  L_L69  L_L274  0.0011
K_K12722  L_L69  L_L275  0.0011
K_K12723  L_L69  L_L276  0.0011
* *  Branch  NP09 - NTMP0000000070
R_R70  NP09  nU_70  32.914993m  TC=0,0
V_Ui70  nU_70  nR_70  STIMULUS=U_IND_0000000070
R_V139  nR_70  nV_139  23.280268m  TC=0,0
L_V139  nR_70  nV_139  0.014646uH
R_V140  nV_139  nV_140  7.852787m  TC=0,0
L_V140  nV_139  nV_140  0.073723uH
L_L70  nV_140  NTMP0000000070  6.519695uH
K_K12724  L_L70  L_L71  0.1050
K_K12725  L_L70  L_L72  0.0397
K_K12726  L_L70  L_L73  0.0258
K_K12727  L_L70  L_L74  0.0192
K_K12728  L_L70  L_L75  0.0153
K_K12729  L_L70  L_L76  0.0127
K_K12730  L_L70  L_L77  0.0109
K_K12731  L_L70  L_L78  0.0095
K_K12732  L_L70  L_L79  0.0084
K_K12733  L_L70  L_L80  0.0076
K_K12734  L_L70  L_L81  0.0069
K_K12735  L_L70  L_L82  0.0063
K_K12736  L_L70  L_L83  0.0058
K_K12737  L_L70  L_L84  0.0054
K_K12738  L_L70  L_L85  0.0051
K_K12739  L_L70  L_L86  0.0047
K_K12740  L_L70  L_L87  0.0045
K_K12741  L_L70  L_L88  0.0042
K_K12742  L_L70  L_L89  0.0040
K_K12743  L_L70  L_L90  0.0038
K_K12744  L_L70  L_L91  0.0036
K_K12745  L_L70  L_L92  0.0034
K_K12746  L_L70  L_L93  0.0033
K_K12747  L_L70  L_L94  0.0032
K_K12748  L_L70  L_L95  0.0030
K_K12749  L_L70  L_L96  0.0029
K_K12750  L_L70  L_L97  0.0028
K_K12751  L_L70  L_L98  0.0027
K_K12752  L_L70  L_L99  0.0026
K_K12753  L_L70  L_L100  0.0025
K_K12754  L_L70  L_L101  0.0024
K_K12755  L_L70  L_L102  0.0024
K_K12756  L_L70  L_L103  0.0023
K_K12757  L_L70  L_L104  0.0022
K_K12758  L_L70  L_L105  0.0022
K_K12759  L_L70  L_L106  0.0021
K_K12760  L_L70  L_L107  0.0020
K_K12761  L_L70  L_L108  0.0020
K_K12762  L_L70  L_L109  0.0019
K_K12763  L_L70  L_L110  0.0019
K_K12764  L_L70  L_L111  0.0019
K_K12765  L_L70  L_L112  0.0018
K_K12766  L_L70  L_L113  0.0018
K_K12767  L_L70  L_L114  0.0017
K_K12768  L_L70  L_L115  0.0017
K_K12769  L_L70  L_L116  0.0016
K_K12770  L_L70  L_L117  0.0016
K_K12771  L_L70  L_L118  0.0016
K_K12772  L_L70  L_L119  0.0015
K_K12773  L_L70  L_L120  0.0015
K_K12774  L_L70  L_L121  0.0015
K_K12775  L_L70  L_L122  0.0015
K_K12776  L_L70  L_L123  0.0014
K_K12777  L_L70  L_L124  0.0014
K_K12778  L_L70  L_L125  0.0014
K_K12779  L_L70  L_L126  0.0014
K_K12780  L_L70  L_L127  0.0013
K_K12781  L_L70  L_L128  0.0013
K_K12782  L_L70  L_L129  0.0013
K_K12783  L_L70  L_L130  0.0013
K_K12784  L_L70  L_L131  0.0013
K_K12785  L_L70  L_L132  0.0012
K_K12786  L_L70  L_L133  0.0012
K_K12787  L_L70  L_L134  0.0012
K_K12788  L_L70  L_L135  0.0012
K_K12789  L_L70  L_L136  0.0011
K_K12790  L_L70  L_L137  0.0011
K_K12791  L_L70  L_L138  0.0011
K_K12792  L_L70  L_L139  0.0011
K_K12793  L_L70  L_L140  0.0011
K_K12794  L_L70  L_L141  0.0011
K_K12795  L_L70  L_L142  0.0011
K_K12796  L_L70  L_L143  0.0012
K_K12797  L_L70  L_L144  0.0012
K_K12798  L_L70  L_L145  0.0012
K_K12799  L_L70  L_L146  0.0012
K_K12800  L_L70  L_L147  0.0012
K_K12801  L_L70  L_L148  0.0013
K_K12802  L_L70  L_L149  0.0013
K_K12803  L_L70  L_L150  0.0013
K_K12804  L_L70  L_L151  0.0013
K_K12805  L_L70  L_L152  0.0014
K_K12806  L_L70  L_L153  0.0014
K_K12807  L_L70  L_L154  0.0014
K_K12808  L_L70  L_L155  0.0014
K_K12809  L_L70  L_L156  0.0015
K_K12810  L_L70  L_L157  0.0015
K_K12811  L_L70  L_L158  0.0015
K_K12812  L_L70  L_L159  0.0015
K_K12813  L_L70  L_L160  0.0016
K_K12814  L_L70  L_L161  0.0016
K_K12815  L_L70  L_L162  0.0016
K_K12816  L_L70  L_L163  0.0017
K_K12817  L_L70  L_L164  0.0017
K_K12818  L_L70  L_L165  0.0018
K_K12819  L_L70  L_L166  0.0018
K_K12820  L_L70  L_L167  0.0018
K_K12821  L_L70  L_L168  0.0019
K_K12822  L_L70  L_L169  0.0019
K_K12823  L_L70  L_L170  0.0020
K_K12824  L_L70  L_L171  0.0020
K_K12825  L_L70  L_L172  0.0021
K_K12826  L_L70  L_L173  0.0022
K_K12827  L_L70  L_L174  0.0022
K_K12828  L_L70  L_L175  0.0023
K_K12829  L_L70  L_L176  0.0024
K_K12830  L_L70  L_L177  0.0024
K_K12831  L_L70  L_L178  0.0025
K_K12832  L_L70  L_L179  0.0026
K_K12833  L_L70  L_L180  0.0027
K_K12834  L_L70  L_L181  0.0028
K_K12835  L_L70  L_L182  0.0029
K_K12836  L_L70  L_L183  0.0030
K_K12837  L_L70  L_L184  0.0032
K_K12838  L_L70  L_L185  0.0033
K_K12839  L_L70  L_L186  0.0034
K_K12840  L_L70  L_L187  0.0036
K_K12841  L_L70  L_L188  0.0038
K_K12842  L_L70  L_L189  0.0040
K_K12843  L_L70  L_L190  0.0042
K_K12844  L_L70  L_L191  0.0045
K_K12845  L_L70  L_L192  0.0047
K_K12846  L_L70  L_L193  0.0051
K_K12847  L_L70  L_L194  0.0054
K_K12848  L_L70  L_L195  0.0058
K_K12849  L_L70  L_L196  0.0063
K_K12850  L_L70  L_L197  0.0069
K_K12851  L_L70  L_L198  0.0076
K_K12852  L_L70  L_L199  0.0084
K_K12853  L_L70  L_L200  0.0095
K_K12854  L_L70  L_L201  0.0109
K_K12855  L_L70  L_L202  0.0127
K_K12856  L_L70  L_L203  0.0152
K_K12857  L_L70  L_L204  0.0191
K_K12858  L_L70  L_L205  0.0256
K_K12859  L_L70  L_L206  0.0389
K_K12860  L_L70  L_L207  0.0812
K_K12861  L_L70  L_L208  0.1569
K_K12862  L_L70  L_L209  0.0812
K_K12863  L_L70  L_L210  0.0389
K_K12864  L_L70  L_L211  0.0256
K_K12865  L_L70  L_L212  0.0191
K_K12866  L_L70  L_L213  0.0152
K_K12867  L_L70  L_L214  0.0127
K_K12868  L_L70  L_L215  0.0109
K_K12869  L_L70  L_L216  0.0095
K_K12870  L_L70  L_L217  0.0084
K_K12871  L_L70  L_L218  0.0076
K_K12872  L_L70  L_L219  0.0069
K_K12873  L_L70  L_L220  0.0063
K_K12874  L_L70  L_L221  0.0058
K_K12875  L_L70  L_L222  0.0054
K_K12876  L_L70  L_L223  0.0051
K_K12877  L_L70  L_L224  0.0047
K_K12878  L_L70  L_L225  0.0045
K_K12879  L_L70  L_L226  0.0042
K_K12880  L_L70  L_L227  0.0040
K_K12881  L_L70  L_L228  0.0038
K_K12882  L_L70  L_L229  0.0036
K_K12883  L_L70  L_L230  0.0034
K_K12884  L_L70  L_L231  0.0033
K_K12885  L_L70  L_L232  0.0032
K_K12886  L_L70  L_L233  0.0030
K_K12887  L_L70  L_L234  0.0029
K_K12888  L_L70  L_L235  0.0028
K_K12889  L_L70  L_L236  0.0027
K_K12890  L_L70  L_L237  0.0026
K_K12891  L_L70  L_L238  0.0025
K_K12892  L_L70  L_L239  0.0024
K_K12893  L_L70  L_L240  0.0024
K_K12894  L_L70  L_L241  0.0023
K_K12895  L_L70  L_L242  0.0022
K_K12896  L_L70  L_L243  0.0022
K_K12897  L_L70  L_L244  0.0021
K_K12898  L_L70  L_L245  0.0020
K_K12899  L_L70  L_L246  0.0020
K_K12900  L_L70  L_L247  0.0019
K_K12901  L_L70  L_L248  0.0019
K_K12902  L_L70  L_L249  0.0018
K_K12903  L_L70  L_L250  0.0018
K_K12904  L_L70  L_L251  0.0018
K_K12905  L_L70  L_L252  0.0017
K_K12906  L_L70  L_L253  0.0017
K_K12907  L_L70  L_L254  0.0016
K_K12908  L_L70  L_L255  0.0016
K_K12909  L_L70  L_L256  0.0016
K_K12910  L_L70  L_L257  0.0015
K_K12911  L_L70  L_L258  0.0015
K_K12912  L_L70  L_L259  0.0015
K_K12913  L_L70  L_L260  0.0015
K_K12914  L_L70  L_L261  0.0014
K_K12915  L_L70  L_L262  0.0014
K_K12916  L_L70  L_L263  0.0014
K_K12917  L_L70  L_L264  0.0014
K_K12918  L_L70  L_L265  0.0013
K_K12919  L_L70  L_L266  0.0013
K_K12920  L_L70  L_L267  0.0013
K_K12921  L_L70  L_L268  0.0013
K_K12922  L_L70  L_L269  0.0012
K_K12923  L_L70  L_L270  0.0012
K_K12924  L_L70  L_L271  0.0012
K_K12925  L_L70  L_L272  0.0012
K_K12926  L_L70  L_L273  0.0012
K_K12927  L_L70  L_L274  0.0011
K_K12928  L_L70  L_L275  0.0011
K_K12929  L_L70  L_L276  0.0011
* *  Branch  NTMP0000000070 - NTMP0000000071
R_R71  NTMP0000000070  nU_71  32.914993m  TC=0,0
V_Ui71  nU_71  nR_71  STIMULUS=U_IND_0000000071
R_V141  nR_71  nV_141  23.280268m  TC=0,0
L_V141  nR_71  nV_141  0.014646uH
R_V142  nV_141  nV_142  7.852787m  TC=0,0
L_V142  nV_141  nV_142  0.073723uH
L_L71  nV_142  NTMP0000000071  6.519695uH
K_K12930  L_L71  L_L72  0.1050
K_K12931  L_L71  L_L73  0.0397
K_K12932  L_L71  L_L74  0.0258
K_K12933  L_L71  L_L75  0.0192
K_K12934  L_L71  L_L76  0.0153
K_K12935  L_L71  L_L77  0.0127
K_K12936  L_L71  L_L78  0.0109
K_K12937  L_L71  L_L79  0.0095
K_K12938  L_L71  L_L80  0.0084
K_K12939  L_L71  L_L81  0.0076
K_K12940  L_L71  L_L82  0.0069
K_K12941  L_L71  L_L83  0.0063
K_K12942  L_L71  L_L84  0.0058
K_K12943  L_L71  L_L85  0.0054
K_K12944  L_L71  L_L86  0.0051
K_K12945  L_L71  L_L87  0.0047
K_K12946  L_L71  L_L88  0.0045
K_K12947  L_L71  L_L89  0.0042
K_K12948  L_L71  L_L90  0.0040
K_K12949  L_L71  L_L91  0.0038
K_K12950  L_L71  L_L92  0.0036
K_K12951  L_L71  L_L93  0.0034
K_K12952  L_L71  L_L94  0.0033
K_K12953  L_L71  L_L95  0.0032
K_K12954  L_L71  L_L96  0.0030
K_K12955  L_L71  L_L97  0.0029
K_K12956  L_L71  L_L98  0.0028
K_K12957  L_L71  L_L99  0.0027
K_K12958  L_L71  L_L100  0.0026
K_K12959  L_L71  L_L101  0.0025
K_K12960  L_L71  L_L102  0.0024
K_K12961  L_L71  L_L103  0.0024
K_K12962  L_L71  L_L104  0.0023
K_K12963  L_L71  L_L105  0.0022
K_K12964  L_L71  L_L106  0.0022
K_K12965  L_L71  L_L107  0.0021
K_K12966  L_L71  L_L108  0.0020
K_K12967  L_L71  L_L109  0.0020
K_K12968  L_L71  L_L110  0.0019
K_K12969  L_L71  L_L111  0.0019
K_K12970  L_L71  L_L112  0.0019
K_K12971  L_L71  L_L113  0.0018
K_K12972  L_L71  L_L114  0.0018
K_K12973  L_L71  L_L115  0.0017
K_K12974  L_L71  L_L116  0.0017
K_K12975  L_L71  L_L117  0.0016
K_K12976  L_L71  L_L118  0.0016
K_K12977  L_L71  L_L119  0.0016
K_K12978  L_L71  L_L120  0.0015
K_K12979  L_L71  L_L121  0.0015
K_K12980  L_L71  L_L122  0.0015
K_K12981  L_L71  L_L123  0.0015
K_K12982  L_L71  L_L124  0.0014
K_K12983  L_L71  L_L125  0.0014
K_K12984  L_L71  L_L126  0.0014
K_K12985  L_L71  L_L127  0.0014
K_K12986  L_L71  L_L128  0.0013
K_K12987  L_L71  L_L129  0.0013
K_K12988  L_L71  L_L130  0.0013
K_K12989  L_L71  L_L131  0.0013
K_K12990  L_L71  L_L132  0.0013
K_K12991  L_L71  L_L133  0.0012
K_K12992  L_L71  L_L134  0.0012
K_K12993  L_L71  L_L135  0.0012
K_K12994  L_L71  L_L136  0.0012
K_K12995  L_L71  L_L137  0.0011
K_K12996  L_L71  L_L138  0.0011
K_K12997  L_L71  L_L139  0.0011
K_K12998  L_L71  L_L140  0.0011
K_K12999  L_L71  L_L141  0.0011
K_K13000  L_L71  L_L142  0.0011
K_K13001  L_L71  L_L143  0.0011
K_K13002  L_L71  L_L144  0.0012
K_K13003  L_L71  L_L145  0.0012
K_K13004  L_L71  L_L146  0.0012
K_K13005  L_L71  L_L147  0.0012
K_K13006  L_L71  L_L148  0.0012
K_K13007  L_L71  L_L149  0.0013
K_K13008  L_L71  L_L150  0.0013
K_K13009  L_L71  L_L151  0.0013
K_K13010  L_L71  L_L152  0.0013
K_K13011  L_L71  L_L153  0.0014
K_K13012  L_L71  L_L154  0.0014
K_K13013  L_L71  L_L155  0.0014
K_K13014  L_L71  L_L156  0.0014
K_K13015  L_L71  L_L157  0.0015
K_K13016  L_L71  L_L158  0.0015
K_K13017  L_L71  L_L159  0.0015
K_K13018  L_L71  L_L160  0.0015
K_K13019  L_L71  L_L161  0.0016
K_K13020  L_L71  L_L162  0.0016
K_K13021  L_L71  L_L163  0.0016
K_K13022  L_L71  L_L164  0.0017
K_K13023  L_L71  L_L165  0.0017
K_K13024  L_L71  L_L166  0.0018
K_K13025  L_L71  L_L167  0.0018
K_K13026  L_L71  L_L168  0.0018
K_K13027  L_L71  L_L169  0.0019
K_K13028  L_L71  L_L170  0.0019
K_K13029  L_L71  L_L171  0.0020
K_K13030  L_L71  L_L172  0.0020
K_K13031  L_L71  L_L173  0.0021
K_K13032  L_L71  L_L174  0.0022
K_K13033  L_L71  L_L175  0.0022
K_K13034  L_L71  L_L176  0.0023
K_K13035  L_L71  L_L177  0.0024
K_K13036  L_L71  L_L178  0.0024
K_K13037  L_L71  L_L179  0.0025
K_K13038  L_L71  L_L180  0.0026
K_K13039  L_L71  L_L181  0.0027
K_K13040  L_L71  L_L182  0.0028
K_K13041  L_L71  L_L183  0.0029
K_K13042  L_L71  L_L184  0.0030
K_K13043  L_L71  L_L185  0.0032
K_K13044  L_L71  L_L186  0.0033
K_K13045  L_L71  L_L187  0.0034
K_K13046  L_L71  L_L188  0.0036
K_K13047  L_L71  L_L189  0.0038
K_K13048  L_L71  L_L190  0.0040
K_K13049  L_L71  L_L191  0.0042
K_K13050  L_L71  L_L192  0.0045
K_K13051  L_L71  L_L193  0.0047
K_K13052  L_L71  L_L194  0.0051
K_K13053  L_L71  L_L195  0.0054
K_K13054  L_L71  L_L196  0.0058
K_K13055  L_L71  L_L197  0.0063
K_K13056  L_L71  L_L198  0.0069
K_K13057  L_L71  L_L199  0.0076
K_K13058  L_L71  L_L200  0.0084
K_K13059  L_L71  L_L201  0.0095
K_K13060  L_L71  L_L202  0.0109
K_K13061  L_L71  L_L203  0.0127
K_K13062  L_L71  L_L204  0.0152
K_K13063  L_L71  L_L205  0.0191
K_K13064  L_L71  L_L206  0.0256
K_K13065  L_L71  L_L207  0.0389
K_K13066  L_L71  L_L208  0.0812
K_K13067  L_L71  L_L209  0.1569
K_K13068  L_L71  L_L210  0.0812
K_K13069  L_L71  L_L211  0.0389
K_K13070  L_L71  L_L212  0.0256
K_K13071  L_L71  L_L213  0.0191
K_K13072  L_L71  L_L214  0.0152
K_K13073  L_L71  L_L215  0.0127
K_K13074  L_L71  L_L216  0.0109
K_K13075  L_L71  L_L217  0.0095
K_K13076  L_L71  L_L218  0.0084
K_K13077  L_L71  L_L219  0.0076
K_K13078  L_L71  L_L220  0.0069
K_K13079  L_L71  L_L221  0.0063
K_K13080  L_L71  L_L222  0.0058
K_K13081  L_L71  L_L223  0.0054
K_K13082  L_L71  L_L224  0.0051
K_K13083  L_L71  L_L225  0.0047
K_K13084  L_L71  L_L226  0.0045
K_K13085  L_L71  L_L227  0.0042
K_K13086  L_L71  L_L228  0.0040
K_K13087  L_L71  L_L229  0.0038
K_K13088  L_L71  L_L230  0.0036
K_K13089  L_L71  L_L231  0.0034
K_K13090  L_L71  L_L232  0.0033
K_K13091  L_L71  L_L233  0.0032
K_K13092  L_L71  L_L234  0.0030
K_K13093  L_L71  L_L235  0.0029
K_K13094  L_L71  L_L236  0.0028
K_K13095  L_L71  L_L237  0.0027
K_K13096  L_L71  L_L238  0.0026
K_K13097  L_L71  L_L239  0.0025
K_K13098  L_L71  L_L240  0.0024
K_K13099  L_L71  L_L241  0.0024
K_K13100  L_L71  L_L242  0.0023
K_K13101  L_L71  L_L243  0.0022
K_K13102  L_L71  L_L244  0.0022
K_K13103  L_L71  L_L245  0.0021
K_K13104  L_L71  L_L246  0.0020
K_K13105  L_L71  L_L247  0.0020
K_K13106  L_L71  L_L248  0.0019
K_K13107  L_L71  L_L249  0.0019
K_K13108  L_L71  L_L250  0.0018
K_K13109  L_L71  L_L251  0.0018
K_K13110  L_L71  L_L252  0.0018
K_K13111  L_L71  L_L253  0.0017
K_K13112  L_L71  L_L254  0.0017
K_K13113  L_L71  L_L255  0.0016
K_K13114  L_L71  L_L256  0.0016
K_K13115  L_L71  L_L257  0.0016
K_K13116  L_L71  L_L258  0.0015
K_K13117  L_L71  L_L259  0.0015
K_K13118  L_L71  L_L260  0.0015
K_K13119  L_L71  L_L261  0.0015
K_K13120  L_L71  L_L262  0.0014
K_K13121  L_L71  L_L263  0.0014
K_K13122  L_L71  L_L264  0.0014
K_K13123  L_L71  L_L265  0.0014
K_K13124  L_L71  L_L266  0.0013
K_K13125  L_L71  L_L267  0.0013
K_K13126  L_L71  L_L268  0.0013
K_K13127  L_L71  L_L269  0.0013
K_K13128  L_L71  L_L270  0.0012
K_K13129  L_L71  L_L271  0.0012
K_K13130  L_L71  L_L272  0.0012
K_K13131  L_L71  L_L273  0.0012
K_K13132  L_L71  L_L274  0.0012
K_K13133  L_L71  L_L275  0.0011
K_K13134  L_L71  L_L276  0.0011
* *  Branch  NTMP0000000071 - NTMP0000000072
R_R72  NTMP0000000071  nU_72  32.914993m  TC=0,0
V_Ui72  nU_72  nR_72  STIMULUS=U_IND_0000000072
R_V143  nR_72  nV_143  23.280268m  TC=0,0
L_V143  nR_72  nV_143  0.014646uH
R_V144  nV_143  nV_144  7.852787m  TC=0,0
L_V144  nV_143  nV_144  0.073723uH
L_L72  nV_144  NTMP0000000072  6.519695uH
K_K13135  L_L72  L_L73  0.1050
K_K13136  L_L72  L_L74  0.0397
K_K13137  L_L72  L_L75  0.0258
K_K13138  L_L72  L_L76  0.0192
K_K13139  L_L72  L_L77  0.0153
K_K13140  L_L72  L_L78  0.0127
K_K13141  L_L72  L_L79  0.0109
K_K13142  L_L72  L_L80  0.0095
K_K13143  L_L72  L_L81  0.0084
K_K13144  L_L72  L_L82  0.0076
K_K13145  L_L72  L_L83  0.0069
K_K13146  L_L72  L_L84  0.0063
K_K13147  L_L72  L_L85  0.0058
K_K13148  L_L72  L_L86  0.0054
K_K13149  L_L72  L_L87  0.0051
K_K13150  L_L72  L_L88  0.0047
K_K13151  L_L72  L_L89  0.0045
K_K13152  L_L72  L_L90  0.0042
K_K13153  L_L72  L_L91  0.0040
K_K13154  L_L72  L_L92  0.0038
K_K13155  L_L72  L_L93  0.0036
K_K13156  L_L72  L_L94  0.0034
K_K13157  L_L72  L_L95  0.0033
K_K13158  L_L72  L_L96  0.0032
K_K13159  L_L72  L_L97  0.0030
K_K13160  L_L72  L_L98  0.0029
K_K13161  L_L72  L_L99  0.0028
K_K13162  L_L72  L_L100  0.0027
K_K13163  L_L72  L_L101  0.0026
K_K13164  L_L72  L_L102  0.0025
K_K13165  L_L72  L_L103  0.0024
K_K13166  L_L72  L_L104  0.0024
K_K13167  L_L72  L_L105  0.0023
K_K13168  L_L72  L_L106  0.0022
K_K13169  L_L72  L_L107  0.0022
K_K13170  L_L72  L_L108  0.0021
K_K13171  L_L72  L_L109  0.0020
K_K13172  L_L72  L_L110  0.0020
K_K13173  L_L72  L_L111  0.0019
K_K13174  L_L72  L_L112  0.0019
K_K13175  L_L72  L_L113  0.0019
K_K13176  L_L72  L_L114  0.0018
K_K13177  L_L72  L_L115  0.0018
K_K13178  L_L72  L_L116  0.0017
K_K13179  L_L72  L_L117  0.0017
K_K13180  L_L72  L_L118  0.0016
K_K13181  L_L72  L_L119  0.0016
K_K13182  L_L72  L_L120  0.0016
K_K13183  L_L72  L_L121  0.0015
K_K13184  L_L72  L_L122  0.0015
K_K13185  L_L72  L_L123  0.0015
K_K13186  L_L72  L_L124  0.0015
K_K13187  L_L72  L_L125  0.0014
K_K13188  L_L72  L_L126  0.0014
K_K13189  L_L72  L_L127  0.0014
K_K13190  L_L72  L_L128  0.0014
K_K13191  L_L72  L_L129  0.0013
K_K13192  L_L72  L_L130  0.0013
K_K13193  L_L72  L_L131  0.0013
K_K13194  L_L72  L_L132  0.0013
K_K13195  L_L72  L_L133  0.0013
K_K13196  L_L72  L_L134  0.0012
K_K13197  L_L72  L_L135  0.0012
K_K13198  L_L72  L_L136  0.0012
K_K13199  L_L72  L_L137  0.0012
K_K13200  L_L72  L_L138  0.0011
K_K13201  L_L72  L_L139  0.0011
K_K13202  L_L72  L_L140  0.0011
K_K13203  L_L72  L_L141  0.0011
K_K13204  L_L72  L_L142  0.0011
K_K13205  L_L72  L_L143  0.0011
K_K13206  L_L72  L_L144  0.0011
K_K13207  L_L72  L_L145  0.0012
K_K13208  L_L72  L_L146  0.0012
K_K13209  L_L72  L_L147  0.0012
K_K13210  L_L72  L_L148  0.0012
K_K13211  L_L72  L_L149  0.0012
K_K13212  L_L72  L_L150  0.0013
K_K13213  L_L72  L_L151  0.0013
K_K13214  L_L72  L_L152  0.0013
K_K13215  L_L72  L_L153  0.0013
K_K13216  L_L72  L_L154  0.0014
K_K13217  L_L72  L_L155  0.0014
K_K13218  L_L72  L_L156  0.0014
K_K13219  L_L72  L_L157  0.0014
K_K13220  L_L72  L_L158  0.0015
K_K13221  L_L72  L_L159  0.0015
K_K13222  L_L72  L_L160  0.0015
K_K13223  L_L72  L_L161  0.0015
K_K13224  L_L72  L_L162  0.0016
K_K13225  L_L72  L_L163  0.0016
K_K13226  L_L72  L_L164  0.0016
K_K13227  L_L72  L_L165  0.0017
K_K13228  L_L72  L_L166  0.0017
K_K13229  L_L72  L_L167  0.0018
K_K13230  L_L72  L_L168  0.0018
K_K13231  L_L72  L_L169  0.0018
K_K13232  L_L72  L_L170  0.0019
K_K13233  L_L72  L_L171  0.0019
K_K13234  L_L72  L_L172  0.0020
K_K13235  L_L72  L_L173  0.0020
K_K13236  L_L72  L_L174  0.0021
K_K13237  L_L72  L_L175  0.0022
K_K13238  L_L72  L_L176  0.0022
K_K13239  L_L72  L_L177  0.0023
K_K13240  L_L72  L_L178  0.0024
K_K13241  L_L72  L_L179  0.0024
K_K13242  L_L72  L_L180  0.0025
K_K13243  L_L72  L_L181  0.0026
K_K13244  L_L72  L_L182  0.0027
K_K13245  L_L72  L_L183  0.0028
K_K13246  L_L72  L_L184  0.0029
K_K13247  L_L72  L_L185  0.0030
K_K13248  L_L72  L_L186  0.0032
K_K13249  L_L72  L_L187  0.0033
K_K13250  L_L72  L_L188  0.0034
K_K13251  L_L72  L_L189  0.0036
K_K13252  L_L72  L_L190  0.0038
K_K13253  L_L72  L_L191  0.0040
K_K13254  L_L72  L_L192  0.0042
K_K13255  L_L72  L_L193  0.0045
K_K13256  L_L72  L_L194  0.0047
K_K13257  L_L72  L_L195  0.0051
K_K13258  L_L72  L_L196  0.0054
K_K13259  L_L72  L_L197  0.0058
K_K13260  L_L72  L_L198  0.0063
K_K13261  L_L72  L_L199  0.0069
K_K13262  L_L72  L_L200  0.0076
K_K13263  L_L72  L_L201  0.0084
K_K13264  L_L72  L_L202  0.0095
K_K13265  L_L72  L_L203  0.0109
K_K13266  L_L72  L_L204  0.0127
K_K13267  L_L72  L_L205  0.0152
K_K13268  L_L72  L_L206  0.0191
K_K13269  L_L72  L_L207  0.0256
K_K13270  L_L72  L_L208  0.0389
K_K13271  L_L72  L_L209  0.0812
K_K13272  L_L72  L_L210  0.1569
K_K13273  L_L72  L_L211  0.0812
K_K13274  L_L72  L_L212  0.0389
K_K13275  L_L72  L_L213  0.0256
K_K13276  L_L72  L_L214  0.0191
K_K13277  L_L72  L_L215  0.0152
K_K13278  L_L72  L_L216  0.0127
K_K13279  L_L72  L_L217  0.0109
K_K13280  L_L72  L_L218  0.0095
K_K13281  L_L72  L_L219  0.0084
K_K13282  L_L72  L_L220  0.0076
K_K13283  L_L72  L_L221  0.0069
K_K13284  L_L72  L_L222  0.0063
K_K13285  L_L72  L_L223  0.0058
K_K13286  L_L72  L_L224  0.0054
K_K13287  L_L72  L_L225  0.0051
K_K13288  L_L72  L_L226  0.0047
K_K13289  L_L72  L_L227  0.0045
K_K13290  L_L72  L_L228  0.0042
K_K13291  L_L72  L_L229  0.0040
K_K13292  L_L72  L_L230  0.0038
K_K13293  L_L72  L_L231  0.0036
K_K13294  L_L72  L_L232  0.0034
K_K13295  L_L72  L_L233  0.0033
K_K13296  L_L72  L_L234  0.0032
K_K13297  L_L72  L_L235  0.0030
K_K13298  L_L72  L_L236  0.0029
K_K13299  L_L72  L_L237  0.0028
K_K13300  L_L72  L_L238  0.0027
K_K13301  L_L72  L_L239  0.0026
K_K13302  L_L72  L_L240  0.0025
K_K13303  L_L72  L_L241  0.0024
K_K13304  L_L72  L_L242  0.0024
K_K13305  L_L72  L_L243  0.0023
K_K13306  L_L72  L_L244  0.0022
K_K13307  L_L72  L_L245  0.0022
K_K13308  L_L72  L_L246  0.0021
K_K13309  L_L72  L_L247  0.0020
K_K13310  L_L72  L_L248  0.0020
K_K13311  L_L72  L_L249  0.0019
K_K13312  L_L72  L_L250  0.0019
K_K13313  L_L72  L_L251  0.0018
K_K13314  L_L72  L_L252  0.0018
K_K13315  L_L72  L_L253  0.0018
K_K13316  L_L72  L_L254  0.0017
K_K13317  L_L72  L_L255  0.0017
K_K13318  L_L72  L_L256  0.0016
K_K13319  L_L72  L_L257  0.0016
K_K13320  L_L72  L_L258  0.0016
K_K13321  L_L72  L_L259  0.0015
K_K13322  L_L72  L_L260  0.0015
K_K13323  L_L72  L_L261  0.0015
K_K13324  L_L72  L_L262  0.0015
K_K13325  L_L72  L_L263  0.0014
K_K13326  L_L72  L_L264  0.0014
K_K13327  L_L72  L_L265  0.0014
K_K13328  L_L72  L_L266  0.0014
K_K13329  L_L72  L_L267  0.0013
K_K13330  L_L72  L_L268  0.0013
K_K13331  L_L72  L_L269  0.0013
K_K13332  L_L72  L_L270  0.0013
K_K13333  L_L72  L_L271  0.0012
K_K13334  L_L72  L_L272  0.0012
K_K13335  L_L72  L_L273  0.0012
K_K13336  L_L72  L_L274  0.0012
K_K13337  L_L72  L_L275  0.0012
K_K13338  L_L72  L_L276  0.0011
* *  Branch  NTMP0000000072 - NTMP0000000073
R_R73  NTMP0000000072  nU_73  32.914993m  TC=0,0
V_Ui73  nU_73  nR_73  STIMULUS=U_IND_0000000073
R_V145  nR_73  nV_145  23.280268m  TC=0,0
L_V145  nR_73  nV_145  0.014646uH
R_V146  nV_145  nV_146  7.852787m  TC=0,0
L_V146  nV_145  nV_146  0.073723uH
L_L73  nV_146  NTMP0000000073  6.519695uH
K_K13339  L_L73  L_L74  0.1050
K_K13340  L_L73  L_L75  0.0397
K_K13341  L_L73  L_L76  0.0258
K_K13342  L_L73  L_L77  0.0192
K_K13343  L_L73  L_L78  0.0153
K_K13344  L_L73  L_L79  0.0127
K_K13345  L_L73  L_L80  0.0109
K_K13346  L_L73  L_L81  0.0095
K_K13347  L_L73  L_L82  0.0084
K_K13348  L_L73  L_L83  0.0076
K_K13349  L_L73  L_L84  0.0069
K_K13350  L_L73  L_L85  0.0063
K_K13351  L_L73  L_L86  0.0058
K_K13352  L_L73  L_L87  0.0054
K_K13353  L_L73  L_L88  0.0051
K_K13354  L_L73  L_L89  0.0047
K_K13355  L_L73  L_L90  0.0045
K_K13356  L_L73  L_L91  0.0042
K_K13357  L_L73  L_L92  0.0040
K_K13358  L_L73  L_L93  0.0038
K_K13359  L_L73  L_L94  0.0036
K_K13360  L_L73  L_L95  0.0034
K_K13361  L_L73  L_L96  0.0033
K_K13362  L_L73  L_L97  0.0032
K_K13363  L_L73  L_L98  0.0030
K_K13364  L_L73  L_L99  0.0029
K_K13365  L_L73  L_L100  0.0028
K_K13366  L_L73  L_L101  0.0027
K_K13367  L_L73  L_L102  0.0026
K_K13368  L_L73  L_L103  0.0025
K_K13369  L_L73  L_L104  0.0024
K_K13370  L_L73  L_L105  0.0024
K_K13371  L_L73  L_L106  0.0023
K_K13372  L_L73  L_L107  0.0022
K_K13373  L_L73  L_L108  0.0022
K_K13374  L_L73  L_L109  0.0021
K_K13375  L_L73  L_L110  0.0020
K_K13376  L_L73  L_L111  0.0020
K_K13377  L_L73  L_L112  0.0019
K_K13378  L_L73  L_L113  0.0019
K_K13379  L_L73  L_L114  0.0019
K_K13380  L_L73  L_L115  0.0018
K_K13381  L_L73  L_L116  0.0018
K_K13382  L_L73  L_L117  0.0017
K_K13383  L_L73  L_L118  0.0017
K_K13384  L_L73  L_L119  0.0016
K_K13385  L_L73  L_L120  0.0016
K_K13386  L_L73  L_L121  0.0016
K_K13387  L_L73  L_L122  0.0015
K_K13388  L_L73  L_L123  0.0015
K_K13389  L_L73  L_L124  0.0015
K_K13390  L_L73  L_L125  0.0015
K_K13391  L_L73  L_L126  0.0014
K_K13392  L_L73  L_L127  0.0014
K_K13393  L_L73  L_L128  0.0014
K_K13394  L_L73  L_L129  0.0014
K_K13395  L_L73  L_L130  0.0013
K_K13396  L_L73  L_L131  0.0013
K_K13397  L_L73  L_L132  0.0013
K_K13398  L_L73  L_L133  0.0013
K_K13399  L_L73  L_L134  0.0013
K_K13400  L_L73  L_L135  0.0012
K_K13401  L_L73  L_L136  0.0012
K_K13402  L_L73  L_L137  0.0012
K_K13403  L_L73  L_L138  0.0012
K_K13404  L_L73  L_L139  0.0011
K_K13405  L_L73  L_L140  0.0011
K_K13406  L_L73  L_L141  0.0011
K_K13407  L_L73  L_L142  0.0011
K_K13408  L_L73  L_L143  0.0011
K_K13409  L_L73  L_L144  0.0011
K_K13410  L_L73  L_L145  0.0011
K_K13411  L_L73  L_L146  0.0012
K_K13412  L_L73  L_L147  0.0012
K_K13413  L_L73  L_L148  0.0012
K_K13414  L_L73  L_L149  0.0012
K_K13415  L_L73  L_L150  0.0012
K_K13416  L_L73  L_L151  0.0013
K_K13417  L_L73  L_L152  0.0013
K_K13418  L_L73  L_L153  0.0013
K_K13419  L_L73  L_L154  0.0013
K_K13420  L_L73  L_L155  0.0014
K_K13421  L_L73  L_L156  0.0014
K_K13422  L_L73  L_L157  0.0014
K_K13423  L_L73  L_L158  0.0014
K_K13424  L_L73  L_L159  0.0015
K_K13425  L_L73  L_L160  0.0015
K_K13426  L_L73  L_L161  0.0015
K_K13427  L_L73  L_L162  0.0015
K_K13428  L_L73  L_L163  0.0016
K_K13429  L_L73  L_L164  0.0016
K_K13430  L_L73  L_L165  0.0016
K_K13431  L_L73  L_L166  0.0017
K_K13432  L_L73  L_L167  0.0017
K_K13433  L_L73  L_L168  0.0018
K_K13434  L_L73  L_L169  0.0018
K_K13435  L_L73  L_L170  0.0018
K_K13436  L_L73  L_L171  0.0019
K_K13437  L_L73  L_L172  0.0019
K_K13438  L_L73  L_L173  0.0020
K_K13439  L_L73  L_L174  0.0020
K_K13440  L_L73  L_L175  0.0021
K_K13441  L_L73  L_L176  0.0022
K_K13442  L_L73  L_L177  0.0022
K_K13443  L_L73  L_L178  0.0023
K_K13444  L_L73  L_L179  0.0024
K_K13445  L_L73  L_L180  0.0024
K_K13446  L_L73  L_L181  0.0025
K_K13447  L_L73  L_L182  0.0026
K_K13448  L_L73  L_L183  0.0027
K_K13449  L_L73  L_L184  0.0028
K_K13450  L_L73  L_L185  0.0029
K_K13451  L_L73  L_L186  0.0030
K_K13452  L_L73  L_L187  0.0032
K_K13453  L_L73  L_L188  0.0033
K_K13454  L_L73  L_L189  0.0034
K_K13455  L_L73  L_L190  0.0036
K_K13456  L_L73  L_L191  0.0038
K_K13457  L_L73  L_L192  0.0040
K_K13458  L_L73  L_L193  0.0042
K_K13459  L_L73  L_L194  0.0045
K_K13460  L_L73  L_L195  0.0047
K_K13461  L_L73  L_L196  0.0051
K_K13462  L_L73  L_L197  0.0054
K_K13463  L_L73  L_L198  0.0058
K_K13464  L_L73  L_L199  0.0063
K_K13465  L_L73  L_L200  0.0069
K_K13466  L_L73  L_L201  0.0076
K_K13467  L_L73  L_L202  0.0084
K_K13468  L_L73  L_L203  0.0095
K_K13469  L_L73  L_L204  0.0109
K_K13470  L_L73  L_L205  0.0127
K_K13471  L_L73  L_L206  0.0152
K_K13472  L_L73  L_L207  0.0191
K_K13473  L_L73  L_L208  0.0256
K_K13474  L_L73  L_L209  0.0389
K_K13475  L_L73  L_L210  0.0812
K_K13476  L_L73  L_L211  0.1569
K_K13477  L_L73  L_L212  0.0812
K_K13478  L_L73  L_L213  0.0389
K_K13479  L_L73  L_L214  0.0256
K_K13480  L_L73  L_L215  0.0191
K_K13481  L_L73  L_L216  0.0152
K_K13482  L_L73  L_L217  0.0127
K_K13483  L_L73  L_L218  0.0109
K_K13484  L_L73  L_L219  0.0095
K_K13485  L_L73  L_L220  0.0084
K_K13486  L_L73  L_L221  0.0076
K_K13487  L_L73  L_L222  0.0069
K_K13488  L_L73  L_L223  0.0063
K_K13489  L_L73  L_L224  0.0058
K_K13490  L_L73  L_L225  0.0054
K_K13491  L_L73  L_L226  0.0051
K_K13492  L_L73  L_L227  0.0047
K_K13493  L_L73  L_L228  0.0045
K_K13494  L_L73  L_L229  0.0042
K_K13495  L_L73  L_L230  0.0040
K_K13496  L_L73  L_L231  0.0038
K_K13497  L_L73  L_L232  0.0036
K_K13498  L_L73  L_L233  0.0034
K_K13499  L_L73  L_L234  0.0033
K_K13500  L_L73  L_L235  0.0032
K_K13501  L_L73  L_L236  0.0030
K_K13502  L_L73  L_L237  0.0029
K_K13503  L_L73  L_L238  0.0028
K_K13504  L_L73  L_L239  0.0027
K_K13505  L_L73  L_L240  0.0026
K_K13506  L_L73  L_L241  0.0025
K_K13507  L_L73  L_L242  0.0024
K_K13508  L_L73  L_L243  0.0024
K_K13509  L_L73  L_L244  0.0023
K_K13510  L_L73  L_L245  0.0022
K_K13511  L_L73  L_L246  0.0022
K_K13512  L_L73  L_L247  0.0021
K_K13513  L_L73  L_L248  0.0020
K_K13514  L_L73  L_L249  0.0020
K_K13515  L_L73  L_L250  0.0019
K_K13516  L_L73  L_L251  0.0019
K_K13517  L_L73  L_L252  0.0018
K_K13518  L_L73  L_L253  0.0018
K_K13519  L_L73  L_L254  0.0018
K_K13520  L_L73  L_L255  0.0017
K_K13521  L_L73  L_L256  0.0017
K_K13522  L_L73  L_L257  0.0016
K_K13523  L_L73  L_L258  0.0016
K_K13524  L_L73  L_L259  0.0016
K_K13525  L_L73  L_L260  0.0015
K_K13526  L_L73  L_L261  0.0015
K_K13527  L_L73  L_L262  0.0015
K_K13528  L_L73  L_L263  0.0015
K_K13529  L_L73  L_L264  0.0014
K_K13530  L_L73  L_L265  0.0014
K_K13531  L_L73  L_L266  0.0014
K_K13532  L_L73  L_L267  0.0014
K_K13533  L_L73  L_L268  0.0013
K_K13534  L_L73  L_L269  0.0013
K_K13535  L_L73  L_L270  0.0013
K_K13536  L_L73  L_L271  0.0013
K_K13537  L_L73  L_L272  0.0012
K_K13538  L_L73  L_L273  0.0012
K_K13539  L_L73  L_L274  0.0012
K_K13540  L_L73  L_L275  0.0012
K_K13541  L_L73  L_L276  0.0012
* *  Branch  NTMP0000000073 - NTMP0000000074
R_R74  NTMP0000000073  nU_74  32.914993m  TC=0,0
V_Ui74  nU_74  nR_74  STIMULUS=U_IND_0000000074
R_V147  nR_74  nV_147  23.280268m  TC=0,0
L_V147  nR_74  nV_147  0.014646uH
R_V148  nV_147  nV_148  7.852787m  TC=0,0
L_V148  nV_147  nV_148  0.073723uH
L_L74  nV_148  NTMP0000000074  6.519695uH
K_K13542  L_L74  L_L75  0.1050
K_K13543  L_L74  L_L76  0.0397
K_K13544  L_L74  L_L77  0.0258
K_K13545  L_L74  L_L78  0.0192
K_K13546  L_L74  L_L79  0.0153
K_K13547  L_L74  L_L80  0.0127
K_K13548  L_L74  L_L81  0.0109
K_K13549  L_L74  L_L82  0.0095
K_K13550  L_L74  L_L83  0.0084
K_K13551  L_L74  L_L84  0.0076
K_K13552  L_L74  L_L85  0.0069
K_K13553  L_L74  L_L86  0.0063
K_K13554  L_L74  L_L87  0.0058
K_K13555  L_L74  L_L88  0.0054
K_K13556  L_L74  L_L89  0.0051
K_K13557  L_L74  L_L90  0.0047
K_K13558  L_L74  L_L91  0.0045
K_K13559  L_L74  L_L92  0.0042
K_K13560  L_L74  L_L93  0.0040
K_K13561  L_L74  L_L94  0.0038
K_K13562  L_L74  L_L95  0.0036
K_K13563  L_L74  L_L96  0.0034
K_K13564  L_L74  L_L97  0.0033
K_K13565  L_L74  L_L98  0.0032
K_K13566  L_L74  L_L99  0.0030
K_K13567  L_L74  L_L100  0.0029
K_K13568  L_L74  L_L101  0.0028
K_K13569  L_L74  L_L102  0.0027
K_K13570  L_L74  L_L103  0.0026
K_K13571  L_L74  L_L104  0.0025
K_K13572  L_L74  L_L105  0.0024
K_K13573  L_L74  L_L106  0.0024
K_K13574  L_L74  L_L107  0.0023
K_K13575  L_L74  L_L108  0.0022
K_K13576  L_L74  L_L109  0.0022
K_K13577  L_L74  L_L110  0.0021
K_K13578  L_L74  L_L111  0.0020
K_K13579  L_L74  L_L112  0.0020
K_K13580  L_L74  L_L113  0.0019
K_K13581  L_L74  L_L114  0.0019
K_K13582  L_L74  L_L115  0.0019
K_K13583  L_L74  L_L116  0.0018
K_K13584  L_L74  L_L117  0.0018
K_K13585  L_L74  L_L118  0.0017
K_K13586  L_L74  L_L119  0.0017
K_K13587  L_L74  L_L120  0.0016
K_K13588  L_L74  L_L121  0.0016
K_K13589  L_L74  L_L122  0.0016
K_K13590  L_L74  L_L123  0.0015
K_K13591  L_L74  L_L124  0.0015
K_K13592  L_L74  L_L125  0.0015
K_K13593  L_L74  L_L126  0.0015
K_K13594  L_L74  L_L127  0.0014
K_K13595  L_L74  L_L128  0.0014
K_K13596  L_L74  L_L129  0.0014
K_K13597  L_L74  L_L130  0.0014
K_K13598  L_L74  L_L131  0.0013
K_K13599  L_L74  L_L132  0.0013
K_K13600  L_L74  L_L133  0.0013
K_K13601  L_L74  L_L134  0.0013
K_K13602  L_L74  L_L135  0.0013
K_K13603  L_L74  L_L136  0.0012
K_K13604  L_L74  L_L137  0.0012
K_K13605  L_L74  L_L138  0.0012
K_K13606  L_L74  L_L139  0.0010
K_K13607  L_L74  L_L140  0.0011
K_K13608  L_L74  L_L141  0.0011
K_K13609  L_L74  L_L142  0.0011
K_K13610  L_L74  L_L143  0.0011
K_K13611  L_L74  L_L144  0.0011
K_K13612  L_L74  L_L145  0.0011
K_K13613  L_L74  L_L146  0.0011
K_K13614  L_L74  L_L147  0.0012
K_K13615  L_L74  L_L148  0.0012
K_K13616  L_L74  L_L149  0.0012
K_K13617  L_L74  L_L150  0.0012
K_K13618  L_L74  L_L151  0.0012
K_K13619  L_L74  L_L152  0.0013
K_K13620  L_L74  L_L153  0.0013
K_K13621  L_L74  L_L154  0.0013
K_K13622  L_L74  L_L155  0.0013
K_K13623  L_L74  L_L156  0.0014
K_K13624  L_L74  L_L157  0.0014
K_K13625  L_L74  L_L158  0.0014
K_K13626  L_L74  L_L159  0.0014
K_K13627  L_L74  L_L160  0.0015
K_K13628  L_L74  L_L161  0.0015
K_K13629  L_L74  L_L162  0.0015
K_K13630  L_L74  L_L163  0.0015
K_K13631  L_L74  L_L164  0.0016
K_K13632  L_L74  L_L165  0.0016
K_K13633  L_L74  L_L166  0.0016
K_K13634  L_L74  L_L167  0.0017
K_K13635  L_L74  L_L168  0.0017
K_K13636  L_L74  L_L169  0.0018
K_K13637  L_L74  L_L170  0.0018
K_K13638  L_L74  L_L171  0.0018
K_K13639  L_L74  L_L172  0.0019
K_K13640  L_L74  L_L173  0.0019
K_K13641  L_L74  L_L174  0.0020
K_K13642  L_L74  L_L175  0.0020
K_K13643  L_L74  L_L176  0.0021
K_K13644  L_L74  L_L177  0.0022
K_K13645  L_L74  L_L178  0.0022
K_K13646  L_L74  L_L179  0.0023
K_K13647  L_L74  L_L180  0.0024
K_K13648  L_L74  L_L181  0.0024
K_K13649  L_L74  L_L182  0.0025
K_K13650  L_L74  L_L183  0.0026
K_K13651  L_L74  L_L184  0.0027
K_K13652  L_L74  L_L185  0.0028
K_K13653  L_L74  L_L186  0.0029
K_K13654  L_L74  L_L187  0.0030
K_K13655  L_L74  L_L188  0.0032
K_K13656  L_L74  L_L189  0.0033
K_K13657  L_L74  L_L190  0.0034
K_K13658  L_L74  L_L191  0.0036
K_K13659  L_L74  L_L192  0.0038
K_K13660  L_L74  L_L193  0.0040
K_K13661  L_L74  L_L194  0.0042
K_K13662  L_L74  L_L195  0.0045
K_K13663  L_L74  L_L196  0.0047
K_K13664  L_L74  L_L197  0.0051
K_K13665  L_L74  L_L198  0.0054
K_K13666  L_L74  L_L199  0.0058
K_K13667  L_L74  L_L200  0.0063
K_K13668  L_L74  L_L201  0.0069
K_K13669  L_L74  L_L202  0.0076
K_K13670  L_L74  L_L203  0.0084
K_K13671  L_L74  L_L204  0.0095
K_K13672  L_L74  L_L205  0.0109
K_K13673  L_L74  L_L206  0.0127
K_K13674  L_L74  L_L207  0.0152
K_K13675  L_L74  L_L208  0.0191
K_K13676  L_L74  L_L209  0.0256
K_K13677  L_L74  L_L210  0.0389
K_K13678  L_L74  L_L211  0.0812
K_K13679  L_L74  L_L212  0.1569
K_K13680  L_L74  L_L213  0.0812
K_K13681  L_L74  L_L214  0.0389
K_K13682  L_L74  L_L215  0.0256
K_K13683  L_L74  L_L216  0.0191
K_K13684  L_L74  L_L217  0.0152
K_K13685  L_L74  L_L218  0.0127
K_K13686  L_L74  L_L219  0.0109
K_K13687  L_L74  L_L220  0.0095
K_K13688  L_L74  L_L221  0.0084
K_K13689  L_L74  L_L222  0.0076
K_K13690  L_L74  L_L223  0.0069
K_K13691  L_L74  L_L224  0.0063
K_K13692  L_L74  L_L225  0.0058
K_K13693  L_L74  L_L226  0.0054
K_K13694  L_L74  L_L227  0.0051
K_K13695  L_L74  L_L228  0.0047
K_K13696  L_L74  L_L229  0.0045
K_K13697  L_L74  L_L230  0.0042
K_K13698  L_L74  L_L231  0.0040
K_K13699  L_L74  L_L232  0.0038
K_K13700  L_L74  L_L233  0.0036
K_K13701  L_L74  L_L234  0.0034
K_K13702  L_L74  L_L235  0.0033
K_K13703  L_L74  L_L236  0.0032
K_K13704  L_L74  L_L237  0.0030
K_K13705  L_L74  L_L238  0.0029
K_K13706  L_L74  L_L239  0.0028
K_K13707  L_L74  L_L240  0.0027
K_K13708  L_L74  L_L241  0.0026
K_K13709  L_L74  L_L242  0.0025
K_K13710  L_L74  L_L243  0.0024
K_K13711  L_L74  L_L244  0.0024
K_K13712  L_L74  L_L245  0.0023
K_K13713  L_L74  L_L246  0.0022
K_K13714  L_L74  L_L247  0.0022
K_K13715  L_L74  L_L248  0.0021
K_K13716  L_L74  L_L249  0.0020
K_K13717  L_L74  L_L250  0.0020
K_K13718  L_L74  L_L251  0.0019
K_K13719  L_L74  L_L252  0.0019
K_K13720  L_L74  L_L253  0.0018
K_K13721  L_L74  L_L254  0.0018
K_K13722  L_L74  L_L255  0.0018
K_K13723  L_L74  L_L256  0.0017
K_K13724  L_L74  L_L257  0.0017
K_K13725  L_L74  L_L258  0.0016
K_K13726  L_L74  L_L259  0.0016
K_K13727  L_L74  L_L260  0.0016
K_K13728  L_L74  L_L261  0.0015
K_K13729  L_L74  L_L262  0.0015
K_K13730  L_L74  L_L263  0.0015
K_K13731  L_L74  L_L264  0.0015
K_K13732  L_L74  L_L265  0.0014
K_K13733  L_L74  L_L266  0.0014
K_K13734  L_L74  L_L267  0.0014
K_K13735  L_L74  L_L268  0.0014
K_K13736  L_L74  L_L269  0.0013
K_K13737  L_L74  L_L270  0.0013
K_K13738  L_L74  L_L271  0.0013
K_K13739  L_L74  L_L272  0.0013
K_K13740  L_L74  L_L273  0.0012
K_K13741  L_L74  L_L274  0.0012
K_K13742  L_L74  L_L275  0.0012
K_K13743  L_L74  L_L276  0.0012
* *  Branch  NTMP0000000074 - NTMP0000000075
R_R75  NTMP0000000074  nU_75  32.914993m  TC=0,0
V_Ui75  nU_75  nR_75  STIMULUS=U_IND_0000000075
R_V149  nR_75  nV_149  23.280268m  TC=0,0
L_V149  nR_75  nV_149  0.014646uH
R_V150  nV_149  nV_150  7.852787m  TC=0,0
L_V150  nV_149  nV_150  0.073723uH
L_L75  nV_150  NTMP0000000075  6.519695uH
K_K13744  L_L75  L_L76  0.1050
K_K13745  L_L75  L_L77  0.0397
K_K13746  L_L75  L_L78  0.0258
K_K13747  L_L75  L_L79  0.0192
K_K13748  L_L75  L_L80  0.0153
K_K13749  L_L75  L_L81  0.0127
K_K13750  L_L75  L_L82  0.0109
K_K13751  L_L75  L_L83  0.0095
K_K13752  L_L75  L_L84  0.0084
K_K13753  L_L75  L_L85  0.0076
K_K13754  L_L75  L_L86  0.0069
K_K13755  L_L75  L_L87  0.0063
K_K13756  L_L75  L_L88  0.0058
K_K13757  L_L75  L_L89  0.0054
K_K13758  L_L75  L_L90  0.0051
K_K13759  L_L75  L_L91  0.0047
K_K13760  L_L75  L_L92  0.0045
K_K13761  L_L75  L_L93  0.0042
K_K13762  L_L75  L_L94  0.0040
K_K13763  L_L75  L_L95  0.0038
K_K13764  L_L75  L_L96  0.0036
K_K13765  L_L75  L_L97  0.0034
K_K13766  L_L75  L_L98  0.0033
K_K13767  L_L75  L_L99  0.0032
K_K13768  L_L75  L_L100  0.0030
K_K13769  L_L75  L_L101  0.0029
K_K13770  L_L75  L_L102  0.0028
K_K13771  L_L75  L_L103  0.0027
K_K13772  L_L75  L_L104  0.0026
K_K13773  L_L75  L_L105  0.0025
K_K13774  L_L75  L_L106  0.0024
K_K13775  L_L75  L_L107  0.0024
K_K13776  L_L75  L_L108  0.0023
K_K13777  L_L75  L_L109  0.0022
K_K13778  L_L75  L_L110  0.0022
K_K13779  L_L75  L_L111  0.0021
K_K13780  L_L75  L_L112  0.0020
K_K13781  L_L75  L_L113  0.0020
K_K13782  L_L75  L_L114  0.0019
K_K13783  L_L75  L_L115  0.0019
K_K13784  L_L75  L_L116  0.0019
K_K13785  L_L75  L_L117  0.0018
K_K13786  L_L75  L_L118  0.0018
K_K13787  L_L75  L_L119  0.0017
K_K13788  L_L75  L_L120  0.0017
K_K13789  L_L75  L_L121  0.0016
K_K13790  L_L75  L_L122  0.0016
K_K13791  L_L75  L_L123  0.0016
K_K13792  L_L75  L_L124  0.0015
K_K13793  L_L75  L_L125  0.0015
K_K13794  L_L75  L_L126  0.0015
K_K13795  L_L75  L_L127  0.0015
K_K13796  L_L75  L_L128  0.0014
K_K13797  L_L75  L_L129  0.0014
K_K13798  L_L75  L_L130  0.0014
K_K13799  L_L75  L_L131  0.0014
K_K13800  L_L75  L_L132  0.0013
K_K13801  L_L75  L_L133  0.0013
K_K13802  L_L75  L_L134  0.0013
K_K13803  L_L75  L_L135  0.0013
K_K13804  L_L75  L_L136  0.0013
K_K13805  L_L75  L_L137  0.0012
K_K13806  L_L75  L_L138  0.0012
K_K13807  L_L75  L_L139  0.0010
K_K13808  L_L75  L_L140  0.0010
K_K13809  L_L75  L_L141  0.0011
K_K13810  L_L75  L_L142  0.0011
K_K13811  L_L75  L_L143  0.0011
K_K13812  L_L75  L_L144  0.0011
K_K13813  L_L75  L_L145  0.0011
K_K13814  L_L75  L_L146  0.0011
K_K13815  L_L75  L_L147  0.0011
K_K13816  L_L75  L_L148  0.0012
K_K13817  L_L75  L_L149  0.0012
K_K13818  L_L75  L_L150  0.0012
K_K13819  L_L75  L_L151  0.0012
K_K13820  L_L75  L_L152  0.0012
K_K13821  L_L75  L_L153  0.0013
K_K13822  L_L75  L_L154  0.0013
K_K13823  L_L75  L_L155  0.0013
K_K13824  L_L75  L_L156  0.0013
K_K13825  L_L75  L_L157  0.0014
K_K13826  L_L75  L_L158  0.0014
K_K13827  L_L75  L_L159  0.0014
K_K13828  L_L75  L_L160  0.0014
K_K13829  L_L75  L_L161  0.0015
K_K13830  L_L75  L_L162  0.0015
K_K13831  L_L75  L_L163  0.0015
K_K13832  L_L75  L_L164  0.0015
K_K13833  L_L75  L_L165  0.0016
K_K13834  L_L75  L_L166  0.0016
K_K13835  L_L75  L_L167  0.0016
K_K13836  L_L75  L_L168  0.0017
K_K13837  L_L75  L_L169  0.0017
K_K13838  L_L75  L_L170  0.0018
K_K13839  L_L75  L_L171  0.0018
K_K13840  L_L75  L_L172  0.0018
K_K13841  L_L75  L_L173  0.0019
K_K13842  L_L75  L_L174  0.0019
K_K13843  L_L75  L_L175  0.0020
K_K13844  L_L75  L_L176  0.0020
K_K13845  L_L75  L_L177  0.0021
K_K13846  L_L75  L_L178  0.0022
K_K13847  L_L75  L_L179  0.0022
K_K13848  L_L75  L_L180  0.0023
K_K13849  L_L75  L_L181  0.0024
K_K13850  L_L75  L_L182  0.0024
K_K13851  L_L75  L_L183  0.0025
K_K13852  L_L75  L_L184  0.0026
K_K13853  L_L75  L_L185  0.0027
K_K13854  L_L75  L_L186  0.0028
K_K13855  L_L75  L_L187  0.0029
K_K13856  L_L75  L_L188  0.0030
K_K13857  L_L75  L_L189  0.0032
K_K13858  L_L75  L_L190  0.0033
K_K13859  L_L75  L_L191  0.0034
K_K13860  L_L75  L_L192  0.0036
K_K13861  L_L75  L_L193  0.0038
K_K13862  L_L75  L_L194  0.0040
K_K13863  L_L75  L_L195  0.0042
K_K13864  L_L75  L_L196  0.0045
K_K13865  L_L75  L_L197  0.0047
K_K13866  L_L75  L_L198  0.0051
K_K13867  L_L75  L_L199  0.0054
K_K13868  L_L75  L_L200  0.0058
K_K13869  L_L75  L_L201  0.0063
K_K13870  L_L75  L_L202  0.0069
K_K13871  L_L75  L_L203  0.0076
K_K13872  L_L75  L_L204  0.0084
K_K13873  L_L75  L_L205  0.0095
K_K13874  L_L75  L_L206  0.0109
K_K13875  L_L75  L_L207  0.0127
K_K13876  L_L75  L_L208  0.0152
K_K13877  L_L75  L_L209  0.0191
K_K13878  L_L75  L_L210  0.0256
K_K13879  L_L75  L_L211  0.0389
K_K13880  L_L75  L_L212  0.0812
K_K13881  L_L75  L_L213  0.1569
K_K13882  L_L75  L_L214  0.0812
K_K13883  L_L75  L_L215  0.0389
K_K13884  L_L75  L_L216  0.0256
K_K13885  L_L75  L_L217  0.0191
K_K13886  L_L75  L_L218  0.0152
K_K13887  L_L75  L_L219  0.0127
K_K13888  L_L75  L_L220  0.0109
K_K13889  L_L75  L_L221  0.0095
K_K13890  L_L75  L_L222  0.0084
K_K13891  L_L75  L_L223  0.0076
K_K13892  L_L75  L_L224  0.0069
K_K13893  L_L75  L_L225  0.0063
K_K13894  L_L75  L_L226  0.0058
K_K13895  L_L75  L_L227  0.0054
K_K13896  L_L75  L_L228  0.0051
K_K13897  L_L75  L_L229  0.0047
K_K13898  L_L75  L_L230  0.0045
K_K13899  L_L75  L_L231  0.0042
K_K13900  L_L75  L_L232  0.0040
K_K13901  L_L75  L_L233  0.0038
K_K13902  L_L75  L_L234  0.0036
K_K13903  L_L75  L_L235  0.0034
K_K13904  L_L75  L_L236  0.0033
K_K13905  L_L75  L_L237  0.0032
K_K13906  L_L75  L_L238  0.0030
K_K13907  L_L75  L_L239  0.0029
K_K13908  L_L75  L_L240  0.0028
K_K13909  L_L75  L_L241  0.0027
K_K13910  L_L75  L_L242  0.0026
K_K13911  L_L75  L_L243  0.0025
K_K13912  L_L75  L_L244  0.0024
K_K13913  L_L75  L_L245  0.0024
K_K13914  L_L75  L_L246  0.0023
K_K13915  L_L75  L_L247  0.0022
K_K13916  L_L75  L_L248  0.0022
K_K13917  L_L75  L_L249  0.0021
K_K13918  L_L75  L_L250  0.0020
K_K13919  L_L75  L_L251  0.0020
K_K13920  L_L75  L_L252  0.0019
K_K13921  L_L75  L_L253  0.0019
K_K13922  L_L75  L_L254  0.0018
K_K13923  L_L75  L_L255  0.0018
K_K13924  L_L75  L_L256  0.0018
K_K13925  L_L75  L_L257  0.0017
K_K13926  L_L75  L_L258  0.0017
K_K13927  L_L75  L_L259  0.0016
K_K13928  L_L75  L_L260  0.0016
K_K13929  L_L75  L_L261  0.0016
K_K13930  L_L75  L_L262  0.0015
K_K13931  L_L75  L_L263  0.0015
K_K13932  L_L75  L_L264  0.0015
K_K13933  L_L75  L_L265  0.0015
K_K13934  L_L75  L_L266  0.0014
K_K13935  L_L75  L_L267  0.0014
K_K13936  L_L75  L_L268  0.0014
K_K13937  L_L75  L_L269  0.0014
K_K13938  L_L75  L_L270  0.0013
K_K13939  L_L75  L_L271  0.0013
K_K13940  L_L75  L_L272  0.0013
K_K13941  L_L75  L_L273  0.0013
K_K13942  L_L75  L_L274  0.0012
K_K13943  L_L75  L_L275  0.0012
K_K13944  L_L75  L_L276  0.0012
* *  Branch  NTMP0000000075 - NTMP0000000076
R_R76  NTMP0000000075  nU_76  32.914993m  TC=0,0
V_Ui76  nU_76  nR_76  STIMULUS=U_IND_0000000076
R_V151  nR_76  nV_151  23.280268m  TC=0,0
L_V151  nR_76  nV_151  0.014646uH
R_V152  nV_151  nV_152  7.852787m  TC=0,0
L_V152  nV_151  nV_152  0.073723uH
L_L76  nV_152  NTMP0000000076  6.519695uH
K_K13945  L_L76  L_L77  0.1050
K_K13946  L_L76  L_L78  0.0397
K_K13947  L_L76  L_L79  0.0258
K_K13948  L_L76  L_L80  0.0192
K_K13949  L_L76  L_L81  0.0153
K_K13950  L_L76  L_L82  0.0127
K_K13951  L_L76  L_L83  0.0109
K_K13952  L_L76  L_L84  0.0095
K_K13953  L_L76  L_L85  0.0084
K_K13954  L_L76  L_L86  0.0076
K_K13955  L_L76  L_L87  0.0069
K_K13956  L_L76  L_L88  0.0063
K_K13957  L_L76  L_L89  0.0058
K_K13958  L_L76  L_L90  0.0054
K_K13959  L_L76  L_L91  0.0051
K_K13960  L_L76  L_L92  0.0047
K_K13961  L_L76  L_L93  0.0045
K_K13962  L_L76  L_L94  0.0042
K_K13963  L_L76  L_L95  0.0040
K_K13964  L_L76  L_L96  0.0038
K_K13965  L_L76  L_L97  0.0036
K_K13966  L_L76  L_L98  0.0034
K_K13967  L_L76  L_L99  0.0033
K_K13968  L_L76  L_L100  0.0032
K_K13969  L_L76  L_L101  0.0030
K_K13970  L_L76  L_L102  0.0029
K_K13971  L_L76  L_L103  0.0028
K_K13972  L_L76  L_L104  0.0027
K_K13973  L_L76  L_L105  0.0026
K_K13974  L_L76  L_L106  0.0025
K_K13975  L_L76  L_L107  0.0024
K_K13976  L_L76  L_L108  0.0024
K_K13977  L_L76  L_L109  0.0023
K_K13978  L_L76  L_L110  0.0022
K_K13979  L_L76  L_L111  0.0022
K_K13980  L_L76  L_L112  0.0021
K_K13981  L_L76  L_L113  0.0020
K_K13982  L_L76  L_L114  0.0020
K_K13983  L_L76  L_L115  0.0019
K_K13984  L_L76  L_L116  0.0019
K_K13985  L_L76  L_L117  0.0019
K_K13986  L_L76  L_L118  0.0018
K_K13987  L_L76  L_L119  0.0018
K_K13988  L_L76  L_L120  0.0017
K_K13989  L_L76  L_L121  0.0017
K_K13990  L_L76  L_L122  0.0016
K_K13991  L_L76  L_L123  0.0016
K_K13992  L_L76  L_L124  0.0016
K_K13993  L_L76  L_L125  0.0015
K_K13994  L_L76  L_L126  0.0015
K_K13995  L_L76  L_L127  0.0015
K_K13996  L_L76  L_L128  0.0015
K_K13997  L_L76  L_L129  0.0014
K_K13998  L_L76  L_L130  0.0014
K_K13999  L_L76  L_L131  0.0014
K_K14000  L_L76  L_L132  0.0014
K_K14001  L_L76  L_L133  0.0013
K_K14002  L_L76  L_L134  0.0013
K_K14003  L_L76  L_L135  0.0013
K_K14004  L_L76  L_L136  0.0013
K_K14005  L_L76  L_L137  0.0013
K_K14006  L_L76  L_L138  0.0012
K_K14007  L_L76  L_L139  0.0010
K_K14008  L_L76  L_L140  0.0010
K_K14009  L_L76  L_L141  0.0010
K_K14010  L_L76  L_L142  0.0011
K_K14011  L_L76  L_L143  0.0011
K_K14012  L_L76  L_L144  0.0011
K_K14013  L_L76  L_L145  0.0011
K_K14014  L_L76  L_L146  0.0011
K_K14015  L_L76  L_L147  0.0011
K_K14016  L_L76  L_L148  0.0011
K_K14017  L_L76  L_L149  0.0012
K_K14018  L_L76  L_L150  0.0012
K_K14019  L_L76  L_L151  0.0012
K_K14020  L_L76  L_L152  0.0012
K_K14021  L_L76  L_L153  0.0012
K_K14022  L_L76  L_L154  0.0013
K_K14023  L_L76  L_L155  0.0013
K_K14024  L_L76  L_L156  0.0013
K_K14025  L_L76  L_L157  0.0013
K_K14026  L_L76  L_L158  0.0014
K_K14027  L_L76  L_L159  0.0014
K_K14028  L_L76  L_L160  0.0014
K_K14029  L_L76  L_L161  0.0014
K_K14030  L_L76  L_L162  0.0015
K_K14031  L_L76  L_L163  0.0015
K_K14032  L_L76  L_L164  0.0015
K_K14033  L_L76  L_L165  0.0015
K_K14034  L_L76  L_L166  0.0016
K_K14035  L_L76  L_L167  0.0016
K_K14036  L_L76  L_L168  0.0016
K_K14037  L_L76  L_L169  0.0017
K_K14038  L_L76  L_L170  0.0017
K_K14039  L_L76  L_L171  0.0018
K_K14040  L_L76  L_L172  0.0018
K_K14041  L_L76  L_L173  0.0018
K_K14042  L_L76  L_L174  0.0019
K_K14043  L_L76  L_L175  0.0019
K_K14044  L_L76  L_L176  0.0020
K_K14045  L_L76  L_L177  0.0020
K_K14046  L_L76  L_L178  0.0021
K_K14047  L_L76  L_L179  0.0022
K_K14048  L_L76  L_L180  0.0022
K_K14049  L_L76  L_L181  0.0023
K_K14050  L_L76  L_L182  0.0024
K_K14051  L_L76  L_L183  0.0024
K_K14052  L_L76  L_L184  0.0025
K_K14053  L_L76  L_L185  0.0026
K_K14054  L_L76  L_L186  0.0027
K_K14055  L_L76  L_L187  0.0028
K_K14056  L_L76  L_L188  0.0029
K_K14057  L_L76  L_L189  0.0030
K_K14058  L_L76  L_L190  0.0032
K_K14059  L_L76  L_L191  0.0033
K_K14060  L_L76  L_L192  0.0034
K_K14061  L_L76  L_L193  0.0036
K_K14062  L_L76  L_L194  0.0038
K_K14063  L_L76  L_L195  0.0040
K_K14064  L_L76  L_L196  0.0042
K_K14065  L_L76  L_L197  0.0045
K_K14066  L_L76  L_L198  0.0047
K_K14067  L_L76  L_L199  0.0051
K_K14068  L_L76  L_L200  0.0054
K_K14069  L_L76  L_L201  0.0058
K_K14070  L_L76  L_L202  0.0063
K_K14071  L_L76  L_L203  0.0069
K_K14072  L_L76  L_L204  0.0076
K_K14073  L_L76  L_L205  0.0084
K_K14074  L_L76  L_L206  0.0095
K_K14075  L_L76  L_L207  0.0109
K_K14076  L_L76  L_L208  0.0127
K_K14077  L_L76  L_L209  0.0152
K_K14078  L_L76  L_L210  0.0191
K_K14079  L_L76  L_L211  0.0256
K_K14080  L_L76  L_L212  0.0389
K_K14081  L_L76  L_L213  0.0812
K_K14082  L_L76  L_L214  0.1569
K_K14083  L_L76  L_L215  0.0812
K_K14084  L_L76  L_L216  0.0389
K_K14085  L_L76  L_L217  0.0256
K_K14086  L_L76  L_L218  0.0191
K_K14087  L_L76  L_L219  0.0152
K_K14088  L_L76  L_L220  0.0127
K_K14089  L_L76  L_L221  0.0109
K_K14090  L_L76  L_L222  0.0095
K_K14091  L_L76  L_L223  0.0084
K_K14092  L_L76  L_L224  0.0076
K_K14093  L_L76  L_L225  0.0069
K_K14094  L_L76  L_L226  0.0063
K_K14095  L_L76  L_L227  0.0058
K_K14096  L_L76  L_L228  0.0054
K_K14097  L_L76  L_L229  0.0051
K_K14098  L_L76  L_L230  0.0047
K_K14099  L_L76  L_L231  0.0045
K_K14100  L_L76  L_L232  0.0042
K_K14101  L_L76  L_L233  0.0040
K_K14102  L_L76  L_L234  0.0038
K_K14103  L_L76  L_L235  0.0036
K_K14104  L_L76  L_L236  0.0034
K_K14105  L_L76  L_L237  0.0033
K_K14106  L_L76  L_L238  0.0032
K_K14107  L_L76  L_L239  0.0030
K_K14108  L_L76  L_L240  0.0029
K_K14109  L_L76  L_L241  0.0028
K_K14110  L_L76  L_L242  0.0027
K_K14111  L_L76  L_L243  0.0026
K_K14112  L_L76  L_L244  0.0025
K_K14113  L_L76  L_L245  0.0024
K_K14114  L_L76  L_L246  0.0024
K_K14115  L_L76  L_L247  0.0023
K_K14116  L_L76  L_L248  0.0022
K_K14117  L_L76  L_L249  0.0022
K_K14118  L_L76  L_L250  0.0021
K_K14119  L_L76  L_L251  0.0020
K_K14120  L_L76  L_L252  0.0020
K_K14121  L_L76  L_L253  0.0019
K_K14122  L_L76  L_L254  0.0019
K_K14123  L_L76  L_L255  0.0018
K_K14124  L_L76  L_L256  0.0018
K_K14125  L_L76  L_L257  0.0018
K_K14126  L_L76  L_L258  0.0017
K_K14127  L_L76  L_L259  0.0017
K_K14128  L_L76  L_L260  0.0016
K_K14129  L_L76  L_L261  0.0016
K_K14130  L_L76  L_L262  0.0016
K_K14131  L_L76  L_L263  0.0015
K_K14132  L_L76  L_L264  0.0015
K_K14133  L_L76  L_L265  0.0015
K_K14134  L_L76  L_L266  0.0015
K_K14135  L_L76  L_L267  0.0014
K_K14136  L_L76  L_L268  0.0014
K_K14137  L_L76  L_L269  0.0014
K_K14138  L_L76  L_L270  0.0014
K_K14139  L_L76  L_L271  0.0013
K_K14140  L_L76  L_L272  0.0013
K_K14141  L_L76  L_L273  0.0013
K_K14142  L_L76  L_L274  0.0013
K_K14143  L_L76  L_L275  0.0012
K_K14144  L_L76  L_L276  0.0012
* *  Branch  NTMP0000000076 - NTMP0000000077
R_R77  NTMP0000000076  nU_77  32.914993m  TC=0,0
V_Ui77  nU_77  nR_77  STIMULUS=U_IND_0000000077
R_V153  nR_77  nV_153  23.280268m  TC=0,0
L_V153  nR_77  nV_153  0.014646uH
R_V154  nV_153  nV_154  7.852787m  TC=0,0
L_V154  nV_153  nV_154  0.073723uH
L_L77  nV_154  NTMP0000000077  6.519695uH
K_K14145  L_L77  L_L78  0.1050
K_K14146  L_L77  L_L79  0.0397
K_K14147  L_L77  L_L80  0.0258
K_K14148  L_L77  L_L81  0.0192
K_K14149  L_L77  L_L82  0.0153
K_K14150  L_L77  L_L83  0.0127
K_K14151  L_L77  L_L84  0.0109
K_K14152  L_L77  L_L85  0.0095
K_K14153  L_L77  L_L86  0.0084
K_K14154  L_L77  L_L87  0.0076
K_K14155  L_L77  L_L88  0.0069
K_K14156  L_L77  L_L89  0.0063
K_K14157  L_L77  L_L90  0.0058
K_K14158  L_L77  L_L91  0.0054
K_K14159  L_L77  L_L92  0.0051
K_K14160  L_L77  L_L93  0.0047
K_K14161  L_L77  L_L94  0.0045
K_K14162  L_L77  L_L95  0.0042
K_K14163  L_L77  L_L96  0.0040
K_K14164  L_L77  L_L97  0.0038
K_K14165  L_L77  L_L98  0.0036
K_K14166  L_L77  L_L99  0.0034
K_K14167  L_L77  L_L100  0.0033
K_K14168  L_L77  L_L101  0.0032
K_K14169  L_L77  L_L102  0.0030
K_K14170  L_L77  L_L103  0.0029
K_K14171  L_L77  L_L104  0.0028
K_K14172  L_L77  L_L105  0.0027
K_K14173  L_L77  L_L106  0.0026
K_K14174  L_L77  L_L107  0.0025
K_K14175  L_L77  L_L108  0.0024
K_K14176  L_L77  L_L109  0.0024
K_K14177  L_L77  L_L110  0.0023
K_K14178  L_L77  L_L111  0.0022
K_K14179  L_L77  L_L112  0.0022
K_K14180  L_L77  L_L113  0.0021
K_K14181  L_L77  L_L114  0.0020
K_K14182  L_L77  L_L115  0.0020
K_K14183  L_L77  L_L116  0.0019
K_K14184  L_L77  L_L117  0.0019
K_K14185  L_L77  L_L118  0.0019
K_K14186  L_L77  L_L119  0.0018
K_K14187  L_L77  L_L120  0.0018
K_K14188  L_L77  L_L121  0.0017
K_K14189  L_L77  L_L122  0.0017
K_K14190  L_L77  L_L123  0.0016
K_K14191  L_L77  L_L124  0.0016
K_K14192  L_L77  L_L125  0.0016
K_K14193  L_L77  L_L126  0.0015
K_K14194  L_L77  L_L127  0.0015
K_K14195  L_L77  L_L128  0.0015
K_K14196  L_L77  L_L129  0.0015
K_K14197  L_L77  L_L130  0.0014
K_K14198  L_L77  L_L131  0.0014
K_K14199  L_L77  L_L132  0.0014
K_K14200  L_L77  L_L133  0.0014
K_K14201  L_L77  L_L134  0.0013
K_K14202  L_L77  L_L135  0.0013
K_K14203  L_L77  L_L136  0.0013
K_K14204  L_L77  L_L137  0.0013
K_K14205  L_L77  L_L138  0.0013
K_K14206  L_L77  L_L140  0.0010
K_K14207  L_L77  L_L141  0.0010
K_K14208  L_L77  L_L142  0.0010
K_K14209  L_L77  L_L143  0.0011
K_K14210  L_L77  L_L144  0.0011
K_K14211  L_L77  L_L145  0.0011
K_K14212  L_L77  L_L146  0.0011
K_K14213  L_L77  L_L147  0.0011
K_K14214  L_L77  L_L148  0.0011
K_K14215  L_L77  L_L149  0.0011
K_K14216  L_L77  L_L150  0.0012
K_K14217  L_L77  L_L151  0.0012
K_K14218  L_L77  L_L152  0.0012
K_K14219  L_L77  L_L153  0.0012
K_K14220  L_L77  L_L154  0.0012
K_K14221  L_L77  L_L155  0.0013
K_K14222  L_L77  L_L156  0.0013
K_K14223  L_L77  L_L157  0.0013
K_K14224  L_L77  L_L158  0.0013
K_K14225  L_L77  L_L159  0.0014
K_K14226  L_L77  L_L160  0.0014
K_K14227  L_L77  L_L161  0.0014
K_K14228  L_L77  L_L162  0.0014
K_K14229  L_L77  L_L163  0.0015
K_K14230  L_L77  L_L164  0.0015
K_K14231  L_L77  L_L165  0.0015
K_K14232  L_L77  L_L166  0.0015
K_K14233  L_L77  L_L167  0.0016
K_K14234  L_L77  L_L168  0.0016
K_K14235  L_L77  L_L169  0.0016
K_K14236  L_L77  L_L170  0.0017
K_K14237  L_L77  L_L171  0.0017
K_K14238  L_L77  L_L172  0.0018
K_K14239  L_L77  L_L173  0.0018
K_K14240  L_L77  L_L174  0.0018
K_K14241  L_L77  L_L175  0.0019
K_K14242  L_L77  L_L176  0.0019
K_K14243  L_L77  L_L177  0.0020
K_K14244  L_L77  L_L178  0.0020
K_K14245  L_L77  L_L179  0.0021
K_K14246  L_L77  L_L180  0.0022
K_K14247  L_L77  L_L181  0.0022
K_K14248  L_L77  L_L182  0.0023
K_K14249  L_L77  L_L183  0.0024
K_K14250  L_L77  L_L184  0.0024
K_K14251  L_L77  L_L185  0.0025
K_K14252  L_L77  L_L186  0.0026
K_K14253  L_L77  L_L187  0.0027
K_K14254  L_L77  L_L188  0.0028
K_K14255  L_L77  L_L189  0.0029
K_K14256  L_L77  L_L190  0.0030
K_K14257  L_L77  L_L191  0.0032
K_K14258  L_L77  L_L192  0.0033
K_K14259  L_L77  L_L193  0.0034
K_K14260  L_L77  L_L194  0.0036
K_K14261  L_L77  L_L195  0.0038
K_K14262  L_L77  L_L196  0.0040
K_K14263  L_L77  L_L197  0.0042
K_K14264  L_L77  L_L198  0.0045
K_K14265  L_L77  L_L199  0.0047
K_K14266  L_L77  L_L200  0.0051
K_K14267  L_L77  L_L201  0.0054
K_K14268  L_L77  L_L202  0.0058
K_K14269  L_L77  L_L203  0.0063
K_K14270  L_L77  L_L204  0.0069
K_K14271  L_L77  L_L205  0.0076
K_K14272  L_L77  L_L206  0.0084
K_K14273  L_L77  L_L207  0.0095
K_K14274  L_L77  L_L208  0.0109
K_K14275  L_L77  L_L209  0.0127
K_K14276  L_L77  L_L210  0.0152
K_K14277  L_L77  L_L211  0.0191
K_K14278  L_L77  L_L212  0.0256
K_K14279  L_L77  L_L213  0.0389
K_K14280  L_L77  L_L214  0.0812
K_K14281  L_L77  L_L215  0.1569
K_K14282  L_L77  L_L216  0.0812
K_K14283  L_L77  L_L217  0.0389
K_K14284  L_L77  L_L218  0.0256
K_K14285  L_L77  L_L219  0.0191
K_K14286  L_L77  L_L220  0.0152
K_K14287  L_L77  L_L221  0.0127
K_K14288  L_L77  L_L222  0.0109
K_K14289  L_L77  L_L223  0.0095
K_K14290  L_L77  L_L224  0.0084
K_K14291  L_L77  L_L225  0.0076
K_K14292  L_L77  L_L226  0.0069
K_K14293  L_L77  L_L227  0.0063
K_K14294  L_L77  L_L228  0.0058
K_K14295  L_L77  L_L229  0.0054
K_K14296  L_L77  L_L230  0.0051
K_K14297  L_L77  L_L231  0.0047
K_K14298  L_L77  L_L232  0.0045
K_K14299  L_L77  L_L233  0.0042
K_K14300  L_L77  L_L234  0.0040
K_K14301  L_L77  L_L235  0.0038
K_K14302  L_L77  L_L236  0.0036
K_K14303  L_L77  L_L237  0.0034
K_K14304  L_L77  L_L238  0.0033
K_K14305  L_L77  L_L239  0.0032
K_K14306  L_L77  L_L240  0.0030
K_K14307  L_L77  L_L241  0.0029
K_K14308  L_L77  L_L242  0.0028
K_K14309  L_L77  L_L243  0.0027
K_K14310  L_L77  L_L244  0.0026
K_K14311  L_L77  L_L245  0.0025
K_K14312  L_L77  L_L246  0.0024
K_K14313  L_L77  L_L247  0.0024
K_K14314  L_L77  L_L248  0.0023
K_K14315  L_L77  L_L249  0.0022
K_K14316  L_L77  L_L250  0.0022
K_K14317  L_L77  L_L251  0.0021
K_K14318  L_L77  L_L252  0.0020
K_K14319  L_L77  L_L253  0.0020
K_K14320  L_L77  L_L254  0.0019
K_K14321  L_L77  L_L255  0.0019
K_K14322  L_L77  L_L256  0.0018
K_K14323  L_L77  L_L257  0.0018
K_K14324  L_L77  L_L258  0.0018
K_K14325  L_L77  L_L259  0.0017
K_K14326  L_L77  L_L260  0.0017
K_K14327  L_L77  L_L261  0.0016
K_K14328  L_L77  L_L262  0.0016
K_K14329  L_L77  L_L263  0.0016
K_K14330  L_L77  L_L264  0.0015
K_K14331  L_L77  L_L265  0.0015
K_K14332  L_L77  L_L266  0.0015
K_K14333  L_L77  L_L267  0.0015
K_K14334  L_L77  L_L268  0.0014
K_K14335  L_L77  L_L269  0.0014
K_K14336  L_L77  L_L270  0.0014
K_K14337  L_L77  L_L271  0.0014
K_K14338  L_L77  L_L272  0.0013
K_K14339  L_L77  L_L273  0.0013
K_K14340  L_L77  L_L274  0.0013
K_K14341  L_L77  L_L275  0.0013
K_K14342  L_L77  L_L276  0.0012
* *  Branch  NTMP0000000077 - NTMP0000000078
R_R78  NTMP0000000077  nU_78  32.914993m  TC=0,0
V_Ui78  nU_78  nR_78  STIMULUS=U_IND_0000000078
R_V155  nR_78  nV_155  23.280268m  TC=0,0
L_V155  nR_78  nV_155  0.014646uH
R_V156  nV_155  nV_156  7.852787m  TC=0,0
L_V156  nV_155  nV_156  0.073723uH
L_L78  nV_156  NTMP0000000078  6.519695uH
K_K14343  L_L78  L_L79  0.1050
K_K14344  L_L78  L_L80  0.0397
K_K14345  L_L78  L_L81  0.0258
K_K14346  L_L78  L_L82  0.0192
K_K14347  L_L78  L_L83  0.0153
K_K14348  L_L78  L_L84  0.0127
K_K14349  L_L78  L_L85  0.0109
K_K14350  L_L78  L_L86  0.0095
K_K14351  L_L78  L_L87  0.0084
K_K14352  L_L78  L_L88  0.0076
K_K14353  L_L78  L_L89  0.0069
K_K14354  L_L78  L_L90  0.0063
K_K14355  L_L78  L_L91  0.0058
K_K14356  L_L78  L_L92  0.0054
K_K14357  L_L78  L_L93  0.0051
K_K14358  L_L78  L_L94  0.0047
K_K14359  L_L78  L_L95  0.0045
K_K14360  L_L78  L_L96  0.0042
K_K14361  L_L78  L_L97  0.0040
K_K14362  L_L78  L_L98  0.0038
K_K14363  L_L78  L_L99  0.0036
K_K14364  L_L78  L_L100  0.0034
K_K14365  L_L78  L_L101  0.0033
K_K14366  L_L78  L_L102  0.0032
K_K14367  L_L78  L_L103  0.0030
K_K14368  L_L78  L_L104  0.0029
K_K14369  L_L78  L_L105  0.0028
K_K14370  L_L78  L_L106  0.0027
K_K14371  L_L78  L_L107  0.0026
K_K14372  L_L78  L_L108  0.0025
K_K14373  L_L78  L_L109  0.0024
K_K14374  L_L78  L_L110  0.0024
K_K14375  L_L78  L_L111  0.0023
K_K14376  L_L78  L_L112  0.0022
K_K14377  L_L78  L_L113  0.0022
K_K14378  L_L78  L_L114  0.0021
K_K14379  L_L78  L_L115  0.0020
K_K14380  L_L78  L_L116  0.0020
K_K14381  L_L78  L_L117  0.0019
K_K14382  L_L78  L_L118  0.0019
K_K14383  L_L78  L_L119  0.0019
K_K14384  L_L78  L_L120  0.0018
K_K14385  L_L78  L_L121  0.0018
K_K14386  L_L78  L_L122  0.0017
K_K14387  L_L78  L_L123  0.0017
K_K14388  L_L78  L_L124  0.0016
K_K14389  L_L78  L_L125  0.0016
K_K14390  L_L78  L_L126  0.0016
K_K14391  L_L78  L_L127  0.0015
K_K14392  L_L78  L_L128  0.0015
K_K14393  L_L78  L_L129  0.0015
K_K14394  L_L78  L_L130  0.0015
K_K14395  L_L78  L_L131  0.0014
K_K14396  L_L78  L_L132  0.0014
K_K14397  L_L78  L_L133  0.0014
K_K14398  L_L78  L_L134  0.0014
K_K14399  L_L78  L_L135  0.0013
K_K14400  L_L78  L_L136  0.0013
K_K14401  L_L78  L_L137  0.0013
K_K14402  L_L78  L_L138  0.0013
K_K14403  L_L78  L_L141  0.0010
K_K14404  L_L78  L_L142  0.0010
K_K14405  L_L78  L_L143  0.0010
K_K14406  L_L78  L_L144  0.0011
K_K14407  L_L78  L_L145  0.0011
K_K14408  L_L78  L_L146  0.0011
K_K14409  L_L78  L_L147  0.0011
K_K14410  L_L78  L_L148  0.0011
K_K14411  L_L78  L_L149  0.0011
K_K14412  L_L78  L_L150  0.0011
K_K14413  L_L78  L_L151  0.0012
K_K14414  L_L78  L_L152  0.0012
K_K14415  L_L78  L_L153  0.0012
K_K14416  L_L78  L_L154  0.0012
K_K14417  L_L78  L_L155  0.0012
K_K14418  L_L78  L_L156  0.0013
K_K14419  L_L78  L_L157  0.0013
K_K14420  L_L78  L_L158  0.0013
K_K14421  L_L78  L_L159  0.0013
K_K14422  L_L78  L_L160  0.0014
K_K14423  L_L78  L_L161  0.0014
K_K14424  L_L78  L_L162  0.0014
K_K14425  L_L78  L_L163  0.0014
K_K14426  L_L78  L_L164  0.0015
K_K14427  L_L78  L_L165  0.0015
K_K14428  L_L78  L_L166  0.0015
K_K14429  L_L78  L_L167  0.0015
K_K14430  L_L78  L_L168  0.0016
K_K14431  L_L78  L_L169  0.0016
K_K14432  L_L78  L_L170  0.0016
K_K14433  L_L78  L_L171  0.0017
K_K14434  L_L78  L_L172  0.0017
K_K14435  L_L78  L_L173  0.0018
K_K14436  L_L78  L_L174  0.0018
K_K14437  L_L78  L_L175  0.0018
K_K14438  L_L78  L_L176  0.0019
K_K14439  L_L78  L_L177  0.0019
K_K14440  L_L78  L_L178  0.0020
K_K14441  L_L78  L_L179  0.0020
K_K14442  L_L78  L_L180  0.0021
K_K14443  L_L78  L_L181  0.0022
K_K14444  L_L78  L_L182  0.0022
K_K14445  L_L78  L_L183  0.0023
K_K14446  L_L78  L_L184  0.0024
K_K14447  L_L78  L_L185  0.0024
K_K14448  L_L78  L_L186  0.0025
K_K14449  L_L78  L_L187  0.0026
K_K14450  L_L78  L_L188  0.0027
K_K14451  L_L78  L_L189  0.0028
K_K14452  L_L78  L_L190  0.0029
K_K14453  L_L78  L_L191  0.0030
K_K14454  L_L78  L_L192  0.0032
K_K14455  L_L78  L_L193  0.0033
K_K14456  L_L78  L_L194  0.0034
K_K14457  L_L78  L_L195  0.0036
K_K14458  L_L78  L_L196  0.0038
K_K14459  L_L78  L_L197  0.0040
K_K14460  L_L78  L_L198  0.0042
K_K14461  L_L78  L_L199  0.0045
K_K14462  L_L78  L_L200  0.0047
K_K14463  L_L78  L_L201  0.0051
K_K14464  L_L78  L_L202  0.0054
K_K14465  L_L78  L_L203  0.0058
K_K14466  L_L78  L_L204  0.0063
K_K14467  L_L78  L_L205  0.0069
K_K14468  L_L78  L_L206  0.0076
K_K14469  L_L78  L_L207  0.0084
K_K14470  L_L78  L_L208  0.0095
K_K14471  L_L78  L_L209  0.0109
K_K14472  L_L78  L_L210  0.0127
K_K14473  L_L78  L_L211  0.0152
K_K14474  L_L78  L_L212  0.0191
K_K14475  L_L78  L_L213  0.0256
K_K14476  L_L78  L_L214  0.0389
K_K14477  L_L78  L_L215  0.0812
K_K14478  L_L78  L_L216  0.1569
K_K14479  L_L78  L_L217  0.0812
K_K14480  L_L78  L_L218  0.0389
K_K14481  L_L78  L_L219  0.0256
K_K14482  L_L78  L_L220  0.0191
K_K14483  L_L78  L_L221  0.0152
K_K14484  L_L78  L_L222  0.0127
K_K14485  L_L78  L_L223  0.0109
K_K14486  L_L78  L_L224  0.0095
K_K14487  L_L78  L_L225  0.0084
K_K14488  L_L78  L_L226  0.0076
K_K14489  L_L78  L_L227  0.0069
K_K14490  L_L78  L_L228  0.0063
K_K14491  L_L78  L_L229  0.0058
K_K14492  L_L78  L_L230  0.0054
K_K14493  L_L78  L_L231  0.0051
K_K14494  L_L78  L_L232  0.0047
K_K14495  L_L78  L_L233  0.0045
K_K14496  L_L78  L_L234  0.0042
K_K14497  L_L78  L_L235  0.0040
K_K14498  L_L78  L_L236  0.0038
K_K14499  L_L78  L_L237  0.0036
K_K14500  L_L78  L_L238  0.0034
K_K14501  L_L78  L_L239  0.0033
K_K14502  L_L78  L_L240  0.0032
K_K14503  L_L78  L_L241  0.0030
K_K14504  L_L78  L_L242  0.0029
K_K14505  L_L78  L_L243  0.0028
K_K14506  L_L78  L_L244  0.0027
K_K14507  L_L78  L_L245  0.0026
K_K14508  L_L78  L_L246  0.0025
K_K14509  L_L78  L_L247  0.0024
K_K14510  L_L78  L_L248  0.0024
K_K14511  L_L78  L_L249  0.0023
K_K14512  L_L78  L_L250  0.0022
K_K14513  L_L78  L_L251  0.0022
K_K14514  L_L78  L_L252  0.0021
K_K14515  L_L78  L_L253  0.0020
K_K14516  L_L78  L_L254  0.0020
K_K14517  L_L78  L_L255  0.0019
K_K14518  L_L78  L_L256  0.0019
K_K14519  L_L78  L_L257  0.0018
K_K14520  L_L78  L_L258  0.0018
K_K14521  L_L78  L_L259  0.0018
K_K14522  L_L78  L_L260  0.0017
K_K14523  L_L78  L_L261  0.0017
K_K14524  L_L78  L_L262  0.0016
K_K14525  L_L78  L_L263  0.0016
K_K14526  L_L78  L_L264  0.0016
K_K14527  L_L78  L_L265  0.0015
K_K14528  L_L78  L_L266  0.0015
K_K14529  L_L78  L_L267  0.0015
K_K14530  L_L78  L_L268  0.0015
K_K14531  L_L78  L_L269  0.0014
K_K14532  L_L78  L_L270  0.0014
K_K14533  L_L78  L_L271  0.0014
K_K14534  L_L78  L_L272  0.0014
K_K14535  L_L78  L_L273  0.0013
K_K14536  L_L78  L_L274  0.0013
K_K14537  L_L78  L_L275  0.0013
K_K14538  L_L78  L_L276  0.0013
* *  Branch  NTMP0000000078 - NTMP0000000079
R_R79  NTMP0000000078  nU_79  32.914993m  TC=0,0
V_Ui79  nU_79  nR_79  STIMULUS=U_IND_0000000079
R_V157  nR_79  nV_157  23.280268m  TC=0,0
L_V157  nR_79  nV_157  0.014646uH
R_V158  nV_157  nV_158  7.852787m  TC=0,0
L_V158  nV_157  nV_158  0.073723uH
L_L79  nV_158  NTMP0000000079  6.519695uH
K_K14539  L_L79  L_L80  0.1050
K_K14540  L_L79  L_L81  0.0397
K_K14541  L_L79  L_L82  0.0258
K_K14542  L_L79  L_L83  0.0192
K_K14543  L_L79  L_L84  0.0153
K_K14544  L_L79  L_L85  0.0127
K_K14545  L_L79  L_L86  0.0109
K_K14546  L_L79  L_L87  0.0095
K_K14547  L_L79  L_L88  0.0084
K_K14548  L_L79  L_L89  0.0076
K_K14549  L_L79  L_L90  0.0069
K_K14550  L_L79  L_L91  0.0063
K_K14551  L_L79  L_L92  0.0058
K_K14552  L_L79  L_L93  0.0054
K_K14553  L_L79  L_L94  0.0051
K_K14554  L_L79  L_L95  0.0047
K_K14555  L_L79  L_L96  0.0045
K_K14556  L_L79  L_L97  0.0042
K_K14557  L_L79  L_L98  0.0040
K_K14558  L_L79  L_L99  0.0038
K_K14559  L_L79  L_L100  0.0036
K_K14560  L_L79  L_L101  0.0034
K_K14561  L_L79  L_L102  0.0033
K_K14562  L_L79  L_L103  0.0032
K_K14563  L_L79  L_L104  0.0030
K_K14564  L_L79  L_L105  0.0029
K_K14565  L_L79  L_L106  0.0028
K_K14566  L_L79  L_L107  0.0027
K_K14567  L_L79  L_L108  0.0026
K_K14568  L_L79  L_L109  0.0025
K_K14569  L_L79  L_L110  0.0024
K_K14570  L_L79  L_L111  0.0024
K_K14571  L_L79  L_L112  0.0023
K_K14572  L_L79  L_L113  0.0022
K_K14573  L_L79  L_L114  0.0022
K_K14574  L_L79  L_L115  0.0021
K_K14575  L_L79  L_L116  0.0020
K_K14576  L_L79  L_L117  0.0020
K_K14577  L_L79  L_L118  0.0019
K_K14578  L_L79  L_L119  0.0019
K_K14579  L_L79  L_L120  0.0019
K_K14580  L_L79  L_L121  0.0018
K_K14581  L_L79  L_L122  0.0018
K_K14582  L_L79  L_L123  0.0017
K_K14583  L_L79  L_L124  0.0017
K_K14584  L_L79  L_L125  0.0016
K_K14585  L_L79  L_L126  0.0016
K_K14586  L_L79  L_L127  0.0016
K_K14587  L_L79  L_L128  0.0015
K_K14588  L_L79  L_L129  0.0015
K_K14589  L_L79  L_L130  0.0015
K_K14590  L_L79  L_L131  0.0015
K_K14591  L_L79  L_L132  0.0014
K_K14592  L_L79  L_L133  0.0014
K_K14593  L_L79  L_L134  0.0014
K_K14594  L_L79  L_L135  0.0014
K_K14595  L_L79  L_L136  0.0013
K_K14596  L_L79  L_L137  0.0013
K_K14597  L_L79  L_L138  0.0013
K_K14598  L_L79  L_L142  0.0010
K_K14599  L_L79  L_L143  0.0010
K_K14600  L_L79  L_L144  0.0010
K_K14601  L_L79  L_L145  0.0011
K_K14602  L_L79  L_L146  0.0011
K_K14603  L_L79  L_L147  0.0011
K_K14604  L_L79  L_L148  0.0011
K_K14605  L_L79  L_L149  0.0011
K_K14606  L_L79  L_L150  0.0011
K_K14607  L_L79  L_L151  0.0011
K_K14608  L_L79  L_L152  0.0012
K_K14609  L_L79  L_L153  0.0012
K_K14610  L_L79  L_L154  0.0012
K_K14611  L_L79  L_L155  0.0012
K_K14612  L_L79  L_L156  0.0012
K_K14613  L_L79  L_L157  0.0013
K_K14614  L_L79  L_L158  0.0013
K_K14615  L_L79  L_L159  0.0013
K_K14616  L_L79  L_L160  0.0013
K_K14617  L_L79  L_L161  0.0014
K_K14618  L_L79  L_L162  0.0014
K_K14619  L_L79  L_L163  0.0014
K_K14620  L_L79  L_L164  0.0014
K_K14621  L_L79  L_L165  0.0015
K_K14622  L_L79  L_L166  0.0015
K_K14623  L_L79  L_L167  0.0015
K_K14624  L_L79  L_L168  0.0015
K_K14625  L_L79  L_L169  0.0016
K_K14626  L_L79  L_L170  0.0016
K_K14627  L_L79  L_L171  0.0016
K_K14628  L_L79  L_L172  0.0017
K_K14629  L_L79  L_L173  0.0017
K_K14630  L_L79  L_L174  0.0018
K_K14631  L_L79  L_L175  0.0018
K_K14632  L_L79  L_L176  0.0018
K_K14633  L_L79  L_L177  0.0019
K_K14634  L_L79  L_L178  0.0019
K_K14635  L_L79  L_L179  0.0020
K_K14636  L_L79  L_L180  0.0020
K_K14637  L_L79  L_L181  0.0021
K_K14638  L_L79  L_L182  0.0022
K_K14639  L_L79  L_L183  0.0022
K_K14640  L_L79  L_L184  0.0023
K_K14641  L_L79  L_L185  0.0024
K_K14642  L_L79  L_L186  0.0024
K_K14643  L_L79  L_L187  0.0025
K_K14644  L_L79  L_L188  0.0026
K_K14645  L_L79  L_L189  0.0027
K_K14646  L_L79  L_L190  0.0028
K_K14647  L_L79  L_L191  0.0029
K_K14648  L_L79  L_L192  0.0030
K_K14649  L_L79  L_L193  0.0032
K_K14650  L_L79  L_L194  0.0033
K_K14651  L_L79  L_L195  0.0034
K_K14652  L_L79  L_L196  0.0036
K_K14653  L_L79  L_L197  0.0038
K_K14654  L_L79  L_L198  0.0040
K_K14655  L_L79  L_L199  0.0042
K_K14656  L_L79  L_L200  0.0045
K_K14657  L_L79  L_L201  0.0047
K_K14658  L_L79  L_L202  0.0051
K_K14659  L_L79  L_L203  0.0054
K_K14660  L_L79  L_L204  0.0058
K_K14661  L_L79  L_L205  0.0063
K_K14662  L_L79  L_L206  0.0069
K_K14663  L_L79  L_L207  0.0076
K_K14664  L_L79  L_L208  0.0084
K_K14665  L_L79  L_L209  0.0095
K_K14666  L_L79  L_L210  0.0109
K_K14667  L_L79  L_L211  0.0127
K_K14668  L_L79  L_L212  0.0152
K_K14669  L_L79  L_L213  0.0191
K_K14670  L_L79  L_L214  0.0256
K_K14671  L_L79  L_L215  0.0389
K_K14672  L_L79  L_L216  0.0812
K_K14673  L_L79  L_L217  0.1569
K_K14674  L_L79  L_L218  0.0812
K_K14675  L_L79  L_L219  0.0389
K_K14676  L_L79  L_L220  0.0256
K_K14677  L_L79  L_L221  0.0191
K_K14678  L_L79  L_L222  0.0152
K_K14679  L_L79  L_L223  0.0127
K_K14680  L_L79  L_L224  0.0109
K_K14681  L_L79  L_L225  0.0095
K_K14682  L_L79  L_L226  0.0084
K_K14683  L_L79  L_L227  0.0076
K_K14684  L_L79  L_L228  0.0069
K_K14685  L_L79  L_L229  0.0063
K_K14686  L_L79  L_L230  0.0058
K_K14687  L_L79  L_L231  0.0054
K_K14688  L_L79  L_L232  0.0051
K_K14689  L_L79  L_L233  0.0047
K_K14690  L_L79  L_L234  0.0045
K_K14691  L_L79  L_L235  0.0042
K_K14692  L_L79  L_L236  0.0040
K_K14693  L_L79  L_L237  0.0038
K_K14694  L_L79  L_L238  0.0036
K_K14695  L_L79  L_L239  0.0034
K_K14696  L_L79  L_L240  0.0033
K_K14697  L_L79  L_L241  0.0032
K_K14698  L_L79  L_L242  0.0030
K_K14699  L_L79  L_L243  0.0029
K_K14700  L_L79  L_L244  0.0028
K_K14701  L_L79  L_L245  0.0027
K_K14702  L_L79  L_L246  0.0026
K_K14703  L_L79  L_L247  0.0025
K_K14704  L_L79  L_L248  0.0024
K_K14705  L_L79  L_L249  0.0024
K_K14706  L_L79  L_L250  0.0023
K_K14707  L_L79  L_L251  0.0022
K_K14708  L_L79  L_L252  0.0022
K_K14709  L_L79  L_L253  0.0021
K_K14710  L_L79  L_L254  0.0020
K_K14711  L_L79  L_L255  0.0020
K_K14712  L_L79  L_L256  0.0019
K_K14713  L_L79  L_L257  0.0019
K_K14714  L_L79  L_L258  0.0018
K_K14715  L_L79  L_L259  0.0018
K_K14716  L_L79  L_L260  0.0018
K_K14717  L_L79  L_L261  0.0017
K_K14718  L_L79  L_L262  0.0017
K_K14719  L_L79  L_L263  0.0016
K_K14720  L_L79  L_L264  0.0016
K_K14721  L_L79  L_L265  0.0016
K_K14722  L_L79  L_L266  0.0015
K_K14723  L_L79  L_L267  0.0015
K_K14724  L_L79  L_L268  0.0015
K_K14725  L_L79  L_L269  0.0015
K_K14726  L_L79  L_L270  0.0014
K_K14727  L_L79  L_L271  0.0014
K_K14728  L_L79  L_L272  0.0014
K_K14729  L_L79  L_L273  0.0014
K_K14730  L_L79  L_L274  0.0013
K_K14731  L_L79  L_L275  0.0013
K_K14732  L_L79  L_L276  0.0013
* *  Branch  NTMP0000000079 - NTMP0000000080
R_R80  NTMP0000000079  nU_80  32.914993m  TC=0,0
V_Ui80  nU_80  nR_80  STIMULUS=U_IND_0000000080
R_V159  nR_80  nV_159  23.280268m  TC=0,0
L_V159  nR_80  nV_159  0.014646uH
R_V160  nV_159  nV_160  7.852787m  TC=0,0
L_V160  nV_159  nV_160  0.073723uH
L_L80  nV_160  NTMP0000000080  6.519695uH
K_K14733  L_L80  L_L81  0.1050
K_K14734  L_L80  L_L82  0.0397
K_K14735  L_L80  L_L83  0.0258
K_K14736  L_L80  L_L84  0.0192
K_K14737  L_L80  L_L85  0.0153
K_K14738  L_L80  L_L86  0.0127
K_K14739  L_L80  L_L87  0.0109
K_K14740  L_L80  L_L88  0.0095
K_K14741  L_L80  L_L89  0.0084
K_K14742  L_L80  L_L90  0.0076
K_K14743  L_L80  L_L91  0.0069
K_K14744  L_L80  L_L92  0.0063
K_K14745  L_L80  L_L93  0.0058
K_K14746  L_L80  L_L94  0.0054
K_K14747  L_L80  L_L95  0.0051
K_K14748  L_L80  L_L96  0.0047
K_K14749  L_L80  L_L97  0.0045
K_K14750  L_L80  L_L98  0.0042
K_K14751  L_L80  L_L99  0.0040
K_K14752  L_L80  L_L100  0.0038
K_K14753  L_L80  L_L101  0.0036
K_K14754  L_L80  L_L102  0.0034
K_K14755  L_L80  L_L103  0.0033
K_K14756  L_L80  L_L104  0.0032
K_K14757  L_L80  L_L105  0.0030
K_K14758  L_L80  L_L106  0.0029
K_K14759  L_L80  L_L107  0.0028
K_K14760  L_L80  L_L108  0.0027
K_K14761  L_L80  L_L109  0.0026
K_K14762  L_L80  L_L110  0.0025
K_K14763  L_L80  L_L111  0.0024
K_K14764  L_L80  L_L112  0.0024
K_K14765  L_L80  L_L113  0.0023
K_K14766  L_L80  L_L114  0.0022
K_K14767  L_L80  L_L115  0.0022
K_K14768  L_L80  L_L116  0.0021
K_K14769  L_L80  L_L117  0.0020
K_K14770  L_L80  L_L118  0.0020
K_K14771  L_L80  L_L119  0.0019
K_K14772  L_L80  L_L120  0.0019
K_K14773  L_L80  L_L121  0.0019
K_K14774  L_L80  L_L122  0.0018
K_K14775  L_L80  L_L123  0.0018
K_K14776  L_L80  L_L124  0.0017
K_K14777  L_L80  L_L125  0.0017
K_K14778  L_L80  L_L126  0.0017
K_K14779  L_L80  L_L127  0.0016
K_K14780  L_L80  L_L128  0.0016
K_K14781  L_L80  L_L129  0.0015
K_K14782  L_L80  L_L130  0.0015
K_K14783  L_L80  L_L131  0.0015
K_K14784  L_L80  L_L132  0.0015
K_K14785  L_L80  L_L133  0.0014
K_K14786  L_L80  L_L134  0.0014
K_K14787  L_L80  L_L135  0.0014
K_K14788  L_L80  L_L136  0.0014
K_K14789  L_L80  L_L137  0.0013
K_K14790  L_L80  L_L138  0.0013
K_K14791  L_L80  L_L143  0.0010
K_K14792  L_L80  L_L144  0.0010
K_K14793  L_L80  L_L145  0.0010
K_K14794  L_L80  L_L146  0.0011
K_K14795  L_L80  L_L147  0.0011
K_K14796  L_L80  L_L148  0.0011
K_K14797  L_L80  L_L149  0.0011
K_K14798  L_L80  L_L150  0.0011
K_K14799  L_L80  L_L151  0.0011
K_K14800  L_L80  L_L152  0.0011
K_K14801  L_L80  L_L153  0.0012
K_K14802  L_L80  L_L154  0.0012
K_K14803  L_L80  L_L155  0.0012
K_K14804  L_L80  L_L156  0.0012
K_K14805  L_L80  L_L157  0.0012
K_K14806  L_L80  L_L158  0.0013
K_K14807  L_L80  L_L159  0.0013
K_K14808  L_L80  L_L160  0.0013
K_K14809  L_L80  L_L161  0.0013
K_K14810  L_L80  L_L162  0.0014
K_K14811  L_L80  L_L163  0.0014
K_K14812  L_L80  L_L164  0.0014
K_K14813  L_L80  L_L165  0.0014
K_K14814  L_L80  L_L166  0.0015
K_K14815  L_L80  L_L167  0.0015
K_K14816  L_L80  L_L168  0.0015
K_K14817  L_L80  L_L169  0.0015
K_K14818  L_L80  L_L170  0.0016
K_K14819  L_L80  L_L171  0.0016
K_K14820  L_L80  L_L172  0.0016
K_K14821  L_L80  L_L173  0.0017
K_K14822  L_L80  L_L174  0.0017
K_K14823  L_L80  L_L175  0.0018
K_K14824  L_L80  L_L176  0.0018
K_K14825  L_L80  L_L177  0.0018
K_K14826  L_L80  L_L178  0.0019
K_K14827  L_L80  L_L179  0.0019
K_K14828  L_L80  L_L180  0.0020
K_K14829  L_L80  L_L181  0.0020
K_K14830  L_L80  L_L182  0.0021
K_K14831  L_L80  L_L183  0.0022
K_K14832  L_L80  L_L184  0.0022
K_K14833  L_L80  L_L185  0.0023
K_K14834  L_L80  L_L186  0.0024
K_K14835  L_L80  L_L187  0.0024
K_K14836  L_L80  L_L188  0.0025
K_K14837  L_L80  L_L189  0.0026
K_K14838  L_L80  L_L190  0.0027
K_K14839  L_L80  L_L191  0.0028
K_K14840  L_L80  L_L192  0.0029
K_K14841  L_L80  L_L193  0.0030
K_K14842  L_L80  L_L194  0.0032
K_K14843  L_L80  L_L195  0.0033
K_K14844  L_L80  L_L196  0.0034
K_K14845  L_L80  L_L197  0.0036
K_K14846  L_L80  L_L198  0.0038
K_K14847  L_L80  L_L199  0.0040
K_K14848  L_L80  L_L200  0.0042
K_K14849  L_L80  L_L201  0.0045
K_K14850  L_L80  L_L202  0.0047
K_K14851  L_L80  L_L203  0.0051
K_K14852  L_L80  L_L204  0.0054
K_K14853  L_L80  L_L205  0.0058
K_K14854  L_L80  L_L206  0.0063
K_K14855  L_L80  L_L207  0.0069
K_K14856  L_L80  L_L208  0.0076
K_K14857  L_L80  L_L209  0.0084
K_K14858  L_L80  L_L210  0.0095
K_K14859  L_L80  L_L211  0.0109
K_K14860  L_L80  L_L212  0.0127
K_K14861  L_L80  L_L213  0.0152
K_K14862  L_L80  L_L214  0.0191
K_K14863  L_L80  L_L215  0.0256
K_K14864  L_L80  L_L216  0.0389
K_K14865  L_L80  L_L217  0.0812
K_K14866  L_L80  L_L218  0.1569
K_K14867  L_L80  L_L219  0.0812
K_K14868  L_L80  L_L220  0.0389
K_K14869  L_L80  L_L221  0.0256
K_K14870  L_L80  L_L222  0.0191
K_K14871  L_L80  L_L223  0.0152
K_K14872  L_L80  L_L224  0.0127
K_K14873  L_L80  L_L225  0.0109
K_K14874  L_L80  L_L226  0.0095
K_K14875  L_L80  L_L227  0.0084
K_K14876  L_L80  L_L228  0.0076
K_K14877  L_L80  L_L229  0.0069
K_K14878  L_L80  L_L230  0.0063
K_K14879  L_L80  L_L231  0.0058
K_K14880  L_L80  L_L232  0.0054
K_K14881  L_L80  L_L233  0.0051
K_K14882  L_L80  L_L234  0.0047
K_K14883  L_L80  L_L235  0.0045
K_K14884  L_L80  L_L236  0.0042
K_K14885  L_L80  L_L237  0.0040
K_K14886  L_L80  L_L238  0.0038
K_K14887  L_L80  L_L239  0.0036
K_K14888  L_L80  L_L240  0.0034
K_K14889  L_L80  L_L241  0.0033
K_K14890  L_L80  L_L242  0.0032
K_K14891  L_L80  L_L243  0.0030
K_K14892  L_L80  L_L244  0.0029
K_K14893  L_L80  L_L245  0.0028
K_K14894  L_L80  L_L246  0.0027
K_K14895  L_L80  L_L247  0.0026
K_K14896  L_L80  L_L248  0.0025
K_K14897  L_L80  L_L249  0.0024
K_K14898  L_L80  L_L250  0.0024
K_K14899  L_L80  L_L251  0.0023
K_K14900  L_L80  L_L252  0.0022
K_K14901  L_L80  L_L253  0.0022
K_K14902  L_L80  L_L254  0.0021
K_K14903  L_L80  L_L255  0.0020
K_K14904  L_L80  L_L256  0.0020
K_K14905  L_L80  L_L257  0.0019
K_K14906  L_L80  L_L258  0.0019
K_K14907  L_L80  L_L259  0.0018
K_K14908  L_L80  L_L260  0.0018
K_K14909  L_L80  L_L261  0.0018
K_K14910  L_L80  L_L262  0.0017
K_K14911  L_L80  L_L263  0.0017
K_K14912  L_L80  L_L264  0.0016
K_K14913  L_L80  L_L265  0.0016
K_K14914  L_L80  L_L266  0.0016
K_K14915  L_L80  L_L267  0.0015
K_K14916  L_L80  L_L268  0.0015
K_K14917  L_L80  L_L269  0.0015
K_K14918  L_L80  L_L270  0.0015
K_K14919  L_L80  L_L271  0.0014
K_K14920  L_L80  L_L272  0.0014
K_K14921  L_L80  L_L273  0.0014
K_K14922  L_L80  L_L274  0.0014
K_K14923  L_L80  L_L275  0.0013
K_K14924  L_L80  L_L276  0.0013
* *  Branch  NTMP0000000080 - NTMP0000000081
R_R81  NTMP0000000080  nU_81  32.914993m  TC=0,0
V_Ui81  nU_81  nR_81  STIMULUS=U_IND_0000000081
R_V161  nR_81  nV_161  23.280268m  TC=0,0
L_V161  nR_81  nV_161  0.014646uH
R_V162  nV_161  nV_162  7.852787m  TC=0,0
L_V162  nV_161  nV_162  0.073723uH
L_L81  nV_162  NTMP0000000081  6.519695uH
K_K14925  L_L81  L_L82  0.1050
K_K14926  L_L81  L_L83  0.0397
K_K14927  L_L81  L_L84  0.0258
K_K14928  L_L81  L_L85  0.0192
K_K14929  L_L81  L_L86  0.0153
K_K14930  L_L81  L_L87  0.0127
K_K14931  L_L81  L_L88  0.0109
K_K14932  L_L81  L_L89  0.0095
K_K14933  L_L81  L_L90  0.0084
K_K14934  L_L81  L_L91  0.0076
K_K14935  L_L81  L_L92  0.0069
K_K14936  L_L81  L_L93  0.0063
K_K14937  L_L81  L_L94  0.0058
K_K14938  L_L81  L_L95  0.0054
K_K14939  L_L81  L_L96  0.0051
K_K14940  L_L81  L_L97  0.0047
K_K14941  L_L81  L_L98  0.0045
K_K14942  L_L81  L_L99  0.0042
K_K14943  L_L81  L_L100  0.0040
K_K14944  L_L81  L_L101  0.0038
K_K14945  L_L81  L_L102  0.0036
K_K14946  L_L81  L_L103  0.0034
K_K14947  L_L81  L_L104  0.0033
K_K14948  L_L81  L_L105  0.0032
K_K14949  L_L81  L_L106  0.0030
K_K14950  L_L81  L_L107  0.0029
K_K14951  L_L81  L_L108  0.0028
K_K14952  L_L81  L_L109  0.0027
K_K14953  L_L81  L_L110  0.0026
K_K14954  L_L81  L_L111  0.0025
K_K14955  L_L81  L_L112  0.0024
K_K14956  L_L81  L_L113  0.0024
K_K14957  L_L81  L_L114  0.0023
K_K14958  L_L81  L_L115  0.0022
K_K14959  L_L81  L_L116  0.0022
K_K14960  L_L81  L_L117  0.0021
K_K14961  L_L81  L_L118  0.0020
K_K14962  L_L81  L_L119  0.0020
K_K14963  L_L81  L_L120  0.0019
K_K14964  L_L81  L_L121  0.0019
K_K14965  L_L81  L_L122  0.0019
K_K14966  L_L81  L_L123  0.0018
K_K14967  L_L81  L_L124  0.0018
K_K14968  L_L81  L_L125  0.0017
K_K14969  L_L81  L_L126  0.0017
K_K14970  L_L81  L_L127  0.0017
K_K14971  L_L81  L_L128  0.0016
K_K14972  L_L81  L_L129  0.0016
K_K14973  L_L81  L_L130  0.0015
K_K14974  L_L81  L_L131  0.0015
K_K14975  L_L81  L_L132  0.0015
K_K14976  L_L81  L_L133  0.0015
K_K14977  L_L81  L_L134  0.0014
K_K14978  L_L81  L_L135  0.0014
K_K14979  L_L81  L_L136  0.0014
K_K14980  L_L81  L_L137  0.0014
K_K14981  L_L81  L_L138  0.0013
K_K14982  L_L81  L_L144  0.0010
K_K14983  L_L81  L_L145  0.0010
K_K14984  L_L81  L_L146  0.0010
K_K14985  L_L81  L_L147  0.0011
K_K14986  L_L81  L_L148  0.0011
K_K14987  L_L81  L_L149  0.0011
K_K14988  L_L81  L_L150  0.0011
K_K14989  L_L81  L_L151  0.0011
K_K14990  L_L81  L_L152  0.0011
K_K14991  L_L81  L_L153  0.0011
K_K14992  L_L81  L_L154  0.0012
K_K14993  L_L81  L_L155  0.0012
K_K14994  L_L81  L_L156  0.0012
K_K14995  L_L81  L_L157  0.0012
K_K14996  L_L81  L_L158  0.0012
K_K14997  L_L81  L_L159  0.0013
K_K14998  L_L81  L_L160  0.0013
K_K14999  L_L81  L_L161  0.0013
K_K15000  L_L81  L_L162  0.0013
K_K15001  L_L81  L_L163  0.0014
K_K15002  L_L81  L_L164  0.0014
K_K15003  L_L81  L_L165  0.0014
K_K15004  L_L81  L_L166  0.0014
K_K15005  L_L81  L_L167  0.0015
K_K15006  L_L81  L_L168  0.0015
K_K15007  L_L81  L_L169  0.0015
K_K15008  L_L81  L_L170  0.0015
K_K15009  L_L81  L_L171  0.0016
K_K15010  L_L81  L_L172  0.0016
K_K15011  L_L81  L_L173  0.0016
K_K15012  L_L81  L_L174  0.0017
K_K15013  L_L81  L_L175  0.0017
K_K15014  L_L81  L_L176  0.0018
K_K15015  L_L81  L_L177  0.0018
K_K15016  L_L81  L_L178  0.0018
K_K15017  L_L81  L_L179  0.0019
K_K15018  L_L81  L_L180  0.0019
K_K15019  L_L81  L_L181  0.0020
K_K15020  L_L81  L_L182  0.0020
K_K15021  L_L81  L_L183  0.0021
K_K15022  L_L81  L_L184  0.0022
K_K15023  L_L81  L_L185  0.0022
K_K15024  L_L81  L_L186  0.0023
K_K15025  L_L81  L_L187  0.0024
K_K15026  L_L81  L_L188  0.0024
K_K15027  L_L81  L_L189  0.0025
K_K15028  L_L81  L_L190  0.0026
K_K15029  L_L81  L_L191  0.0027
K_K15030  L_L81  L_L192  0.0028
K_K15031  L_L81  L_L193  0.0029
K_K15032  L_L81  L_L194  0.0030
K_K15033  L_L81  L_L195  0.0032
K_K15034  L_L81  L_L196  0.0033
K_K15035  L_L81  L_L197  0.0034
K_K15036  L_L81  L_L198  0.0036
K_K15037  L_L81  L_L199  0.0038
K_K15038  L_L81  L_L200  0.0040
K_K15039  L_L81  L_L201  0.0042
K_K15040  L_L81  L_L202  0.0045
K_K15041  L_L81  L_L203  0.0047
K_K15042  L_L81  L_L204  0.0051
K_K15043  L_L81  L_L205  0.0054
K_K15044  L_L81  L_L206  0.0058
K_K15045  L_L81  L_L207  0.0063
K_K15046  L_L81  L_L208  0.0069
K_K15047  L_L81  L_L209  0.0076
K_K15048  L_L81  L_L210  0.0084
K_K15049  L_L81  L_L211  0.0095
K_K15050  L_L81  L_L212  0.0109
K_K15051  L_L81  L_L213  0.0127
K_K15052  L_L81  L_L214  0.0152
K_K15053  L_L81  L_L215  0.0191
K_K15054  L_L81  L_L216  0.0256
K_K15055  L_L81  L_L217  0.0389
K_K15056  L_L81  L_L218  0.0812
K_K15057  L_L81  L_L219  0.1569
K_K15058  L_L81  L_L220  0.0812
K_K15059  L_L81  L_L221  0.0389
K_K15060  L_L81  L_L222  0.0256
K_K15061  L_L81  L_L223  0.0191
K_K15062  L_L81  L_L224  0.0152
K_K15063  L_L81  L_L225  0.0127
K_K15064  L_L81  L_L226  0.0109
K_K15065  L_L81  L_L227  0.0095
K_K15066  L_L81  L_L228  0.0084
K_K15067  L_L81  L_L229  0.0076
K_K15068  L_L81  L_L230  0.0069
K_K15069  L_L81  L_L231  0.0063
K_K15070  L_L81  L_L232  0.0058
K_K15071  L_L81  L_L233  0.0054
K_K15072  L_L81  L_L234  0.0051
K_K15073  L_L81  L_L235  0.0047
K_K15074  L_L81  L_L236  0.0045
K_K15075  L_L81  L_L237  0.0042
K_K15076  L_L81  L_L238  0.0040
K_K15077  L_L81  L_L239  0.0038
K_K15078  L_L81  L_L240  0.0036
K_K15079  L_L81  L_L241  0.0034
K_K15080  L_L81  L_L242  0.0033
K_K15081  L_L81  L_L243  0.0032
K_K15082  L_L81  L_L244  0.0030
K_K15083  L_L81  L_L245  0.0029
K_K15084  L_L81  L_L246  0.0028
K_K15085  L_L81  L_L247  0.0027
K_K15086  L_L81  L_L248  0.0026
K_K15087  L_L81  L_L249  0.0025
K_K15088  L_L81  L_L250  0.0024
K_K15089  L_L81  L_L251  0.0024
K_K15090  L_L81  L_L252  0.0023
K_K15091  L_L81  L_L253  0.0022
K_K15092  L_L81  L_L254  0.0022
K_K15093  L_L81  L_L255  0.0021
K_K15094  L_L81  L_L256  0.0020
K_K15095  L_L81  L_L257  0.0020
K_K15096  L_L81  L_L258  0.0019
K_K15097  L_L81  L_L259  0.0019
K_K15098  L_L81  L_L260  0.0018
K_K15099  L_L81  L_L261  0.0018
K_K15100  L_L81  L_L262  0.0018
K_K15101  L_L81  L_L263  0.0017
K_K15102  L_L81  L_L264  0.0017
K_K15103  L_L81  L_L265  0.0016
K_K15104  L_L81  L_L266  0.0016
K_K15105  L_L81  L_L267  0.0016
K_K15106  L_L81  L_L268  0.0015
K_K15107  L_L81  L_L269  0.0015
K_K15108  L_L81  L_L270  0.0015
K_K15109  L_L81  L_L271  0.0015
K_K15110  L_L81  L_L272  0.0014
K_K15111  L_L81  L_L273  0.0014
K_K15112  L_L81  L_L274  0.0014
K_K15113  L_L81  L_L275  0.0014
K_K15114  L_L81  L_L276  0.0013
* *  Branch  NTMP0000000081 - NTMP0000000082
R_R82  NTMP0000000081  nU_82  32.914993m  TC=0,0
V_Ui82  nU_82  nR_82  STIMULUS=U_IND_0000000082
R_V163  nR_82  nV_163  23.280268m  TC=0,0
L_V163  nR_82  nV_163  0.014646uH
R_V164  nV_163  nV_164  7.852787m  TC=0,0
L_V164  nV_163  nV_164  0.073723uH
L_L82  nV_164  NTMP0000000082  6.519695uH
K_K15115  L_L82  L_L83  0.1050
K_K15116  L_L82  L_L84  0.0397
K_K15117  L_L82  L_L85  0.0258
K_K15118  L_L82  L_L86  0.0192
K_K15119  L_L82  L_L87  0.0153
K_K15120  L_L82  L_L88  0.0127
K_K15121  L_L82  L_L89  0.0109
K_K15122  L_L82  L_L90  0.0095
K_K15123  L_L82  L_L91  0.0084
K_K15124  L_L82  L_L92  0.0076
K_K15125  L_L82  L_L93  0.0069
K_K15126  L_L82  L_L94  0.0063
K_K15127  L_L82  L_L95  0.0058
K_K15128  L_L82  L_L96  0.0054
K_K15129  L_L82  L_L97  0.0051
K_K15130  L_L82  L_L98  0.0047
K_K15131  L_L82  L_L99  0.0045
K_K15132  L_L82  L_L100  0.0042
K_K15133  L_L82  L_L101  0.0040
K_K15134  L_L82  L_L102  0.0038
K_K15135  L_L82  L_L103  0.0036
K_K15136  L_L82  L_L104  0.0034
K_K15137  L_L82  L_L105  0.0033
K_K15138  L_L82  L_L106  0.0032
K_K15139  L_L82  L_L107  0.0030
K_K15140  L_L82  L_L108  0.0029
K_K15141  L_L82  L_L109  0.0028
K_K15142  L_L82  L_L110  0.0027
K_K15143  L_L82  L_L111  0.0026
K_K15144  L_L82  L_L112  0.0025
K_K15145  L_L82  L_L113  0.0024
K_K15146  L_L82  L_L114  0.0024
K_K15147  L_L82  L_L115  0.0023
K_K15148  L_L82  L_L116  0.0022
K_K15149  L_L82  L_L117  0.0022
K_K15150  L_L82  L_L118  0.0021
K_K15151  L_L82  L_L119  0.0020
K_K15152  L_L82  L_L120  0.0020
K_K15153  L_L82  L_L121  0.0019
K_K15154  L_L82  L_L122  0.0019
K_K15155  L_L82  L_L123  0.0019
K_K15156  L_L82  L_L124  0.0018
K_K15157  L_L82  L_L125  0.0018
K_K15158  L_L82  L_L126  0.0017
K_K15159  L_L82  L_L127  0.0017
K_K15160  L_L82  L_L128  0.0017
K_K15161  L_L82  L_L129  0.0016
K_K15162  L_L82  L_L130  0.0016
K_K15163  L_L82  L_L131  0.0015
K_K15164  L_L82  L_L132  0.0015
K_K15165  L_L82  L_L133  0.0015
K_K15166  L_L82  L_L134  0.0015
K_K15167  L_L82  L_L135  0.0014
K_K15168  L_L82  L_L136  0.0014
K_K15169  L_L82  L_L137  0.0014
K_K15170  L_L82  L_L138  0.0014
K_K15171  L_L82  L_L145  0.0010
K_K15172  L_L82  L_L146  0.0010
K_K15173  L_L82  L_L147  0.0010
K_K15174  L_L82  L_L148  0.0011
K_K15175  L_L82  L_L149  0.0011
K_K15176  L_L82  L_L150  0.0011
K_K15177  L_L82  L_L151  0.0011
K_K15178  L_L82  L_L152  0.0011
K_K15179  L_L82  L_L153  0.0011
K_K15180  L_L82  L_L154  0.0011
K_K15181  L_L82  L_L155  0.0012
K_K15182  L_L82  L_L156  0.0012
K_K15183  L_L82  L_L157  0.0012
K_K15184  L_L82  L_L158  0.0012
K_K15185  L_L82  L_L159  0.0012
K_K15186  L_L82  L_L160  0.0013
K_K15187  L_L82  L_L161  0.0013
K_K15188  L_L82  L_L162  0.0013
K_K15189  L_L82  L_L163  0.0013
K_K15190  L_L82  L_L164  0.0014
K_K15191  L_L82  L_L165  0.0014
K_K15192  L_L82  L_L166  0.0014
K_K15193  L_L82  L_L167  0.0014
K_K15194  L_L82  L_L168  0.0015
K_K15195  L_L82  L_L169  0.0015
K_K15196  L_L82  L_L170  0.0015
K_K15197  L_L82  L_L171  0.0015
K_K15198  L_L82  L_L172  0.0016
K_K15199  L_L82  L_L173  0.0016
K_K15200  L_L82  L_L174  0.0016
K_K15201  L_L82  L_L175  0.0017
K_K15202  L_L82  L_L176  0.0017
K_K15203  L_L82  L_L177  0.0018
K_K15204  L_L82  L_L178  0.0018
K_K15205  L_L82  L_L179  0.0018
K_K15206  L_L82  L_L180  0.0019
K_K15207  L_L82  L_L181  0.0019
K_K15208  L_L82  L_L182  0.0020
K_K15209  L_L82  L_L183  0.0020
K_K15210  L_L82  L_L184  0.0021
K_K15211  L_L82  L_L185  0.0022
K_K15212  L_L82  L_L186  0.0022
K_K15213  L_L82  L_L187  0.0023
K_K15214  L_L82  L_L188  0.0024
K_K15215  L_L82  L_L189  0.0024
K_K15216  L_L82  L_L190  0.0025
K_K15217  L_L82  L_L191  0.0026
K_K15218  L_L82  L_L192  0.0027
K_K15219  L_L82  L_L193  0.0028
K_K15220  L_L82  L_L194  0.0029
K_K15221  L_L82  L_L195  0.0030
K_K15222  L_L82  L_L196  0.0032
K_K15223  L_L82  L_L197  0.0033
K_K15224  L_L82  L_L198  0.0034
K_K15225  L_L82  L_L199  0.0036
K_K15226  L_L82  L_L200  0.0038
K_K15227  L_L82  L_L201  0.0040
K_K15228  L_L82  L_L202  0.0042
K_K15229  L_L82  L_L203  0.0045
K_K15230  L_L82  L_L204  0.0047
K_K15231  L_L82  L_L205  0.0051
K_K15232  L_L82  L_L206  0.0054
K_K15233  L_L82  L_L207  0.0058
K_K15234  L_L82  L_L208  0.0063
K_K15235  L_L82  L_L209  0.0069
K_K15236  L_L82  L_L210  0.0076
K_K15237  L_L82  L_L211  0.0084
K_K15238  L_L82  L_L212  0.0095
K_K15239  L_L82  L_L213  0.0109
K_K15240  L_L82  L_L214  0.0127
K_K15241  L_L82  L_L215  0.0152
K_K15242  L_L82  L_L216  0.0191
K_K15243  L_L82  L_L217  0.0256
K_K15244  L_L82  L_L218  0.0389
K_K15245  L_L82  L_L219  0.0812
K_K15246  L_L82  L_L220  0.1569
K_K15247  L_L82  L_L221  0.0812
K_K15248  L_L82  L_L222  0.0389
K_K15249  L_L82  L_L223  0.0256
K_K15250  L_L82  L_L224  0.0191
K_K15251  L_L82  L_L225  0.0152
K_K15252  L_L82  L_L226  0.0127
K_K15253  L_L82  L_L227  0.0109
K_K15254  L_L82  L_L228  0.0095
K_K15255  L_L82  L_L229  0.0084
K_K15256  L_L82  L_L230  0.0076
K_K15257  L_L82  L_L231  0.0069
K_K15258  L_L82  L_L232  0.0063
K_K15259  L_L82  L_L233  0.0058
K_K15260  L_L82  L_L234  0.0054
K_K15261  L_L82  L_L235  0.0051
K_K15262  L_L82  L_L236  0.0047
K_K15263  L_L82  L_L237  0.0045
K_K15264  L_L82  L_L238  0.0042
K_K15265  L_L82  L_L239  0.0040
K_K15266  L_L82  L_L240  0.0038
K_K15267  L_L82  L_L241  0.0036
K_K15268  L_L82  L_L242  0.0034
K_K15269  L_L82  L_L243  0.0033
K_K15270  L_L82  L_L244  0.0032
K_K15271  L_L82  L_L245  0.0030
K_K15272  L_L82  L_L246  0.0029
K_K15273  L_L82  L_L247  0.0028
K_K15274  L_L82  L_L248  0.0027
K_K15275  L_L82  L_L249  0.0026
K_K15276  L_L82  L_L250  0.0025
K_K15277  L_L82  L_L251  0.0024
K_K15278  L_L82  L_L252  0.0024
K_K15279  L_L82  L_L253  0.0023
K_K15280  L_L82  L_L254  0.0022
K_K15281  L_L82  L_L255  0.0022
K_K15282  L_L82  L_L256  0.0021
K_K15283  L_L82  L_L257  0.0020
K_K15284  L_L82  L_L258  0.0020
K_K15285  L_L82  L_L259  0.0019
K_K15286  L_L82  L_L260  0.0019
K_K15287  L_L82  L_L261  0.0018
K_K15288  L_L82  L_L262  0.0018
K_K15289  L_L82  L_L263  0.0018
K_K15290  L_L82  L_L264  0.0017
K_K15291  L_L82  L_L265  0.0017
K_K15292  L_L82  L_L266  0.0016
K_K15293  L_L82  L_L267  0.0016
K_K15294  L_L82  L_L268  0.0016
K_K15295  L_L82  L_L269  0.0015
K_K15296  L_L82  L_L270  0.0015
K_K15297  L_L82  L_L271  0.0015
K_K15298  L_L82  L_L272  0.0015
K_K15299  L_L82  L_L273  0.0014
K_K15300  L_L82  L_L274  0.0014
K_K15301  L_L82  L_L275  0.0014
K_K15302  L_L82  L_L276  0.0014
* *  Branch  NTMP0000000082 - NTMP0000000083
R_R83  NTMP0000000082  nU_83  32.914993m  TC=0,0
V_Ui83  nU_83  nR_83  STIMULUS=U_IND_0000000083
R_V165  nR_83  nV_165  23.280268m  TC=0,0
L_V165  nR_83  nV_165  0.014646uH
R_V166  nV_165  nV_166  7.852787m  TC=0,0
L_V166  nV_165  nV_166  0.073723uH
L_L83  nV_166  NTMP0000000083  6.519695uH
K_K15303  L_L83  L_L84  0.1050
K_K15304  L_L83  L_L85  0.0397
K_K15305  L_L83  L_L86  0.0258
K_K15306  L_L83  L_L87  0.0192
K_K15307  L_L83  L_L88  0.0153
K_K15308  L_L83  L_L89  0.0127
K_K15309  L_L83  L_L90  0.0109
K_K15310  L_L83  L_L91  0.0095
K_K15311  L_L83  L_L92  0.0084
K_K15312  L_L83  L_L93  0.0076
K_K15313  L_L83  L_L94  0.0069
K_K15314  L_L83  L_L95  0.0063
K_K15315  L_L83  L_L96  0.0058
K_K15316  L_L83  L_L97  0.0054
K_K15317  L_L83  L_L98  0.0051
K_K15318  L_L83  L_L99  0.0047
K_K15319  L_L83  L_L100  0.0045
K_K15320  L_L83  L_L101  0.0042
K_K15321  L_L83  L_L102  0.0040
K_K15322  L_L83  L_L103  0.0038
K_K15323  L_L83  L_L104  0.0036
K_K15324  L_L83  L_L105  0.0034
K_K15325  L_L83  L_L106  0.0033
K_K15326  L_L83  L_L107  0.0032
K_K15327  L_L83  L_L108  0.0030
K_K15328  L_L83  L_L109  0.0029
K_K15329  L_L83  L_L110  0.0028
K_K15330  L_L83  L_L111  0.0027
K_K15331  L_L83  L_L112  0.0026
K_K15332  L_L83  L_L113  0.0025
K_K15333  L_L83  L_L114  0.0024
K_K15334  L_L83  L_L115  0.0024
K_K15335  L_L83  L_L116  0.0023
K_K15336  L_L83  L_L117  0.0022
K_K15337  L_L83  L_L118  0.0022
K_K15338  L_L83  L_L119  0.0021
K_K15339  L_L83  L_L120  0.0020
K_K15340  L_L83  L_L121  0.0020
K_K15341  L_L83  L_L122  0.0019
K_K15342  L_L83  L_L123  0.0019
K_K15343  L_L83  L_L124  0.0019
K_K15344  L_L83  L_L125  0.0018
K_K15345  L_L83  L_L126  0.0018
K_K15346  L_L83  L_L127  0.0017
K_K15347  L_L83  L_L128  0.0017
K_K15348  L_L83  L_L129  0.0017
K_K15349  L_L83  L_L130  0.0016
K_K15350  L_L83  L_L131  0.0016
K_K15351  L_L83  L_L132  0.0015
K_K15352  L_L83  L_L133  0.0015
K_K15353  L_L83  L_L134  0.0015
K_K15354  L_L83  L_L135  0.0015
K_K15355  L_L83  L_L136  0.0014
K_K15356  L_L83  L_L137  0.0014
K_K15357  L_L83  L_L138  0.0014
K_K15358  L_L83  L_L146  0.0010
K_K15359  L_L83  L_L147  0.0010
K_K15360  L_L83  L_L148  0.0010
K_K15361  L_L83  L_L149  0.0011
K_K15362  L_L83  L_L150  0.0011
K_K15363  L_L83  L_L151  0.0011
K_K15364  L_L83  L_L152  0.0011
K_K15365  L_L83  L_L153  0.0011
K_K15366  L_L83  L_L154  0.0011
K_K15367  L_L83  L_L155  0.0011
K_K15368  L_L83  L_L156  0.0012
K_K15369  L_L83  L_L157  0.0012
K_K15370  L_L83  L_L158  0.0012
K_K15371  L_L83  L_L159  0.0012
K_K15372  L_L83  L_L160  0.0012
K_K15373  L_L83  L_L161  0.0013
K_K15374  L_L83  L_L162  0.0013
K_K15375  L_L83  L_L163  0.0013
K_K15376  L_L83  L_L164  0.0013
K_K15377  L_L83  L_L165  0.0014
K_K15378  L_L83  L_L166  0.0014
K_K15379  L_L83  L_L167  0.0014
K_K15380  L_L83  L_L168  0.0014
K_K15381  L_L83  L_L169  0.0015
K_K15382  L_L83  L_L170  0.0015
K_K15383  L_L83  L_L171  0.0015
K_K15384  L_L83  L_L172  0.0015
K_K15385  L_L83  L_L173  0.0016
K_K15386  L_L83  L_L174  0.0016
K_K15387  L_L83  L_L175  0.0016
K_K15388  L_L83  L_L176  0.0017
K_K15389  L_L83  L_L177  0.0017
K_K15390  L_L83  L_L178  0.0018
K_K15391  L_L83  L_L179  0.0018
K_K15392  L_L83  L_L180  0.0018
K_K15393  L_L83  L_L181  0.0019
K_K15394  L_L83  L_L182  0.0019
K_K15395  L_L83  L_L183  0.0020
K_K15396  L_L83  L_L184  0.0020
K_K15397  L_L83  L_L185  0.0021
K_K15398  L_L83  L_L186  0.0022
K_K15399  L_L83  L_L187  0.0022
K_K15400  L_L83  L_L188  0.0023
K_K15401  L_L83  L_L189  0.0024
K_K15402  L_L83  L_L190  0.0024
K_K15403  L_L83  L_L191  0.0025
K_K15404  L_L83  L_L192  0.0026
K_K15405  L_L83  L_L193  0.0027
K_K15406  L_L83  L_L194  0.0028
K_K15407  L_L83  L_L195  0.0029
K_K15408  L_L83  L_L196  0.0030
K_K15409  L_L83  L_L197  0.0032
K_K15410  L_L83  L_L198  0.0033
K_K15411  L_L83  L_L199  0.0034
K_K15412  L_L83  L_L200  0.0036
K_K15413  L_L83  L_L201  0.0038
K_K15414  L_L83  L_L202  0.0040
K_K15415  L_L83  L_L203  0.0042
K_K15416  L_L83  L_L204  0.0045
K_K15417  L_L83  L_L205  0.0047
K_K15418  L_L83  L_L206  0.0051
K_K15419  L_L83  L_L207  0.0054
K_K15420  L_L83  L_L208  0.0058
K_K15421  L_L83  L_L209  0.0063
K_K15422  L_L83  L_L210  0.0069
K_K15423  L_L83  L_L211  0.0076
K_K15424  L_L83  L_L212  0.0084
K_K15425  L_L83  L_L213  0.0095
K_K15426  L_L83  L_L214  0.0109
K_K15427  L_L83  L_L215  0.0127
K_K15428  L_L83  L_L216  0.0152
K_K15429  L_L83  L_L217  0.0191
K_K15430  L_L83  L_L218  0.0256
K_K15431  L_L83  L_L219  0.0389
K_K15432  L_L83  L_L220  0.0812
K_K15433  L_L83  L_L221  0.1569
K_K15434  L_L83  L_L222  0.0812
K_K15435  L_L83  L_L223  0.0389
K_K15436  L_L83  L_L224  0.0256
K_K15437  L_L83  L_L225  0.0191
K_K15438  L_L83  L_L226  0.0152
K_K15439  L_L83  L_L227  0.0127
K_K15440  L_L83  L_L228  0.0109
K_K15441  L_L83  L_L229  0.0095
K_K15442  L_L83  L_L230  0.0084
K_K15443  L_L83  L_L231  0.0076
K_K15444  L_L83  L_L232  0.0069
K_K15445  L_L83  L_L233  0.0063
K_K15446  L_L83  L_L234  0.0058
K_K15447  L_L83  L_L235  0.0054
K_K15448  L_L83  L_L236  0.0051
K_K15449  L_L83  L_L237  0.0047
K_K15450  L_L83  L_L238  0.0045
K_K15451  L_L83  L_L239  0.0042
K_K15452  L_L83  L_L240  0.0040
K_K15453  L_L83  L_L241  0.0038
K_K15454  L_L83  L_L242  0.0036
K_K15455  L_L83  L_L243  0.0034
K_K15456  L_L83  L_L244  0.0033
K_K15457  L_L83  L_L245  0.0032
K_K15458  L_L83  L_L246  0.0030
K_K15459  L_L83  L_L247  0.0029
K_K15460  L_L83  L_L248  0.0028
K_K15461  L_L83  L_L249  0.0027
K_K15462  L_L83  L_L250  0.0026
K_K15463  L_L83  L_L251  0.0025
K_K15464  L_L83  L_L252  0.0024
K_K15465  L_L83  L_L253  0.0024
K_K15466  L_L83  L_L254  0.0023
K_K15467  L_L83  L_L255  0.0022
K_K15468  L_L83  L_L256  0.0022
K_K15469  L_L83  L_L257  0.0021
K_K15470  L_L83  L_L258  0.0020
K_K15471  L_L83  L_L259  0.0020
K_K15472  L_L83  L_L260  0.0019
K_K15473  L_L83  L_L261  0.0019
K_K15474  L_L83  L_L262  0.0018
K_K15475  L_L83  L_L263  0.0018
K_K15476  L_L83  L_L264  0.0018
K_K15477  L_L83  L_L265  0.0017
K_K15478  L_L83  L_L266  0.0017
K_K15479  L_L83  L_L267  0.0016
K_K15480  L_L83  L_L268  0.0016
K_K15481  L_L83  L_L269  0.0016
K_K15482  L_L83  L_L270  0.0015
K_K15483  L_L83  L_L271  0.0015
K_K15484  L_L83  L_L272  0.0015
K_K15485  L_L83  L_L273  0.0015
K_K15486  L_L83  L_L274  0.0014
K_K15487  L_L83  L_L275  0.0014
K_K15488  L_L83  L_L276  0.0014
* *  Branch  NTMP0000000083 - NTMP0000000084
R_R84  NTMP0000000083  nU_84  32.914993m  TC=0,0
V_Ui84  nU_84  nR_84  STIMULUS=U_IND_0000000084
R_V167  nR_84  nV_167  23.280268m  TC=0,0
L_V167  nR_84  nV_167  0.014646uH
R_V168  nV_167  nV_168  7.852787m  TC=0,0
L_V168  nV_167  nV_168  0.073723uH
L_L84  nV_168  NTMP0000000084  6.519695uH
K_K15489  L_L84  L_L85  0.1050
K_K15490  L_L84  L_L86  0.0397
K_K15491  L_L84  L_L87  0.0258
K_K15492  L_L84  L_L88  0.0192
K_K15493  L_L84  L_L89  0.0153
K_K15494  L_L84  L_L90  0.0127
K_K15495  L_L84  L_L91  0.0109
K_K15496  L_L84  L_L92  0.0095
K_K15497  L_L84  L_L93  0.0084
K_K15498  L_L84  L_L94  0.0076
K_K15499  L_L84  L_L95  0.0069
K_K15500  L_L84  L_L96  0.0063
K_K15501  L_L84  L_L97  0.0058
K_K15502  L_L84  L_L98  0.0054
K_K15503  L_L84  L_L99  0.0051
K_K15504  L_L84  L_L100  0.0047
K_K15505  L_L84  L_L101  0.0045
K_K15506  L_L84  L_L102  0.0042
K_K15507  L_L84  L_L103  0.0040
K_K15508  L_L84  L_L104  0.0038
K_K15509  L_L84  L_L105  0.0036
K_K15510  L_L84  L_L106  0.0034
K_K15511  L_L84  L_L107  0.0033
K_K15512  L_L84  L_L108  0.0032
K_K15513  L_L84  L_L109  0.0030
K_K15514  L_L84  L_L110  0.0029
K_K15515  L_L84  L_L111  0.0028
K_K15516  L_L84  L_L112  0.0027
K_K15517  L_L84  L_L113  0.0026
K_K15518  L_L84  L_L114  0.0025
K_K15519  L_L84  L_L115  0.0024
K_K15520  L_L84  L_L116  0.0024
K_K15521  L_L84  L_L117  0.0023
K_K15522  L_L84  L_L118  0.0022
K_K15523  L_L84  L_L119  0.0022
K_K15524  L_L84  L_L120  0.0021
K_K15525  L_L84  L_L121  0.0020
K_K15526  L_L84  L_L122  0.0020
K_K15527  L_L84  L_L123  0.0019
K_K15528  L_L84  L_L124  0.0019
K_K15529  L_L84  L_L125  0.0019
K_K15530  L_L84  L_L126  0.0018
K_K15531  L_L84  L_L127  0.0018
K_K15532  L_L84  L_L128  0.0017
K_K15533  L_L84  L_L129  0.0017
K_K15534  L_L84  L_L130  0.0017
K_K15535  L_L84  L_L131  0.0016
K_K15536  L_L84  L_L132  0.0016
K_K15537  L_L84  L_L133  0.0015
K_K15538  L_L84  L_L134  0.0015
K_K15539  L_L84  L_L135  0.0015
K_K15540  L_L84  L_L136  0.0015
K_K15541  L_L84  L_L137  0.0014
K_K15542  L_L84  L_L138  0.0014
K_K15543  L_L84  L_L147  0.0010
K_K15544  L_L84  L_L148  0.0010
K_K15545  L_L84  L_L149  0.0010
K_K15546  L_L84  L_L150  0.0011
K_K15547  L_L84  L_L151  0.0011
K_K15548  L_L84  L_L152  0.0011
K_K15549  L_L84  L_L153  0.0011
K_K15550  L_L84  L_L154  0.0011
K_K15551  L_L84  L_L155  0.0011
K_K15552  L_L84  L_L156  0.0011
K_K15553  L_L84  L_L157  0.0012
K_K15554  L_L84  L_L158  0.0012
K_K15555  L_L84  L_L159  0.0012
K_K15556  L_L84  L_L160  0.0012
K_K15557  L_L84  L_L161  0.0012
K_K15558  L_L84  L_L162  0.0013
K_K15559  L_L84  L_L163  0.0013
K_K15560  L_L84  L_L164  0.0013
K_K15561  L_L84  L_L165  0.0013
K_K15562  L_L84  L_L166  0.0014
K_K15563  L_L84  L_L167  0.0014
K_K15564  L_L84  L_L168  0.0014
K_K15565  L_L84  L_L169  0.0014
K_K15566  L_L84  L_L170  0.0015
K_K15567  L_L84  L_L171  0.0015
K_K15568  L_L84  L_L172  0.0015
K_K15569  L_L84  L_L173  0.0015
K_K15570  L_L84  L_L174  0.0016
K_K15571  L_L84  L_L175  0.0016
K_K15572  L_L84  L_L176  0.0016
K_K15573  L_L84  L_L177  0.0017
K_K15574  L_L84  L_L178  0.0017
K_K15575  L_L84  L_L179  0.0018
K_K15576  L_L84  L_L180  0.0018
K_K15577  L_L84  L_L181  0.0018
K_K15578  L_L84  L_L182  0.0019
K_K15579  L_L84  L_L183  0.0019
K_K15580  L_L84  L_L184  0.0020
K_K15581  L_L84  L_L185  0.0020
K_K15582  L_L84  L_L186  0.0021
K_K15583  L_L84  L_L187  0.0022
K_K15584  L_L84  L_L188  0.0022
K_K15585  L_L84  L_L189  0.0023
K_K15586  L_L84  L_L190  0.0024
K_K15587  L_L84  L_L191  0.0024
K_K15588  L_L84  L_L192  0.0025
K_K15589  L_L84  L_L193  0.0026
K_K15590  L_L84  L_L194  0.0027
K_K15591  L_L84  L_L195  0.0028
K_K15592  L_L84  L_L196  0.0029
K_K15593  L_L84  L_L197  0.0030
K_K15594  L_L84  L_L198  0.0032
K_K15595  L_L84  L_L199  0.0033
K_K15596  L_L84  L_L200  0.0034
K_K15597  L_L84  L_L201  0.0036
K_K15598  L_L84  L_L202  0.0038
K_K15599  L_L84  L_L203  0.0040
K_K15600  L_L84  L_L204  0.0042
K_K15601  L_L84  L_L205  0.0045
K_K15602  L_L84  L_L206  0.0047
K_K15603  L_L84  L_L207  0.0051
K_K15604  L_L84  L_L208  0.0054
K_K15605  L_L84  L_L209  0.0058
K_K15606  L_L84  L_L210  0.0063
K_K15607  L_L84  L_L211  0.0069
K_K15608  L_L84  L_L212  0.0076
K_K15609  L_L84  L_L213  0.0084
K_K15610  L_L84  L_L214  0.0095
K_K15611  L_L84  L_L215  0.0109
K_K15612  L_L84  L_L216  0.0127
K_K15613  L_L84  L_L217  0.0152
K_K15614  L_L84  L_L218  0.0191
K_K15615  L_L84  L_L219  0.0256
K_K15616  L_L84  L_L220  0.0389
K_K15617  L_L84  L_L221  0.0812
K_K15618  L_L84  L_L222  0.1569
K_K15619  L_L84  L_L223  0.0812
K_K15620  L_L84  L_L224  0.0389
K_K15621  L_L84  L_L225  0.0256
K_K15622  L_L84  L_L226  0.0191
K_K15623  L_L84  L_L227  0.0152
K_K15624  L_L84  L_L228  0.0127
K_K15625  L_L84  L_L229  0.0109
K_K15626  L_L84  L_L230  0.0095
K_K15627  L_L84  L_L231  0.0084
K_K15628  L_L84  L_L232  0.0076
K_K15629  L_L84  L_L233  0.0069
K_K15630  L_L84  L_L234  0.0063
K_K15631  L_L84  L_L235  0.0058
K_K15632  L_L84  L_L236  0.0054
K_K15633  L_L84  L_L237  0.0051
K_K15634  L_L84  L_L238  0.0047
K_K15635  L_L84  L_L239  0.0045
K_K15636  L_L84  L_L240  0.0042
K_K15637  L_L84  L_L241  0.0040
K_K15638  L_L84  L_L242  0.0038
K_K15639  L_L84  L_L243  0.0036
K_K15640  L_L84  L_L244  0.0034
K_K15641  L_L84  L_L245  0.0033
K_K15642  L_L84  L_L246  0.0032
K_K15643  L_L84  L_L247  0.0030
K_K15644  L_L84  L_L248  0.0029
K_K15645  L_L84  L_L249  0.0028
K_K15646  L_L84  L_L250  0.0027
K_K15647  L_L84  L_L251  0.0026
K_K15648  L_L84  L_L252  0.0025
K_K15649  L_L84  L_L253  0.0024
K_K15650  L_L84  L_L254  0.0024
K_K15651  L_L84  L_L255  0.0023
K_K15652  L_L84  L_L256  0.0022
K_K15653  L_L84  L_L257  0.0022
K_K15654  L_L84  L_L258  0.0021
K_K15655  L_L84  L_L259  0.0020
K_K15656  L_L84  L_L260  0.0020
K_K15657  L_L84  L_L261  0.0019
K_K15658  L_L84  L_L262  0.0019
K_K15659  L_L84  L_L263  0.0018
K_K15660  L_L84  L_L264  0.0018
K_K15661  L_L84  L_L265  0.0018
K_K15662  L_L84  L_L266  0.0017
K_K15663  L_L84  L_L267  0.0017
K_K15664  L_L84  L_L268  0.0016
K_K15665  L_L84  L_L269  0.0016
K_K15666  L_L84  L_L270  0.0016
K_K15667  L_L84  L_L271  0.0015
K_K15668  L_L84  L_L272  0.0015
K_K15669  L_L84  L_L273  0.0015
K_K15670  L_L84  L_L274  0.0015
K_K15671  L_L84  L_L275  0.0014
K_K15672  L_L84  L_L276  0.0014
* *  Branch  NTMP0000000084 - NTMP0000000085
R_R85  NTMP0000000084  nU_85  32.914993m  TC=0,0
V_Ui85  nU_85  nR_85  STIMULUS=U_IND_0000000085
R_V169  nR_85  nV_169  23.280268m  TC=0,0
L_V169  nR_85  nV_169  0.014646uH
R_V170  nV_169  nV_170  7.852787m  TC=0,0
L_V170  nV_169  nV_170  0.073723uH
L_L85  nV_170  NTMP0000000085  6.519695uH
K_K15673  L_L85  L_L86  0.1050
K_K15674  L_L85  L_L87  0.0397
K_K15675  L_L85  L_L88  0.0258
K_K15676  L_L85  L_L89  0.0192
K_K15677  L_L85  L_L90  0.0153
K_K15678  L_L85  L_L91  0.0127
K_K15679  L_L85  L_L92  0.0109
K_K15680  L_L85  L_L93  0.0095
K_K15681  L_L85  L_L94  0.0084
K_K15682  L_L85  L_L95  0.0076
K_K15683  L_L85  L_L96  0.0069
K_K15684  L_L85  L_L97  0.0063
K_K15685  L_L85  L_L98  0.0058
K_K15686  L_L85  L_L99  0.0054
K_K15687  L_L85  L_L100  0.0051
K_K15688  L_L85  L_L101  0.0047
K_K15689  L_L85  L_L102  0.0045
K_K15690  L_L85  L_L103  0.0042
K_K15691  L_L85  L_L104  0.0040
K_K15692  L_L85  L_L105  0.0038
K_K15693  L_L85  L_L106  0.0036
K_K15694  L_L85  L_L107  0.0034
K_K15695  L_L85  L_L108  0.0033
K_K15696  L_L85  L_L109  0.0032
K_K15697  L_L85  L_L110  0.0030
K_K15698  L_L85  L_L111  0.0029
K_K15699  L_L85  L_L112  0.0028
K_K15700  L_L85  L_L113  0.0027
K_K15701  L_L85  L_L114  0.0026
K_K15702  L_L85  L_L115  0.0025
K_K15703  L_L85  L_L116  0.0024
K_K15704  L_L85  L_L117  0.0024
K_K15705  L_L85  L_L118  0.0023
K_K15706  L_L85  L_L119  0.0022
K_K15707  L_L85  L_L120  0.0022
K_K15708  L_L85  L_L121  0.0021
K_K15709  L_L85  L_L122  0.0020
K_K15710  L_L85  L_L123  0.0020
K_K15711  L_L85  L_L124  0.0019
K_K15712  L_L85  L_L125  0.0019
K_K15713  L_L85  L_L126  0.0019
K_K15714  L_L85  L_L127  0.0018
K_K15715  L_L85  L_L128  0.0018
K_K15716  L_L85  L_L129  0.0017
K_K15717  L_L85  L_L130  0.0017
K_K15718  L_L85  L_L131  0.0017
K_K15719  L_L85  L_L132  0.0016
K_K15720  L_L85  L_L133  0.0016
K_K15721  L_L85  L_L134  0.0015
K_K15722  L_L85  L_L135  0.0015
K_K15723  L_L85  L_L136  0.0015
K_K15724  L_L85  L_L137  0.0015
K_K15725  L_L85  L_L138  0.0014
K_K15726  L_L85  L_L148  0.0010
K_K15727  L_L85  L_L149  0.0010
K_K15728  L_L85  L_L150  0.0010
K_K15729  L_L85  L_L151  0.0011
K_K15730  L_L85  L_L152  0.0011
K_K15731  L_L85  L_L153  0.0011
K_K15732  L_L85  L_L154  0.0011
K_K15733  L_L85  L_L155  0.0011
K_K15734  L_L85  L_L156  0.0011
K_K15735  L_L85  L_L157  0.0011
K_K15736  L_L85  L_L158  0.0012
K_K15737  L_L85  L_L159  0.0012
K_K15738  L_L85  L_L160  0.0012
K_K15739  L_L85  L_L161  0.0012
K_K15740  L_L85  L_L162  0.0012
K_K15741  L_L85  L_L163  0.0013
K_K15742  L_L85  L_L164  0.0013
K_K15743  L_L85  L_L165  0.0013
K_K15744  L_L85  L_L166  0.0013
K_K15745  L_L85  L_L167  0.0014
K_K15746  L_L85  L_L168  0.0014
K_K15747  L_L85  L_L169  0.0014
K_K15748  L_L85  L_L170  0.0014
K_K15749  L_L85  L_L171  0.0015
K_K15750  L_L85  L_L172  0.0015
K_K15751  L_L85  L_L173  0.0015
K_K15752  L_L85  L_L174  0.0015
K_K15753  L_L85  L_L175  0.0016
K_K15754  L_L85  L_L176  0.0016
K_K15755  L_L85  L_L177  0.0016
K_K15756  L_L85  L_L178  0.0017
K_K15757  L_L85  L_L179  0.0017
K_K15758  L_L85  L_L180  0.0018
K_K15759  L_L85  L_L181  0.0018
K_K15760  L_L85  L_L182  0.0018
K_K15761  L_L85  L_L183  0.0019
K_K15762  L_L85  L_L184  0.0019
K_K15763  L_L85  L_L185  0.0020
K_K15764  L_L85  L_L186  0.0020
K_K15765  L_L85  L_L187  0.0021
K_K15766  L_L85  L_L188  0.0022
K_K15767  L_L85  L_L189  0.0022
K_K15768  L_L85  L_L190  0.0023
K_K15769  L_L85  L_L191  0.0024
K_K15770  L_L85  L_L192  0.0024
K_K15771  L_L85  L_L193  0.0025
K_K15772  L_L85  L_L194  0.0026
K_K15773  L_L85  L_L195  0.0027
K_K15774  L_L85  L_L196  0.0028
K_K15775  L_L85  L_L197  0.0029
K_K15776  L_L85  L_L198  0.0030
K_K15777  L_L85  L_L199  0.0032
K_K15778  L_L85  L_L200  0.0033
K_K15779  L_L85  L_L201  0.0034
K_K15780  L_L85  L_L202  0.0036
K_K15781  L_L85  L_L203  0.0038
K_K15782  L_L85  L_L204  0.0040
K_K15783  L_L85  L_L205  0.0042
K_K15784  L_L85  L_L206  0.0045
K_K15785  L_L85  L_L207  0.0047
K_K15786  L_L85  L_L208  0.0051
K_K15787  L_L85  L_L209  0.0054
K_K15788  L_L85  L_L210  0.0058
K_K15789  L_L85  L_L211  0.0063
K_K15790  L_L85  L_L212  0.0069
K_K15791  L_L85  L_L213  0.0076
K_K15792  L_L85  L_L214  0.0084
K_K15793  L_L85  L_L215  0.0095
K_K15794  L_L85  L_L216  0.0109
K_K15795  L_L85  L_L217  0.0127
K_K15796  L_L85  L_L218  0.0152
K_K15797  L_L85  L_L219  0.0191
K_K15798  L_L85  L_L220  0.0256
K_K15799  L_L85  L_L221  0.0389
K_K15800  L_L85  L_L222  0.0812
K_K15801  L_L85  L_L223  0.1569
K_K15802  L_L85  L_L224  0.0812
K_K15803  L_L85  L_L225  0.0389
K_K15804  L_L85  L_L226  0.0256
K_K15805  L_L85  L_L227  0.0191
K_K15806  L_L85  L_L228  0.0152
K_K15807  L_L85  L_L229  0.0127
K_K15808  L_L85  L_L230  0.0109
K_K15809  L_L85  L_L231  0.0095
K_K15810  L_L85  L_L232  0.0084
K_K15811  L_L85  L_L233  0.0076
K_K15812  L_L85  L_L234  0.0069
K_K15813  L_L85  L_L235  0.0063
K_K15814  L_L85  L_L236  0.0058
K_K15815  L_L85  L_L237  0.0054
K_K15816  L_L85  L_L238  0.0051
K_K15817  L_L85  L_L239  0.0047
K_K15818  L_L85  L_L240  0.0045
K_K15819  L_L85  L_L241  0.0042
K_K15820  L_L85  L_L242  0.0040
K_K15821  L_L85  L_L243  0.0038
K_K15822  L_L85  L_L244  0.0036
K_K15823  L_L85  L_L245  0.0034
K_K15824  L_L85  L_L246  0.0033
K_K15825  L_L85  L_L247  0.0032
K_K15826  L_L85  L_L248  0.0030
K_K15827  L_L85  L_L249  0.0029
K_K15828  L_L85  L_L250  0.0028
K_K15829  L_L85  L_L251  0.0027
K_K15830  L_L85  L_L252  0.0026
K_K15831  L_L85  L_L253  0.0025
K_K15832  L_L85  L_L254  0.0024
K_K15833  L_L85  L_L255  0.0024
K_K15834  L_L85  L_L256  0.0023
K_K15835  L_L85  L_L257  0.0022
K_K15836  L_L85  L_L258  0.0022
K_K15837  L_L85  L_L259  0.0021
K_K15838  L_L85  L_L260  0.0020
K_K15839  L_L85  L_L261  0.0020
K_K15840  L_L85  L_L262  0.0019
K_K15841  L_L85  L_L263  0.0019
K_K15842  L_L85  L_L264  0.0018
K_K15843  L_L85  L_L265  0.0018
K_K15844  L_L85  L_L266  0.0018
K_K15845  L_L85  L_L267  0.0017
K_K15846  L_L85  L_L268  0.0017
K_K15847  L_L85  L_L269  0.0016
K_K15848  L_L85  L_L270  0.0016
K_K15849  L_L85  L_L271  0.0016
K_K15850  L_L85  L_L272  0.0015
K_K15851  L_L85  L_L273  0.0015
K_K15852  L_L85  L_L274  0.0015
K_K15853  L_L85  L_L275  0.0015
K_K15854  L_L85  L_L276  0.0014
* *  Branch  NTMP0000000085 - NTMP0000000086
R_R86  NTMP0000000085  nU_86  32.914993m  TC=0,0
V_Ui86  nU_86  nR_86  STIMULUS=U_IND_0000000086
R_V171  nR_86  nV_171  23.280268m  TC=0,0
L_V171  nR_86  nV_171  0.014646uH
R_V172  nV_171  nV_172  7.852787m  TC=0,0
L_V172  nV_171  nV_172  0.073723uH
L_L86  nV_172  NTMP0000000086  6.519695uH
K_K15855  L_L86  L_L87  0.1050
K_K15856  L_L86  L_L88  0.0397
K_K15857  L_L86  L_L89  0.0258
K_K15858  L_L86  L_L90  0.0192
K_K15859  L_L86  L_L91  0.0153
K_K15860  L_L86  L_L92  0.0127
K_K15861  L_L86  L_L93  0.0109
K_K15862  L_L86  L_L94  0.0095
K_K15863  L_L86  L_L95  0.0084
K_K15864  L_L86  L_L96  0.0076
K_K15865  L_L86  L_L97  0.0069
K_K15866  L_L86  L_L98  0.0063
K_K15867  L_L86  L_L99  0.0058
K_K15868  L_L86  L_L100  0.0054
K_K15869  L_L86  L_L101  0.0051
K_K15870  L_L86  L_L102  0.0047
K_K15871  L_L86  L_L103  0.0045
K_K15872  L_L86  L_L104  0.0042
K_K15873  L_L86  L_L105  0.0040
K_K15874  L_L86  L_L106  0.0038
K_K15875  L_L86  L_L107  0.0036
K_K15876  L_L86  L_L108  0.0034
K_K15877  L_L86  L_L109  0.0033
K_K15878  L_L86  L_L110  0.0032
K_K15879  L_L86  L_L111  0.0030
K_K15880  L_L86  L_L112  0.0029
K_K15881  L_L86  L_L113  0.0028
K_K15882  L_L86  L_L114  0.0027
K_K15883  L_L86  L_L115  0.0026
K_K15884  L_L86  L_L116  0.0025
K_K15885  L_L86  L_L117  0.0024
K_K15886  L_L86  L_L118  0.0024
K_K15887  L_L86  L_L119  0.0023
K_K15888  L_L86  L_L120  0.0022
K_K15889  L_L86  L_L121  0.0022
K_K15890  L_L86  L_L122  0.0021
K_K15891  L_L86  L_L123  0.0020
K_K15892  L_L86  L_L124  0.0020
K_K15893  L_L86  L_L125  0.0019
K_K15894  L_L86  L_L126  0.0019
K_K15895  L_L86  L_L127  0.0019
K_K15896  L_L86  L_L128  0.0018
K_K15897  L_L86  L_L129  0.0018
K_K15898  L_L86  L_L130  0.0017
K_K15899  L_L86  L_L131  0.0017
K_K15900  L_L86  L_L132  0.0017
K_K15901  L_L86  L_L133  0.0016
K_K15902  L_L86  L_L134  0.0016
K_K15903  L_L86  L_L135  0.0015
K_K15904  L_L86  L_L136  0.0015
K_K15905  L_L86  L_L137  0.0015
K_K15906  L_L86  L_L138  0.0015
K_K15907  L_L86  L_L149  0.0010
K_K15908  L_L86  L_L150  0.0010
K_K15909  L_L86  L_L151  0.0010
K_K15910  L_L86  L_L152  0.0011
K_K15911  L_L86  L_L153  0.0011
K_K15912  L_L86  L_L154  0.0011
K_K15913  L_L86  L_L155  0.0011
K_K15914  L_L86  L_L156  0.0011
K_K15915  L_L86  L_L157  0.0011
K_K15916  L_L86  L_L158  0.0011
K_K15917  L_L86  L_L159  0.0012
K_K15918  L_L86  L_L160  0.0012
K_K15919  L_L86  L_L161  0.0012
K_K15920  L_L86  L_L162  0.0012
K_K15921  L_L86  L_L163  0.0012
K_K15922  L_L86  L_L164  0.0013
K_K15923  L_L86  L_L165  0.0013
K_K15924  L_L86  L_L166  0.0013
K_K15925  L_L86  L_L167  0.0013
K_K15926  L_L86  L_L168  0.0014
K_K15927  L_L86  L_L169  0.0014
K_K15928  L_L86  L_L170  0.0014
K_K15929  L_L86  L_L171  0.0014
K_K15930  L_L86  L_L172  0.0015
K_K15931  L_L86  L_L173  0.0015
K_K15932  L_L86  L_L174  0.0015
K_K15933  L_L86  L_L175  0.0015
K_K15934  L_L86  L_L176  0.0016
K_K15935  L_L86  L_L177  0.0016
K_K15936  L_L86  L_L178  0.0016
K_K15937  L_L86  L_L179  0.0017
K_K15938  L_L86  L_L180  0.0017
K_K15939  L_L86  L_L181  0.0018
K_K15940  L_L86  L_L182  0.0018
K_K15941  L_L86  L_L183  0.0018
K_K15942  L_L86  L_L184  0.0019
K_K15943  L_L86  L_L185  0.0019
K_K15944  L_L86  L_L186  0.0020
K_K15945  L_L86  L_L187  0.0020
K_K15946  L_L86  L_L188  0.0021
K_K15947  L_L86  L_L189  0.0022
K_K15948  L_L86  L_L190  0.0022
K_K15949  L_L86  L_L191  0.0023
K_K15950  L_L86  L_L192  0.0024
K_K15951  L_L86  L_L193  0.0024
K_K15952  L_L86  L_L194  0.0025
K_K15953  L_L86  L_L195  0.0026
K_K15954  L_L86  L_L196  0.0027
K_K15955  L_L86  L_L197  0.0028
K_K15956  L_L86  L_L198  0.0029
K_K15957  L_L86  L_L199  0.0030
K_K15958  L_L86  L_L200  0.0032
K_K15959  L_L86  L_L201  0.0033
K_K15960  L_L86  L_L202  0.0034
K_K15961  L_L86  L_L203  0.0036
K_K15962  L_L86  L_L204  0.0038
K_K15963  L_L86  L_L205  0.0040
K_K15964  L_L86  L_L206  0.0042
K_K15965  L_L86  L_L207  0.0045
K_K15966  L_L86  L_L208  0.0047
K_K15967  L_L86  L_L209  0.0051
K_K15968  L_L86  L_L210  0.0054
K_K15969  L_L86  L_L211  0.0058
K_K15970  L_L86  L_L212  0.0063
K_K15971  L_L86  L_L213  0.0069
K_K15972  L_L86  L_L214  0.0076
K_K15973  L_L86  L_L215  0.0084
K_K15974  L_L86  L_L216  0.0095
K_K15975  L_L86  L_L217  0.0109
K_K15976  L_L86  L_L218  0.0127
K_K15977  L_L86  L_L219  0.0152
K_K15978  L_L86  L_L220  0.0191
K_K15979  L_L86  L_L221  0.0256
K_K15980  L_L86  L_L222  0.0389
K_K15981  L_L86  L_L223  0.0812
K_K15982  L_L86  L_L224  0.1569
K_K15983  L_L86  L_L225  0.0812
K_K15984  L_L86  L_L226  0.0389
K_K15985  L_L86  L_L227  0.0256
K_K15986  L_L86  L_L228  0.0191
K_K15987  L_L86  L_L229  0.0152
K_K15988  L_L86  L_L230  0.0127
K_K15989  L_L86  L_L231  0.0109
K_K15990  L_L86  L_L232  0.0095
K_K15991  L_L86  L_L233  0.0084
K_K15992  L_L86  L_L234  0.0076
K_K15993  L_L86  L_L235  0.0069
K_K15994  L_L86  L_L236  0.0063
K_K15995  L_L86  L_L237  0.0058
K_K15996  L_L86  L_L238  0.0054
K_K15997  L_L86  L_L239  0.0051
K_K15998  L_L86  L_L240  0.0047
K_K15999  L_L86  L_L241  0.0045
K_K16000  L_L86  L_L242  0.0042
K_K16001  L_L86  L_L243  0.0040
K_K16002  L_L86  L_L244  0.0038
K_K16003  L_L86  L_L245  0.0036
K_K16004  L_L86  L_L246  0.0034
K_K16005  L_L86  L_L247  0.0033
K_K16006  L_L86  L_L248  0.0032
K_K16007  L_L86  L_L249  0.0030
K_K16008  L_L86  L_L250  0.0029
K_K16009  L_L86  L_L251  0.0028
K_K16010  L_L86  L_L252  0.0027
K_K16011  L_L86  L_L253  0.0026
K_K16012  L_L86  L_L254  0.0025
K_K16013  L_L86  L_L255  0.0024
K_K16014  L_L86  L_L256  0.0024
K_K16015  L_L86  L_L257  0.0023
K_K16016  L_L86  L_L258  0.0022
K_K16017  L_L86  L_L259  0.0022
K_K16018  L_L86  L_L260  0.0021
K_K16019  L_L86  L_L261  0.0020
K_K16020  L_L86  L_L262  0.0020
K_K16021  L_L86  L_L263  0.0019
K_K16022  L_L86  L_L264  0.0019
K_K16023  L_L86  L_L265  0.0018
K_K16024  L_L86  L_L266  0.0018
K_K16025  L_L86  L_L267  0.0018
K_K16026  L_L86  L_L268  0.0017
K_K16027  L_L86  L_L269  0.0017
K_K16028  L_L86  L_L270  0.0016
K_K16029  L_L86  L_L271  0.0016
K_K16030  L_L86  L_L272  0.0016
K_K16031  L_L86  L_L273  0.0015
K_K16032  L_L86  L_L274  0.0015
K_K16033  L_L86  L_L275  0.0015
K_K16034  L_L86  L_L276  0.0015
* *  Branch  NTMP0000000086 - NTMP0000000087
R_R87  NTMP0000000086  nU_87  32.914993m  TC=0,0
V_Ui87  nU_87  nR_87  STIMULUS=U_IND_0000000087
R_V173  nR_87  nV_173  23.280268m  TC=0,0
L_V173  nR_87  nV_173  0.014646uH
R_V174  nV_173  nV_174  7.852787m  TC=0,0
L_V174  nV_173  nV_174  0.073723uH
L_L87  nV_174  NTMP0000000087  6.519695uH
K_K16035  L_L87  L_L88  0.1050
K_K16036  L_L87  L_L89  0.0397
K_K16037  L_L87  L_L90  0.0258
K_K16038  L_L87  L_L91  0.0192
K_K16039  L_L87  L_L92  0.0153
K_K16040  L_L87  L_L93  0.0127
K_K16041  L_L87  L_L94  0.0109
K_K16042  L_L87  L_L95  0.0095
K_K16043  L_L87  L_L96  0.0084
K_K16044  L_L87  L_L97  0.0076
K_K16045  L_L87  L_L98  0.0069
K_K16046  L_L87  L_L99  0.0063
K_K16047  L_L87  L_L100  0.0058
K_K16048  L_L87  L_L101  0.0054
K_K16049  L_L87  L_L102  0.0051
K_K16050  L_L87  L_L103  0.0047
K_K16051  L_L87  L_L104  0.0045
K_K16052  L_L87  L_L105  0.0042
K_K16053  L_L87  L_L106  0.0040
K_K16054  L_L87  L_L107  0.0038
K_K16055  L_L87  L_L108  0.0036
K_K16056  L_L87  L_L109  0.0034
K_K16057  L_L87  L_L110  0.0033
K_K16058  L_L87  L_L111  0.0032
K_K16059  L_L87  L_L112  0.0030
K_K16060  L_L87  L_L113  0.0029
K_K16061  L_L87  L_L114  0.0028
K_K16062  L_L87  L_L115  0.0027
K_K16063  L_L87  L_L116  0.0026
K_K16064  L_L87  L_L117  0.0025
K_K16065  L_L87  L_L118  0.0024
K_K16066  L_L87  L_L119  0.0024
K_K16067  L_L87  L_L120  0.0023
K_K16068  L_L87  L_L121  0.0022
K_K16069  L_L87  L_L122  0.0022
K_K16070  L_L87  L_L123  0.0021
K_K16071  L_L87  L_L124  0.0020
K_K16072  L_L87  L_L125  0.0020
K_K16073  L_L87  L_L126  0.0019
K_K16074  L_L87  L_L127  0.0019
K_K16075  L_L87  L_L128  0.0019
K_K16076  L_L87  L_L129  0.0018
K_K16077  L_L87  L_L130  0.0018
K_K16078  L_L87  L_L131  0.0017
K_K16079  L_L87  L_L132  0.0017
K_K16080  L_L87  L_L133  0.0017
K_K16081  L_L87  L_L134  0.0016
K_K16082  L_L87  L_L135  0.0016
K_K16083  L_L87  L_L136  0.0015
K_K16084  L_L87  L_L137  0.0015
K_K16085  L_L87  L_L138  0.0015
K_K16086  L_L87  L_L150  0.0010
K_K16087  L_L87  L_L151  0.0010
K_K16088  L_L87  L_L152  0.0010
K_K16089  L_L87  L_L153  0.0011
K_K16090  L_L87  L_L154  0.0011
K_K16091  L_L87  L_L155  0.0011
K_K16092  L_L87  L_L156  0.0011
K_K16093  L_L87  L_L157  0.0011
K_K16094  L_L87  L_L158  0.0011
K_K16095  L_L87  L_L159  0.0011
K_K16096  L_L87  L_L160  0.0012
K_K16097  L_L87  L_L161  0.0012
K_K16098  L_L87  L_L162  0.0012
K_K16099  L_L87  L_L163  0.0012
K_K16100  L_L87  L_L164  0.0012
K_K16101  L_L87  L_L165  0.0013
K_K16102  L_L87  L_L166  0.0013
K_K16103  L_L87  L_L167  0.0013
K_K16104  L_L87  L_L168  0.0013
K_K16105  L_L87  L_L169  0.0014
K_K16106  L_L87  L_L170  0.0014
K_K16107  L_L87  L_L171  0.0014
K_K16108  L_L87  L_L172  0.0014
K_K16109  L_L87  L_L173  0.0015
K_K16110  L_L87  L_L174  0.0015
K_K16111  L_L87  L_L175  0.0015
K_K16112  L_L87  L_L176  0.0015
K_K16113  L_L87  L_L177  0.0016
K_K16114  L_L87  L_L178  0.0016
K_K16115  L_L87  L_L179  0.0016
K_K16116  L_L87  L_L180  0.0017
K_K16117  L_L87  L_L181  0.0017
K_K16118  L_L87  L_L182  0.0018
K_K16119  L_L87  L_L183  0.0018
K_K16120  L_L87  L_L184  0.0018
K_K16121  L_L87  L_L185  0.0019
K_K16122  L_L87  L_L186  0.0019
K_K16123  L_L87  L_L187  0.0020
K_K16124  L_L87  L_L188  0.0020
K_K16125  L_L87  L_L189  0.0021
K_K16126  L_L87  L_L190  0.0022
K_K16127  L_L87  L_L191  0.0022
K_K16128  L_L87  L_L192  0.0023
K_K16129  L_L87  L_L193  0.0024
K_K16130  L_L87  L_L194  0.0024
K_K16131  L_L87  L_L195  0.0025
K_K16132  L_L87  L_L196  0.0026
K_K16133  L_L87  L_L197  0.0027
K_K16134  L_L87  L_L198  0.0028
K_K16135  L_L87  L_L199  0.0029
K_K16136  L_L87  L_L200  0.0030
K_K16137  L_L87  L_L201  0.0032
K_K16138  L_L87  L_L202  0.0033
K_K16139  L_L87  L_L203  0.0034
K_K16140  L_L87  L_L204  0.0036
K_K16141  L_L87  L_L205  0.0038
K_K16142  L_L87  L_L206  0.0040
K_K16143  L_L87  L_L207  0.0042
K_K16144  L_L87  L_L208  0.0045
K_K16145  L_L87  L_L209  0.0047
K_K16146  L_L87  L_L210  0.0051
K_K16147  L_L87  L_L211  0.0054
K_K16148  L_L87  L_L212  0.0058
K_K16149  L_L87  L_L213  0.0063
K_K16150  L_L87  L_L214  0.0069
K_K16151  L_L87  L_L215  0.0076
K_K16152  L_L87  L_L216  0.0084
K_K16153  L_L87  L_L217  0.0095
K_K16154  L_L87  L_L218  0.0109
K_K16155  L_L87  L_L219  0.0127
K_K16156  L_L87  L_L220  0.0152
K_K16157  L_L87  L_L221  0.0191
K_K16158  L_L87  L_L222  0.0256
K_K16159  L_L87  L_L223  0.0389
K_K16160  L_L87  L_L224  0.0812
K_K16161  L_L87  L_L225  0.1569
K_K16162  L_L87  L_L226  0.0812
K_K16163  L_L87  L_L227  0.0389
K_K16164  L_L87  L_L228  0.0256
K_K16165  L_L87  L_L229  0.0191
K_K16166  L_L87  L_L230  0.0152
K_K16167  L_L87  L_L231  0.0127
K_K16168  L_L87  L_L232  0.0109
K_K16169  L_L87  L_L233  0.0095
K_K16170  L_L87  L_L234  0.0084
K_K16171  L_L87  L_L235  0.0076
K_K16172  L_L87  L_L236  0.0069
K_K16173  L_L87  L_L237  0.0063
K_K16174  L_L87  L_L238  0.0058
K_K16175  L_L87  L_L239  0.0054
K_K16176  L_L87  L_L240  0.0051
K_K16177  L_L87  L_L241  0.0047
K_K16178  L_L87  L_L242  0.0045
K_K16179  L_L87  L_L243  0.0042
K_K16180  L_L87  L_L244  0.0040
K_K16181  L_L87  L_L245  0.0038
K_K16182  L_L87  L_L246  0.0036
K_K16183  L_L87  L_L247  0.0034
K_K16184  L_L87  L_L248  0.0033
K_K16185  L_L87  L_L249  0.0032
K_K16186  L_L87  L_L250  0.0030
K_K16187  L_L87  L_L251  0.0029
K_K16188  L_L87  L_L252  0.0028
K_K16189  L_L87  L_L253  0.0027
K_K16190  L_L87  L_L254  0.0026
K_K16191  L_L87  L_L255  0.0025
K_K16192  L_L87  L_L256  0.0024
K_K16193  L_L87  L_L257  0.0024
K_K16194  L_L87  L_L258  0.0023
K_K16195  L_L87  L_L259  0.0022
K_K16196  L_L87  L_L260  0.0022
K_K16197  L_L87  L_L261  0.0021
K_K16198  L_L87  L_L262  0.0020
K_K16199  L_L87  L_L263  0.0020
K_K16200  L_L87  L_L264  0.0019
K_K16201  L_L87  L_L265  0.0019
K_K16202  L_L87  L_L266  0.0018
K_K16203  L_L87  L_L267  0.0018
K_K16204  L_L87  L_L268  0.0018
K_K16205  L_L87  L_L269  0.0017
K_K16206  L_L87  L_L270  0.0017
K_K16207  L_L87  L_L271  0.0016
K_K16208  L_L87  L_L272  0.0016
K_K16209  L_L87  L_L273  0.0016
K_K16210  L_L87  L_L274  0.0015
K_K16211  L_L87  L_L275  0.0015
K_K16212  L_L87  L_L276  0.0015
* *  Branch  NTMP0000000087 - NTMP0000000088
R_R88  NTMP0000000087  nU_88  32.914993m  TC=0,0
V_Ui88  nU_88  nR_88  STIMULUS=U_IND_0000000088
R_V175  nR_88  nV_175  23.280268m  TC=0,0
L_V175  nR_88  nV_175  0.014646uH
R_V176  nV_175  nV_176  7.852787m  TC=0,0
L_V176  nV_175  nV_176  0.073723uH
L_L88  nV_176  NTMP0000000088  6.519695uH
K_K16213  L_L88  L_L89  0.1050
K_K16214  L_L88  L_L90  0.0397
K_K16215  L_L88  L_L91  0.0258
K_K16216  L_L88  L_L92  0.0192
K_K16217  L_L88  L_L93  0.0153
K_K16218  L_L88  L_L94  0.0127
K_K16219  L_L88  L_L95  0.0109
K_K16220  L_L88  L_L96  0.0095
K_K16221  L_L88  L_L97  0.0084
K_K16222  L_L88  L_L98  0.0076
K_K16223  L_L88  L_L99  0.0069
K_K16224  L_L88  L_L100  0.0063
K_K16225  L_L88  L_L101  0.0058
K_K16226  L_L88  L_L102  0.0054
K_K16227  L_L88  L_L103  0.0051
K_K16228  L_L88  L_L104  0.0047
K_K16229  L_L88  L_L105  0.0045
K_K16230  L_L88  L_L106  0.0042
K_K16231  L_L88  L_L107  0.0040
K_K16232  L_L88  L_L108  0.0038
K_K16233  L_L88  L_L109  0.0036
K_K16234  L_L88  L_L110  0.0034
K_K16235  L_L88  L_L111  0.0033
K_K16236  L_L88  L_L112  0.0032
K_K16237  L_L88  L_L113  0.0030
K_K16238  L_L88  L_L114  0.0029
K_K16239  L_L88  L_L115  0.0028
K_K16240  L_L88  L_L116  0.0027
K_K16241  L_L88  L_L117  0.0026
K_K16242  L_L88  L_L118  0.0025
K_K16243  L_L88  L_L119  0.0024
K_K16244  L_L88  L_L120  0.0024
K_K16245  L_L88  L_L121  0.0023
K_K16246  L_L88  L_L122  0.0022
K_K16247  L_L88  L_L123  0.0022
K_K16248  L_L88  L_L124  0.0021
K_K16249  L_L88  L_L125  0.0020
K_K16250  L_L88  L_L126  0.0020
K_K16251  L_L88  L_L127  0.0019
K_K16252  L_L88  L_L128  0.0019
K_K16253  L_L88  L_L129  0.0019
K_K16254  L_L88  L_L130  0.0018
K_K16255  L_L88  L_L131  0.0018
K_K16256  L_L88  L_L132  0.0017
K_K16257  L_L88  L_L133  0.0017
K_K16258  L_L88  L_L134  0.0017
K_K16259  L_L88  L_L135  0.0016
K_K16260  L_L88  L_L136  0.0016
K_K16261  L_L88  L_L137  0.0015
K_K16262  L_L88  L_L138  0.0015
K_K16263  L_L88  L_L151  0.0010
K_K16264  L_L88  L_L152  0.0010
K_K16265  L_L88  L_L153  0.0010
K_K16266  L_L88  L_L154  0.0011
K_K16267  L_L88  L_L155  0.0011
K_K16268  L_L88  L_L156  0.0011
K_K16269  L_L88  L_L157  0.0011
K_K16270  L_L88  L_L158  0.0011
K_K16271  L_L88  L_L159  0.0011
K_K16272  L_L88  L_L160  0.0011
K_K16273  L_L88  L_L161  0.0012
K_K16274  L_L88  L_L162  0.0012
K_K16275  L_L88  L_L163  0.0012
K_K16276  L_L88  L_L164  0.0012
K_K16277  L_L88  L_L165  0.0012
K_K16278  L_L88  L_L166  0.0013
K_K16279  L_L88  L_L167  0.0013
K_K16280  L_L88  L_L168  0.0013
K_K16281  L_L88  L_L169  0.0013
K_K16282  L_L88  L_L170  0.0014
K_K16283  L_L88  L_L171  0.0014
K_K16284  L_L88  L_L172  0.0014
K_K16285  L_L88  L_L173  0.0014
K_K16286  L_L88  L_L174  0.0015
K_K16287  L_L88  L_L175  0.0015
K_K16288  L_L88  L_L176  0.0015
K_K16289  L_L88  L_L177  0.0015
K_K16290  L_L88  L_L178  0.0016
K_K16291  L_L88  L_L179  0.0016
K_K16292  L_L88  L_L180  0.0016
K_K16293  L_L88  L_L181  0.0017
K_K16294  L_L88  L_L182  0.0017
K_K16295  L_L88  L_L183  0.0018
K_K16296  L_L88  L_L184  0.0018
K_K16297  L_L88  L_L185  0.0018
K_K16298  L_L88  L_L186  0.0019
K_K16299  L_L88  L_L187  0.0019
K_K16300  L_L88  L_L188  0.0020
K_K16301  L_L88  L_L189  0.0020
K_K16302  L_L88  L_L190  0.0021
K_K16303  L_L88  L_L191  0.0022
K_K16304  L_L88  L_L192  0.0022
K_K16305  L_L88  L_L193  0.0023
K_K16306  L_L88  L_L194  0.0024
K_K16307  L_L88  L_L195  0.0024
K_K16308  L_L88  L_L196  0.0025
K_K16309  L_L88  L_L197  0.0026
K_K16310  L_L88  L_L198  0.0027
K_K16311  L_L88  L_L199  0.0028
K_K16312  L_L88  L_L200  0.0029
K_K16313  L_L88  L_L201  0.0030
K_K16314  L_L88  L_L202  0.0032
K_K16315  L_L88  L_L203  0.0033
K_K16316  L_L88  L_L204  0.0034
K_K16317  L_L88  L_L205  0.0036
K_K16318  L_L88  L_L206  0.0038
K_K16319  L_L88  L_L207  0.0040
K_K16320  L_L88  L_L208  0.0042
K_K16321  L_L88  L_L209  0.0045
K_K16322  L_L88  L_L210  0.0047
K_K16323  L_L88  L_L211  0.0051
K_K16324  L_L88  L_L212  0.0054
K_K16325  L_L88  L_L213  0.0058
K_K16326  L_L88  L_L214  0.0063
K_K16327  L_L88  L_L215  0.0069
K_K16328  L_L88  L_L216  0.0076
K_K16329  L_L88  L_L217  0.0084
K_K16330  L_L88  L_L218  0.0095
K_K16331  L_L88  L_L219  0.0109
K_K16332  L_L88  L_L220  0.0127
K_K16333  L_L88  L_L221  0.0152
K_K16334  L_L88  L_L222  0.0191
K_K16335  L_L88  L_L223  0.0256
K_K16336  L_L88  L_L224  0.0389
K_K16337  L_L88  L_L225  0.0812
K_K16338  L_L88  L_L226  0.1569
K_K16339  L_L88  L_L227  0.0812
K_K16340  L_L88  L_L228  0.0389
K_K16341  L_L88  L_L229  0.0256
K_K16342  L_L88  L_L230  0.0191
K_K16343  L_L88  L_L231  0.0152
K_K16344  L_L88  L_L232  0.0127
K_K16345  L_L88  L_L233  0.0109
K_K16346  L_L88  L_L234  0.0095
K_K16347  L_L88  L_L235  0.0084
K_K16348  L_L88  L_L236  0.0076
K_K16349  L_L88  L_L237  0.0069
K_K16350  L_L88  L_L238  0.0063
K_K16351  L_L88  L_L239  0.0058
K_K16352  L_L88  L_L240  0.0054
K_K16353  L_L88  L_L241  0.0051
K_K16354  L_L88  L_L242  0.0047
K_K16355  L_L88  L_L243  0.0045
K_K16356  L_L88  L_L244  0.0042
K_K16357  L_L88  L_L245  0.0040
K_K16358  L_L88  L_L246  0.0038
K_K16359  L_L88  L_L247  0.0036
K_K16360  L_L88  L_L248  0.0034
K_K16361  L_L88  L_L249  0.0033
K_K16362  L_L88  L_L250  0.0032
K_K16363  L_L88  L_L251  0.0030
K_K16364  L_L88  L_L252  0.0029
K_K16365  L_L88  L_L253  0.0028
K_K16366  L_L88  L_L254  0.0027
K_K16367  L_L88  L_L255  0.0026
K_K16368  L_L88  L_L256  0.0025
K_K16369  L_L88  L_L257  0.0024
K_K16370  L_L88  L_L258  0.0024
K_K16371  L_L88  L_L259  0.0023
K_K16372  L_L88  L_L260  0.0022
K_K16373  L_L88  L_L261  0.0022
K_K16374  L_L88  L_L262  0.0021
K_K16375  L_L88  L_L263  0.0020
K_K16376  L_L88  L_L264  0.0020
K_K16377  L_L88  L_L265  0.0019
K_K16378  L_L88  L_L266  0.0019
K_K16379  L_L88  L_L267  0.0018
K_K16380  L_L88  L_L268  0.0018
K_K16381  L_L88  L_L269  0.0018
K_K16382  L_L88  L_L270  0.0017
K_K16383  L_L88  L_L271  0.0017
K_K16384  L_L88  L_L272  0.0016
K_K16385  L_L88  L_L273  0.0016
K_K16386  L_L88  L_L274  0.0016
K_K16387  L_L88  L_L275  0.0015
K_K16388  L_L88  L_L276  0.0015
* *  Branch  NTMP0000000088 - NTMP0000000089
R_R89  NTMP0000000088  nU_89  32.914993m  TC=0,0
V_Ui89  nU_89  nR_89  STIMULUS=U_IND_0000000089
R_V177  nR_89  nV_177  23.280268m  TC=0,0
L_V177  nR_89  nV_177  0.014646uH
R_V178  nV_177  nV_178  7.852787m  TC=0,0
L_V178  nV_177  nV_178  0.073723uH
L_L89  nV_178  NTMP0000000089  6.519695uH
K_K16389  L_L89  L_L90  0.1050
K_K16390  L_L89  L_L91  0.0397
K_K16391  L_L89  L_L92  0.0258
K_K16392  L_L89  L_L93  0.0192
K_K16393  L_L89  L_L94  0.0153
K_K16394  L_L89  L_L95  0.0127
K_K16395  L_L89  L_L96  0.0109
K_K16396  L_L89  L_L97  0.0095
K_K16397  L_L89  L_L98  0.0084
K_K16398  L_L89  L_L99  0.0076
K_K16399  L_L89  L_L100  0.0069
K_K16400  L_L89  L_L101  0.0063
K_K16401  L_L89  L_L102  0.0058
K_K16402  L_L89  L_L103  0.0054
K_K16403  L_L89  L_L104  0.0051
K_K16404  L_L89  L_L105  0.0047
K_K16405  L_L89  L_L106  0.0045
K_K16406  L_L89  L_L107  0.0042
K_K16407  L_L89  L_L108  0.0040
K_K16408  L_L89  L_L109  0.0038
K_K16409  L_L89  L_L110  0.0036
K_K16410  L_L89  L_L111  0.0034
K_K16411  L_L89  L_L112  0.0033
K_K16412  L_L89  L_L113  0.0032
K_K16413  L_L89  L_L114  0.0030
K_K16414  L_L89  L_L115  0.0029
K_K16415  L_L89  L_L116  0.0028
K_K16416  L_L89  L_L117  0.0027
K_K16417  L_L89  L_L118  0.0026
K_K16418  L_L89  L_L119  0.0025
K_K16419  L_L89  L_L120  0.0024
K_K16420  L_L89  L_L121  0.0024
K_K16421  L_L89  L_L122  0.0023
K_K16422  L_L89  L_L123  0.0022
K_K16423  L_L89  L_L124  0.0022
K_K16424  L_L89  L_L125  0.0021
K_K16425  L_L89  L_L126  0.0020
K_K16426  L_L89  L_L127  0.0020
K_K16427  L_L89  L_L128  0.0019
K_K16428  L_L89  L_L129  0.0019
K_K16429  L_L89  L_L130  0.0019
K_K16430  L_L89  L_L131  0.0018
K_K16431  L_L89  L_L132  0.0018
K_K16432  L_L89  L_L133  0.0017
K_K16433  L_L89  L_L134  0.0017
K_K16434  L_L89  L_L135  0.0017
K_K16435  L_L89  L_L136  0.0016
K_K16436  L_L89  L_L137  0.0016
K_K16437  L_L89  L_L138  0.0015
K_K16438  L_L89  L_L152  0.0010
K_K16439  L_L89  L_L153  0.0010
K_K16440  L_L89  L_L154  0.0010
K_K16441  L_L89  L_L155  0.0011
K_K16442  L_L89  L_L156  0.0011
K_K16443  L_L89  L_L157  0.0011
K_K16444  L_L89  L_L158  0.0011
K_K16445  L_L89  L_L159  0.0011
K_K16446  L_L89  L_L160  0.0011
K_K16447  L_L89  L_L161  0.0011
K_K16448  L_L89  L_L162  0.0012
K_K16449  L_L89  L_L163  0.0012
K_K16450  L_L89  L_L164  0.0012
K_K16451  L_L89  L_L165  0.0012
K_K16452  L_L89  L_L166  0.0012
K_K16453  L_L89  L_L167  0.0013
K_K16454  L_L89  L_L168  0.0013
K_K16455  L_L89  L_L169  0.0013
K_K16456  L_L89  L_L170  0.0013
K_K16457  L_L89  L_L171  0.0014
K_K16458  L_L89  L_L172  0.0014
K_K16459  L_L89  L_L173  0.0014
K_K16460  L_L89  L_L174  0.0014
K_K16461  L_L89  L_L175  0.0015
K_K16462  L_L89  L_L176  0.0015
K_K16463  L_L89  L_L177  0.0015
K_K16464  L_L89  L_L178  0.0015
K_K16465  L_L89  L_L179  0.0016
K_K16466  L_L89  L_L180  0.0016
K_K16467  L_L89  L_L181  0.0016
K_K16468  L_L89  L_L182  0.0017
K_K16469  L_L89  L_L183  0.0017
K_K16470  L_L89  L_L184  0.0018
K_K16471  L_L89  L_L185  0.0018
K_K16472  L_L89  L_L186  0.0018
K_K16473  L_L89  L_L187  0.0019
K_K16474  L_L89  L_L188  0.0019
K_K16475  L_L89  L_L189  0.0020
K_K16476  L_L89  L_L190  0.0020
K_K16477  L_L89  L_L191  0.0021
K_K16478  L_L89  L_L192  0.0022
K_K16479  L_L89  L_L193  0.0022
K_K16480  L_L89  L_L194  0.0023
K_K16481  L_L89  L_L195  0.0024
K_K16482  L_L89  L_L196  0.0024
K_K16483  L_L89  L_L197  0.0025
K_K16484  L_L89  L_L198  0.0026
K_K16485  L_L89  L_L199  0.0027
K_K16486  L_L89  L_L200  0.0028
K_K16487  L_L89  L_L201  0.0029
K_K16488  L_L89  L_L202  0.0030
K_K16489  L_L89  L_L203  0.0032
K_K16490  L_L89  L_L204  0.0033
K_K16491  L_L89  L_L205  0.0034
K_K16492  L_L89  L_L206  0.0036
K_K16493  L_L89  L_L207  0.0038
K_K16494  L_L89  L_L208  0.0040
K_K16495  L_L89  L_L209  0.0042
K_K16496  L_L89  L_L210  0.0045
K_K16497  L_L89  L_L211  0.0047
K_K16498  L_L89  L_L212  0.0051
K_K16499  L_L89  L_L213  0.0054
K_K16500  L_L89  L_L214  0.0058
K_K16501  L_L89  L_L215  0.0063
K_K16502  L_L89  L_L216  0.0069
K_K16503  L_L89  L_L217  0.0076
K_K16504  L_L89  L_L218  0.0084
K_K16505  L_L89  L_L219  0.0095
K_K16506  L_L89  L_L220  0.0109
K_K16507  L_L89  L_L221  0.0127
K_K16508  L_L89  L_L222  0.0152
K_K16509  L_L89  L_L223  0.0191
K_K16510  L_L89  L_L224  0.0256
K_K16511  L_L89  L_L225  0.0389
K_K16512  L_L89  L_L226  0.0812
K_K16513  L_L89  L_L227  0.1569
K_K16514  L_L89  L_L228  0.0812
K_K16515  L_L89  L_L229  0.0389
K_K16516  L_L89  L_L230  0.0256
K_K16517  L_L89  L_L231  0.0191
K_K16518  L_L89  L_L232  0.0152
K_K16519  L_L89  L_L233  0.0127
K_K16520  L_L89  L_L234  0.0109
K_K16521  L_L89  L_L235  0.0095
K_K16522  L_L89  L_L236  0.0084
K_K16523  L_L89  L_L237  0.0076
K_K16524  L_L89  L_L238  0.0069
K_K16525  L_L89  L_L239  0.0063
K_K16526  L_L89  L_L240  0.0058
K_K16527  L_L89  L_L241  0.0054
K_K16528  L_L89  L_L242  0.0051
K_K16529  L_L89  L_L243  0.0047
K_K16530  L_L89  L_L244  0.0045
K_K16531  L_L89  L_L245  0.0042
K_K16532  L_L89  L_L246  0.0040
K_K16533  L_L89  L_L247  0.0038
K_K16534  L_L89  L_L248  0.0036
K_K16535  L_L89  L_L249  0.0034
K_K16536  L_L89  L_L250  0.0033
K_K16537  L_L89  L_L251  0.0032
K_K16538  L_L89  L_L252  0.0030
K_K16539  L_L89  L_L253  0.0029
K_K16540  L_L89  L_L254  0.0028
K_K16541  L_L89  L_L255  0.0027
K_K16542  L_L89  L_L256  0.0026
K_K16543  L_L89  L_L257  0.0025
K_K16544  L_L89  L_L258  0.0024
K_K16545  L_L89  L_L259  0.0024
K_K16546  L_L89  L_L260  0.0023
K_K16547  L_L89  L_L261  0.0022
K_K16548  L_L89  L_L262  0.0022
K_K16549  L_L89  L_L263  0.0021
K_K16550  L_L89  L_L264  0.0020
K_K16551  L_L89  L_L265  0.0020
K_K16552  L_L89  L_L266  0.0019
K_K16553  L_L89  L_L267  0.0019
K_K16554  L_L89  L_L268  0.0018
K_K16555  L_L89  L_L269  0.0018
K_K16556  L_L89  L_L270  0.0018
K_K16557  L_L89  L_L271  0.0017
K_K16558  L_L89  L_L272  0.0017
K_K16559  L_L89  L_L273  0.0016
K_K16560  L_L89  L_L274  0.0016
K_K16561  L_L89  L_L275  0.0016
K_K16562  L_L89  L_L276  0.0015
* *  Branch  NTMP0000000089 - NTMP0000000090
R_R90  NTMP0000000089  nU_90  32.914993m  TC=0,0
V_Ui90  nU_90  nR_90  STIMULUS=U_IND_0000000090
R_V179  nR_90  nV_179  23.280268m  TC=0,0
L_V179  nR_90  nV_179  0.014646uH
R_V180  nV_179  nV_180  7.852787m  TC=0,0
L_V180  nV_179  nV_180  0.073723uH
L_L90  nV_180  NTMP0000000090  6.519695uH
K_K16563  L_L90  L_L91  0.1050
K_K16564  L_L90  L_L92  0.0397
K_K16565  L_L90  L_L93  0.0258
K_K16566  L_L90  L_L94  0.0192
K_K16567  L_L90  L_L95  0.0153
K_K16568  L_L90  L_L96  0.0127
K_K16569  L_L90  L_L97  0.0109
K_K16570  L_L90  L_L98  0.0095
K_K16571  L_L90  L_L99  0.0084
K_K16572  L_L90  L_L100  0.0076
K_K16573  L_L90  L_L101  0.0069
K_K16574  L_L90  L_L102  0.0063
K_K16575  L_L90  L_L103  0.0058
K_K16576  L_L90  L_L104  0.0054
K_K16577  L_L90  L_L105  0.0051
K_K16578  L_L90  L_L106  0.0047
K_K16579  L_L90  L_L107  0.0045
K_K16580  L_L90  L_L108  0.0042
K_K16581  L_L90  L_L109  0.0040
K_K16582  L_L90  L_L110  0.0038
K_K16583  L_L90  L_L111  0.0036
K_K16584  L_L90  L_L112  0.0034
K_K16585  L_L90  L_L113  0.0033
K_K16586  L_L90  L_L114  0.0032
K_K16587  L_L90  L_L115  0.0030
K_K16588  L_L90  L_L116  0.0029
K_K16589  L_L90  L_L117  0.0028
K_K16590  L_L90  L_L118  0.0027
K_K16591  L_L90  L_L119  0.0026
K_K16592  L_L90  L_L120  0.0025
K_K16593  L_L90  L_L121  0.0024
K_K16594  L_L90  L_L122  0.0024
K_K16595  L_L90  L_L123  0.0023
K_K16596  L_L90  L_L124  0.0022
K_K16597  L_L90  L_L125  0.0022
K_K16598  L_L90  L_L126  0.0021
K_K16599  L_L90  L_L127  0.0020
K_K16600  L_L90  L_L128  0.0020
K_K16601  L_L90  L_L129  0.0019
K_K16602  L_L90  L_L130  0.0019
K_K16603  L_L90  L_L131  0.0019
K_K16604  L_L90  L_L132  0.0018
K_K16605  L_L90  L_L133  0.0018
K_K16606  L_L90  L_L134  0.0017
K_K16607  L_L90  L_L135  0.0017
K_K16608  L_L90  L_L136  0.0017
K_K16609  L_L90  L_L137  0.0016
K_K16610  L_L90  L_L138  0.0016
K_K16611  L_L90  L_L153  0.0010
K_K16612  L_L90  L_L154  0.0010
K_K16613  L_L90  L_L155  0.0010
K_K16614  L_L90  L_L156  0.0011
K_K16615  L_L90  L_L157  0.0011
K_K16616  L_L90  L_L158  0.0011
K_K16617  L_L90  L_L159  0.0011
K_K16618  L_L90  L_L160  0.0011
K_K16619  L_L90  L_L161  0.0011
K_K16620  L_L90  L_L162  0.0011
K_K16621  L_L90  L_L163  0.0012
K_K16622  L_L90  L_L164  0.0012
K_K16623  L_L90  L_L165  0.0012
K_K16624  L_L90  L_L166  0.0012
K_K16625  L_L90  L_L167  0.0012
K_K16626  L_L90  L_L168  0.0013
K_K16627  L_L90  L_L169  0.0013
K_K16628  L_L90  L_L170  0.0013
K_K16629  L_L90  L_L171  0.0013
K_K16630  L_L90  L_L172  0.0014
K_K16631  L_L90  L_L173  0.0014
K_K16632  L_L90  L_L174  0.0014
K_K16633  L_L90  L_L175  0.0014
K_K16634  L_L90  L_L176  0.0015
K_K16635  L_L90  L_L177  0.0015
K_K16636  L_L90  L_L178  0.0015
K_K16637  L_L90  L_L179  0.0015
K_K16638  L_L90  L_L180  0.0016
K_K16639  L_L90  L_L181  0.0016
K_K16640  L_L90  L_L182  0.0016
K_K16641  L_L90  L_L183  0.0017
K_K16642  L_L90  L_L184  0.0017
K_K16643  L_L90  L_L185  0.0018
K_K16644  L_L90  L_L186  0.0018
K_K16645  L_L90  L_L187  0.0018
K_K16646  L_L90  L_L188  0.0019
K_K16647  L_L90  L_L189  0.0019
K_K16648  L_L90  L_L190  0.0020
K_K16649  L_L90  L_L191  0.0020
K_K16650  L_L90  L_L192  0.0021
K_K16651  L_L90  L_L193  0.0022
K_K16652  L_L90  L_L194  0.0022
K_K16653  L_L90  L_L195  0.0023
K_K16654  L_L90  L_L196  0.0024
K_K16655  L_L90  L_L197  0.0024
K_K16656  L_L90  L_L198  0.0025
K_K16657  L_L90  L_L199  0.0026
K_K16658  L_L90  L_L200  0.0027
K_K16659  L_L90  L_L201  0.0028
K_K16660  L_L90  L_L202  0.0029
K_K16661  L_L90  L_L203  0.0030
K_K16662  L_L90  L_L204  0.0032
K_K16663  L_L90  L_L205  0.0033
K_K16664  L_L90  L_L206  0.0034
K_K16665  L_L90  L_L207  0.0036
K_K16666  L_L90  L_L208  0.0038
K_K16667  L_L90  L_L209  0.0040
K_K16668  L_L90  L_L210  0.0042
K_K16669  L_L90  L_L211  0.0045
K_K16670  L_L90  L_L212  0.0047
K_K16671  L_L90  L_L213  0.0051
K_K16672  L_L90  L_L214  0.0054
K_K16673  L_L90  L_L215  0.0058
K_K16674  L_L90  L_L216  0.0063
K_K16675  L_L90  L_L217  0.0069
K_K16676  L_L90  L_L218  0.0076
K_K16677  L_L90  L_L219  0.0084
K_K16678  L_L90  L_L220  0.0095
K_K16679  L_L90  L_L221  0.0109
K_K16680  L_L90  L_L222  0.0127
K_K16681  L_L90  L_L223  0.0152
K_K16682  L_L90  L_L224  0.0191
K_K16683  L_L90  L_L225  0.0256
K_K16684  L_L90  L_L226  0.0389
K_K16685  L_L90  L_L227  0.0812
K_K16686  L_L90  L_L228  0.1569
K_K16687  L_L90  L_L229  0.0812
K_K16688  L_L90  L_L230  0.0389
K_K16689  L_L90  L_L231  0.0256
K_K16690  L_L90  L_L232  0.0191
K_K16691  L_L90  L_L233  0.0152
K_K16692  L_L90  L_L234  0.0127
K_K16693  L_L90  L_L235  0.0109
K_K16694  L_L90  L_L236  0.0095
K_K16695  L_L90  L_L237  0.0084
K_K16696  L_L90  L_L238  0.0076
K_K16697  L_L90  L_L239  0.0069
K_K16698  L_L90  L_L240  0.0063
K_K16699  L_L90  L_L241  0.0058
K_K16700  L_L90  L_L242  0.0054
K_K16701  L_L90  L_L243  0.0051
K_K16702  L_L90  L_L244  0.0047
K_K16703  L_L90  L_L245  0.0045
K_K16704  L_L90  L_L246  0.0042
K_K16705  L_L90  L_L247  0.0040
K_K16706  L_L90  L_L248  0.0038
K_K16707  L_L90  L_L249  0.0036
K_K16708  L_L90  L_L250  0.0034
K_K16709  L_L90  L_L251  0.0033
K_K16710  L_L90  L_L252  0.0032
K_K16711  L_L90  L_L253  0.0030
K_K16712  L_L90  L_L254  0.0029
K_K16713  L_L90  L_L255  0.0028
K_K16714  L_L90  L_L256  0.0027
K_K16715  L_L90  L_L257  0.0026
K_K16716  L_L90  L_L258  0.0025
K_K16717  L_L90  L_L259  0.0024
K_K16718  L_L90  L_L260  0.0024
K_K16719  L_L90  L_L261  0.0023
K_K16720  L_L90  L_L262  0.0022
K_K16721  L_L90  L_L263  0.0022
K_K16722  L_L90  L_L264  0.0021
K_K16723  L_L90  L_L265  0.0020
K_K16724  L_L90  L_L266  0.0020
K_K16725  L_L90  L_L267  0.0019
K_K16726  L_L90  L_L268  0.0019
K_K16727  L_L90  L_L269  0.0018
K_K16728  L_L90  L_L270  0.0018
K_K16729  L_L90  L_L271  0.0018
K_K16730  L_L90  L_L272  0.0017
K_K16731  L_L90  L_L273  0.0017
K_K16732  L_L90  L_L274  0.0016
K_K16733  L_L90  L_L275  0.0016
K_K16734  L_L90  L_L276  0.0016
* *  Branch  NTMP0000000090 - NTMP0000000091
R_R91  NTMP0000000090  nU_91  32.914993m  TC=0,0
V_Ui91  nU_91  nR_91  STIMULUS=U_IND_0000000091
R_V181  nR_91  nV_181  23.280268m  TC=0,0
L_V181  nR_91  nV_181  0.014646uH
R_V182  nV_181  nV_182  7.852787m  TC=0,0
L_V182  nV_181  nV_182  0.073723uH
L_L91  nV_182  NTMP0000000091  6.519695uH
K_K16735  L_L91  L_L92  0.1050
K_K16736  L_L91  L_L93  0.0397
K_K16737  L_L91  L_L94  0.0258
K_K16738  L_L91  L_L95  0.0192
K_K16739  L_L91  L_L96  0.0153
K_K16740  L_L91  L_L97  0.0127
K_K16741  L_L91  L_L98  0.0109
K_K16742  L_L91  L_L99  0.0095
K_K16743  L_L91  L_L100  0.0084
K_K16744  L_L91  L_L101  0.0076
K_K16745  L_L91  L_L102  0.0069
K_K16746  L_L91  L_L103  0.0063
K_K16747  L_L91  L_L104  0.0058
K_K16748  L_L91  L_L105  0.0054
K_K16749  L_L91  L_L106  0.0051
K_K16750  L_L91  L_L107  0.0047
K_K16751  L_L91  L_L108  0.0045
K_K16752  L_L91  L_L109  0.0042
K_K16753  L_L91  L_L110  0.0040
K_K16754  L_L91  L_L111  0.0038
K_K16755  L_L91  L_L112  0.0036
K_K16756  L_L91  L_L113  0.0034
K_K16757  L_L91  L_L114  0.0033
K_K16758  L_L91  L_L115  0.0032
K_K16759  L_L91  L_L116  0.0030
K_K16760  L_L91  L_L117  0.0029
K_K16761  L_L91  L_L118  0.0028
K_K16762  L_L91  L_L119  0.0027
K_K16763  L_L91  L_L120  0.0026
K_K16764  L_L91  L_L121  0.0025
K_K16765  L_L91  L_L122  0.0024
K_K16766  L_L91  L_L123  0.0024
K_K16767  L_L91  L_L124  0.0023
K_K16768  L_L91  L_L125  0.0022
K_K16769  L_L91  L_L126  0.0022
K_K16770  L_L91  L_L127  0.0021
K_K16771  L_L91  L_L128  0.0020
K_K16772  L_L91  L_L129  0.0020
K_K16773  L_L91  L_L130  0.0019
K_K16774  L_L91  L_L131  0.0019
K_K16775  L_L91  L_L132  0.0019
K_K16776  L_L91  L_L133  0.0018
K_K16777  L_L91  L_L134  0.0018
K_K16778  L_L91  L_L135  0.0017
K_K16779  L_L91  L_L136  0.0017
K_K16780  L_L91  L_L137  0.0017
K_K16781  L_L91  L_L138  0.0016
K_K16782  L_L91  L_L154  0.0010
K_K16783  L_L91  L_L155  0.0010
K_K16784  L_L91  L_L156  0.0010
K_K16785  L_L91  L_L157  0.0011
K_K16786  L_L91  L_L158  0.0011
K_K16787  L_L91  L_L159  0.0011
K_K16788  L_L91  L_L160  0.0011
K_K16789  L_L91  L_L161  0.0011
K_K16790  L_L91  L_L162  0.0011
K_K16791  L_L91  L_L163  0.0011
K_K16792  L_L91  L_L164  0.0012
K_K16793  L_L91  L_L165  0.0012
K_K16794  L_L91  L_L166  0.0012
K_K16795  L_L91  L_L167  0.0012
K_K16796  L_L91  L_L168  0.0012
K_K16797  L_L91  L_L169  0.0013
K_K16798  L_L91  L_L170  0.0013
K_K16799  L_L91  L_L171  0.0013
K_K16800  L_L91  L_L172  0.0013
K_K16801  L_L91  L_L173  0.0014
K_K16802  L_L91  L_L174  0.0014
K_K16803  L_L91  L_L175  0.0014
K_K16804  L_L91  L_L176  0.0014
K_K16805  L_L91  L_L177  0.0015
K_K16806  L_L91  L_L178  0.0015
K_K16807  L_L91  L_L179  0.0015
K_K16808  L_L91  L_L180  0.0015
K_K16809  L_L91  L_L181  0.0016
K_K16810  L_L91  L_L182  0.0016
K_K16811  L_L91  L_L183  0.0016
K_K16812  L_L91  L_L184  0.0017
K_K16813  L_L91  L_L185  0.0017
K_K16814  L_L91  L_L186  0.0018
K_K16815  L_L91  L_L187  0.0018
K_K16816  L_L91  L_L188  0.0018
K_K16817  L_L91  L_L189  0.0019
K_K16818  L_L91  L_L190  0.0019
K_K16819  L_L91  L_L191  0.0020
K_K16820  L_L91  L_L192  0.0020
K_K16821  L_L91  L_L193  0.0021
K_K16822  L_L91  L_L194  0.0022
K_K16823  L_L91  L_L195  0.0022
K_K16824  L_L91  L_L196  0.0023
K_K16825  L_L91  L_L197  0.0024
K_K16826  L_L91  L_L198  0.0024
K_K16827  L_L91  L_L199  0.0025
K_K16828  L_L91  L_L200  0.0026
K_K16829  L_L91  L_L201  0.0027
K_K16830  L_L91  L_L202  0.0028
K_K16831  L_L91  L_L203  0.0029
K_K16832  L_L91  L_L204  0.0030
K_K16833  L_L91  L_L205  0.0032
K_K16834  L_L91  L_L206  0.0033
K_K16835  L_L91  L_L207  0.0034
K_K16836  L_L91  L_L208  0.0036
K_K16837  L_L91  L_L209  0.0038
K_K16838  L_L91  L_L210  0.0040
K_K16839  L_L91  L_L211  0.0042
K_K16840  L_L91  L_L212  0.0045
K_K16841  L_L91  L_L213  0.0047
K_K16842  L_L91  L_L214  0.0051
K_K16843  L_L91  L_L215  0.0054
K_K16844  L_L91  L_L216  0.0058
K_K16845  L_L91  L_L217  0.0063
K_K16846  L_L91  L_L218  0.0069
K_K16847  L_L91  L_L219  0.0076
K_K16848  L_L91  L_L220  0.0084
K_K16849  L_L91  L_L221  0.0095
K_K16850  L_L91  L_L222  0.0109
K_K16851  L_L91  L_L223  0.0127
K_K16852  L_L91  L_L224  0.0152
K_K16853  L_L91  L_L225  0.0191
K_K16854  L_L91  L_L226  0.0256
K_K16855  L_L91  L_L227  0.0389
K_K16856  L_L91  L_L228  0.0812
K_K16857  L_L91  L_L229  0.1569
K_K16858  L_L91  L_L230  0.0812
K_K16859  L_L91  L_L231  0.0389
K_K16860  L_L91  L_L232  0.0256
K_K16861  L_L91  L_L233  0.0191
K_K16862  L_L91  L_L234  0.0152
K_K16863  L_L91  L_L235  0.0127
K_K16864  L_L91  L_L236  0.0109
K_K16865  L_L91  L_L237  0.0095
K_K16866  L_L91  L_L238  0.0084
K_K16867  L_L91  L_L239  0.0076
K_K16868  L_L91  L_L240  0.0069
K_K16869  L_L91  L_L241  0.0063
K_K16870  L_L91  L_L242  0.0058
K_K16871  L_L91  L_L243  0.0054
K_K16872  L_L91  L_L244  0.0051
K_K16873  L_L91  L_L245  0.0047
K_K16874  L_L91  L_L246  0.0045
K_K16875  L_L91  L_L247  0.0042
K_K16876  L_L91  L_L248  0.0040
K_K16877  L_L91  L_L249  0.0038
K_K16878  L_L91  L_L250  0.0036
K_K16879  L_L91  L_L251  0.0034
K_K16880  L_L91  L_L252  0.0033
K_K16881  L_L91  L_L253  0.0032
K_K16882  L_L91  L_L254  0.0030
K_K16883  L_L91  L_L255  0.0029
K_K16884  L_L91  L_L256  0.0028
K_K16885  L_L91  L_L257  0.0027
K_K16886  L_L91  L_L258  0.0026
K_K16887  L_L91  L_L259  0.0025
K_K16888  L_L91  L_L260  0.0024
K_K16889  L_L91  L_L261  0.0024
K_K16890  L_L91  L_L262  0.0023
K_K16891  L_L91  L_L263  0.0022
K_K16892  L_L91  L_L264  0.0022
K_K16893  L_L91  L_L265  0.0021
K_K16894  L_L91  L_L266  0.0020
K_K16895  L_L91  L_L267  0.0020
K_K16896  L_L91  L_L268  0.0019
K_K16897  L_L91  L_L269  0.0019
K_K16898  L_L91  L_L270  0.0018
K_K16899  L_L91  L_L271  0.0018
K_K16900  L_L91  L_L272  0.0018
K_K16901  L_L91  L_L273  0.0017
K_K16902  L_L91  L_L274  0.0017
K_K16903  L_L91  L_L275  0.0016
K_K16904  L_L91  L_L276  0.0016
* *  Branch  NTMP0000000091 - NTMP0000000092
R_R92  NTMP0000000091  nU_92  32.914993m  TC=0,0
V_Ui92  nU_92  nR_92  STIMULUS=U_IND_0000000092
R_V183  nR_92  nV_183  23.280268m  TC=0,0
L_V183  nR_92  nV_183  0.014646uH
R_V184  nV_183  nV_184  7.852787m  TC=0,0
L_V184  nV_183  nV_184  0.073723uH
L_L92  nV_184  NTMP0000000092  6.519695uH
K_K16905  L_L92  L_L93  0.1050
K_K16906  L_L92  L_L94  0.0397
K_K16907  L_L92  L_L95  0.0258
K_K16908  L_L92  L_L96  0.0192
K_K16909  L_L92  L_L97  0.0153
K_K16910  L_L92  L_L98  0.0127
K_K16911  L_L92  L_L99  0.0109
K_K16912  L_L92  L_L100  0.0095
K_K16913  L_L92  L_L101  0.0084
K_K16914  L_L92  L_L102  0.0076
K_K16915  L_L92  L_L103  0.0069
K_K16916  L_L92  L_L104  0.0063
K_K16917  L_L92  L_L105  0.0058
K_K16918  L_L92  L_L106  0.0054
K_K16919  L_L92  L_L107  0.0051
K_K16920  L_L92  L_L108  0.0047
K_K16921  L_L92  L_L109  0.0045
K_K16922  L_L92  L_L110  0.0042
K_K16923  L_L92  L_L111  0.0040
K_K16924  L_L92  L_L112  0.0038
K_K16925  L_L92  L_L113  0.0036
K_K16926  L_L92  L_L114  0.0034
K_K16927  L_L92  L_L115  0.0033
K_K16928  L_L92  L_L116  0.0032
K_K16929  L_L92  L_L117  0.0030
K_K16930  L_L92  L_L118  0.0029
K_K16931  L_L92  L_L119  0.0028
K_K16932  L_L92  L_L120  0.0027
K_K16933  L_L92  L_L121  0.0026
K_K16934  L_L92  L_L122  0.0025
K_K16935  L_L92  L_L123  0.0024
K_K16936  L_L92  L_L124  0.0024
K_K16937  L_L92  L_L125  0.0023
K_K16938  L_L92  L_L126  0.0022
K_K16939  L_L92  L_L127  0.0022
K_K16940  L_L92  L_L128  0.0021
K_K16941  L_L92  L_L129  0.0020
K_K16942  L_L92  L_L130  0.0020
K_K16943  L_L92  L_L131  0.0019
K_K16944  L_L92  L_L132  0.0019
K_K16945  L_L92  L_L133  0.0019
K_K16946  L_L92  L_L134  0.0018
K_K16947  L_L92  L_L135  0.0018
K_K16948  L_L92  L_L136  0.0017
K_K16949  L_L92  L_L137  0.0017
K_K16950  L_L92  L_L138  0.0017
K_K16951  L_L92  L_L155  0.0010
K_K16952  L_L92  L_L156  0.0010
K_K16953  L_L92  L_L157  0.0010
K_K16954  L_L92  L_L158  0.0011
K_K16955  L_L92  L_L159  0.0011
K_K16956  L_L92  L_L160  0.0011
K_K16957  L_L92  L_L161  0.0011
K_K16958  L_L92  L_L162  0.0011
K_K16959  L_L92  L_L163  0.0011
K_K16960  L_L92  L_L164  0.0011
K_K16961  L_L92  L_L165  0.0012
K_K16962  L_L92  L_L166  0.0012
K_K16963  L_L92  L_L167  0.0012
K_K16964  L_L92  L_L168  0.0012
K_K16965  L_L92  L_L169  0.0012
K_K16966  L_L92  L_L170  0.0013
K_K16967  L_L92  L_L171  0.0013
K_K16968  L_L92  L_L172  0.0013
K_K16969  L_L92  L_L173  0.0013
K_K16970  L_L92  L_L174  0.0014
K_K16971  L_L92  L_L175  0.0014
K_K16972  L_L92  L_L176  0.0014
K_K16973  L_L92  L_L177  0.0014
K_K16974  L_L92  L_L178  0.0015
K_K16975  L_L92  L_L179  0.0015
K_K16976  L_L92  L_L180  0.0015
K_K16977  L_L92  L_L181  0.0015
K_K16978  L_L92  L_L182  0.0016
K_K16979  L_L92  L_L183  0.0016
K_K16980  L_L92  L_L184  0.0016
K_K16981  L_L92  L_L185  0.0017
K_K16982  L_L92  L_L186  0.0017
K_K16983  L_L92  L_L187  0.0018
K_K16984  L_L92  L_L188  0.0018
K_K16985  L_L92  L_L189  0.0018
K_K16986  L_L92  L_L190  0.0019
K_K16987  L_L92  L_L191  0.0019
K_K16988  L_L92  L_L192  0.0020
K_K16989  L_L92  L_L193  0.0020
K_K16990  L_L92  L_L194  0.0021
K_K16991  L_L92  L_L195  0.0022
K_K16992  L_L92  L_L196  0.0022
K_K16993  L_L92  L_L197  0.0023
K_K16994  L_L92  L_L198  0.0024
K_K16995  L_L92  L_L199  0.0024
K_K16996  L_L92  L_L200  0.0025
K_K16997  L_L92  L_L201  0.0026
K_K16998  L_L92  L_L202  0.0027
K_K16999  L_L92  L_L203  0.0028
K_K17000  L_L92  L_L204  0.0029
K_K17001  L_L92  L_L205  0.0030
K_K17002  L_L92  L_L206  0.0032
K_K17003  L_L92  L_L207  0.0033
K_K17004  L_L92  L_L208  0.0034
K_K17005  L_L92  L_L209  0.0036
K_K17006  L_L92  L_L210  0.0038
K_K17007  L_L92  L_L211  0.0040
K_K17008  L_L92  L_L212  0.0042
K_K17009  L_L92  L_L213  0.0045
K_K17010  L_L92  L_L214  0.0047
K_K17011  L_L92  L_L215  0.0051
K_K17012  L_L92  L_L216  0.0054
K_K17013  L_L92  L_L217  0.0058
K_K17014  L_L92  L_L218  0.0063
K_K17015  L_L92  L_L219  0.0069
K_K17016  L_L92  L_L220  0.0076
K_K17017  L_L92  L_L221  0.0084
K_K17018  L_L92  L_L222  0.0095
K_K17019  L_L92  L_L223  0.0109
K_K17020  L_L92  L_L224  0.0127
K_K17021  L_L92  L_L225  0.0152
K_K17022  L_L92  L_L226  0.0191
K_K17023  L_L92  L_L227  0.0256
K_K17024  L_L92  L_L228  0.0389
K_K17025  L_L92  L_L229  0.0812
K_K17026  L_L92  L_L230  0.1569
K_K17027  L_L92  L_L231  0.0812
K_K17028  L_L92  L_L232  0.0389
K_K17029  L_L92  L_L233  0.0256
K_K17030  L_L92  L_L234  0.0191
K_K17031  L_L92  L_L235  0.0152
K_K17032  L_L92  L_L236  0.0127
K_K17033  L_L92  L_L237  0.0109
K_K17034  L_L92  L_L238  0.0095
K_K17035  L_L92  L_L239  0.0084
K_K17036  L_L92  L_L240  0.0076
K_K17037  L_L92  L_L241  0.0069
K_K17038  L_L92  L_L242  0.0063
K_K17039  L_L92  L_L243  0.0058
K_K17040  L_L92  L_L244  0.0054
K_K17041  L_L92  L_L245  0.0051
K_K17042  L_L92  L_L246  0.0047
K_K17043  L_L92  L_L247  0.0045
K_K17044  L_L92  L_L248  0.0042
K_K17045  L_L92  L_L249  0.0040
K_K17046  L_L92  L_L250  0.0038
K_K17047  L_L92  L_L251  0.0036
K_K17048  L_L92  L_L252  0.0034
K_K17049  L_L92  L_L253  0.0033
K_K17050  L_L92  L_L254  0.0032
K_K17051  L_L92  L_L255  0.0030
K_K17052  L_L92  L_L256  0.0029
K_K17053  L_L92  L_L257  0.0028
K_K17054  L_L92  L_L258  0.0027
K_K17055  L_L92  L_L259  0.0026
K_K17056  L_L92  L_L260  0.0025
K_K17057  L_L92  L_L261  0.0024
K_K17058  L_L92  L_L262  0.0024
K_K17059  L_L92  L_L263  0.0023
K_K17060  L_L92  L_L264  0.0022
K_K17061  L_L92  L_L265  0.0022
K_K17062  L_L92  L_L266  0.0021
K_K17063  L_L92  L_L267  0.0020
K_K17064  L_L92  L_L268  0.0020
K_K17065  L_L92  L_L269  0.0019
K_K17066  L_L92  L_L270  0.0019
K_K17067  L_L92  L_L271  0.0018
K_K17068  L_L92  L_L272  0.0018
K_K17069  L_L92  L_L273  0.0018
K_K17070  L_L92  L_L274  0.0017
K_K17071  L_L92  L_L275  0.0017
K_K17072  L_L92  L_L276  0.0016
* *  Branch  NTMP0000000092 - NTMP0000000093
R_R93  NTMP0000000092  nU_93  32.914993m  TC=0,0
V_Ui93  nU_93  nR_93  STIMULUS=U_IND_0000000093
R_V185  nR_93  nV_185  23.280268m  TC=0,0
L_V185  nR_93  nV_185  0.014646uH
R_V186  nV_185  nV_186  7.852787m  TC=0,0
L_V186  nV_185  nV_186  0.073723uH
L_L93  nV_186  NTMP0000000093  6.519695uH
K_K17073  L_L93  L_L94  0.1050
K_K17074  L_L93  L_L95  0.0397
K_K17075  L_L93  L_L96  0.0258
K_K17076  L_L93  L_L97  0.0192
K_K17077  L_L93  L_L98  0.0153
K_K17078  L_L93  L_L99  0.0127
K_K17079  L_L93  L_L100  0.0109
K_K17080  L_L93  L_L101  0.0095
K_K17081  L_L93  L_L102  0.0084
K_K17082  L_L93  L_L103  0.0076
K_K17083  L_L93  L_L104  0.0069
K_K17084  L_L93  L_L105  0.0063
K_K17085  L_L93  L_L106  0.0058
K_K17086  L_L93  L_L107  0.0054
K_K17087  L_L93  L_L108  0.0051
K_K17088  L_L93  L_L109  0.0047
K_K17089  L_L93  L_L110  0.0045
K_K17090  L_L93  L_L111  0.0042
K_K17091  L_L93  L_L112  0.0040
K_K17092  L_L93  L_L113  0.0038
K_K17093  L_L93  L_L114  0.0036
K_K17094  L_L93  L_L115  0.0034
K_K17095  L_L93  L_L116  0.0033
K_K17096  L_L93  L_L117  0.0032
K_K17097  L_L93  L_L118  0.0030
K_K17098  L_L93  L_L119  0.0029
K_K17099  L_L93  L_L120  0.0028
K_K17100  L_L93  L_L121  0.0027
K_K17101  L_L93  L_L122  0.0026
K_K17102  L_L93  L_L123  0.0025
K_K17103  L_L93  L_L124  0.0024
K_K17104  L_L93  L_L125  0.0024
K_K17105  L_L93  L_L126  0.0023
K_K17106  L_L93  L_L127  0.0022
K_K17107  L_L93  L_L128  0.0022
K_K17108  L_L93  L_L129  0.0021
K_K17109  L_L93  L_L130  0.0020
K_K17110  L_L93  L_L131  0.0020
K_K17111  L_L93  L_L132  0.0019
K_K17112  L_L93  L_L133  0.0019
K_K17113  L_L93  L_L134  0.0019
K_K17114  L_L93  L_L135  0.0018
K_K17115  L_L93  L_L136  0.0018
K_K17116  L_L93  L_L137  0.0017
K_K17117  L_L93  L_L138  0.0017
K_K17118  L_L93  L_L156  0.0010
K_K17119  L_L93  L_L157  0.0010
K_K17120  L_L93  L_L158  0.0010
K_K17121  L_L93  L_L159  0.0011
K_K17122  L_L93  L_L160  0.0011
K_K17123  L_L93  L_L161  0.0011
K_K17124  L_L93  L_L162  0.0011
K_K17125  L_L93  L_L163  0.0011
K_K17126  L_L93  L_L164  0.0011
K_K17127  L_L93  L_L165  0.0011
K_K17128  L_L93  L_L166  0.0012
K_K17129  L_L93  L_L167  0.0012
K_K17130  L_L93  L_L168  0.0012
K_K17131  L_L93  L_L169  0.0012
K_K17132  L_L93  L_L170  0.0012
K_K17133  L_L93  L_L171  0.0013
K_K17134  L_L93  L_L172  0.0013
K_K17135  L_L93  L_L173  0.0013
K_K17136  L_L93  L_L174  0.0013
K_K17137  L_L93  L_L175  0.0014
K_K17138  L_L93  L_L176  0.0014
K_K17139  L_L93  L_L177  0.0014
K_K17140  L_L93  L_L178  0.0014
K_K17141  L_L93  L_L179  0.0015
K_K17142  L_L93  L_L180  0.0015
K_K17143  L_L93  L_L181  0.0015
K_K17144  L_L93  L_L182  0.0015
K_K17145  L_L93  L_L183  0.0016
K_K17146  L_L93  L_L184  0.0016
K_K17147  L_L93  L_L185  0.0016
K_K17148  L_L93  L_L186  0.0017
K_K17149  L_L93  L_L187  0.0017
K_K17150  L_L93  L_L188  0.0018
K_K17151  L_L93  L_L189  0.0018
K_K17152  L_L93  L_L190  0.0018
K_K17153  L_L93  L_L191  0.0019
K_K17154  L_L93  L_L192  0.0019
K_K17155  L_L93  L_L193  0.0020
K_K17156  L_L93  L_L194  0.0020
K_K17157  L_L93  L_L195  0.0021
K_K17158  L_L93  L_L196  0.0022
K_K17159  L_L93  L_L197  0.0022
K_K17160  L_L93  L_L198  0.0023
K_K17161  L_L93  L_L199  0.0024
K_K17162  L_L93  L_L200  0.0024
K_K17163  L_L93  L_L201  0.0025
K_K17164  L_L93  L_L202  0.0026
K_K17165  L_L93  L_L203  0.0027
K_K17166  L_L93  L_L204  0.0028
K_K17167  L_L93  L_L205  0.0029
K_K17168  L_L93  L_L206  0.0030
K_K17169  L_L93  L_L207  0.0032
K_K17170  L_L93  L_L208  0.0033
K_K17171  L_L93  L_L209  0.0034
K_K17172  L_L93  L_L210  0.0036
K_K17173  L_L93  L_L211  0.0038
K_K17174  L_L93  L_L212  0.0040
K_K17175  L_L93  L_L213  0.0042
K_K17176  L_L93  L_L214  0.0045
K_K17177  L_L93  L_L215  0.0047
K_K17178  L_L93  L_L216  0.0051
K_K17179  L_L93  L_L217  0.0054
K_K17180  L_L93  L_L218  0.0058
K_K17181  L_L93  L_L219  0.0063
K_K17182  L_L93  L_L220  0.0069
K_K17183  L_L93  L_L221  0.0076
K_K17184  L_L93  L_L222  0.0084
K_K17185  L_L93  L_L223  0.0095
K_K17186  L_L93  L_L224  0.0109
K_K17187  L_L93  L_L225  0.0127
K_K17188  L_L93  L_L226  0.0152
K_K17189  L_L93  L_L227  0.0191
K_K17190  L_L93  L_L228  0.0256
K_K17191  L_L93  L_L229  0.0389
K_K17192  L_L93  L_L230  0.0812
K_K17193  L_L93  L_L231  0.1569
K_K17194  L_L93  L_L232  0.0812
K_K17195  L_L93  L_L233  0.0389
K_K17196  L_L93  L_L234  0.0256
K_K17197  L_L93  L_L235  0.0191
K_K17198  L_L93  L_L236  0.0152
K_K17199  L_L93  L_L237  0.0127
K_K17200  L_L93  L_L238  0.0109
K_K17201  L_L93  L_L239  0.0095
K_K17202  L_L93  L_L240  0.0084
K_K17203  L_L93  L_L241  0.0076
K_K17204  L_L93  L_L242  0.0069
K_K17205  L_L93  L_L243  0.0063
K_K17206  L_L93  L_L244  0.0058
K_K17207  L_L93  L_L245  0.0054
K_K17208  L_L93  L_L246  0.0051
K_K17209  L_L93  L_L247  0.0047
K_K17210  L_L93  L_L248  0.0045
K_K17211  L_L93  L_L249  0.0042
K_K17212  L_L93  L_L250  0.0040
K_K17213  L_L93  L_L251  0.0038
K_K17214  L_L93  L_L252  0.0036
K_K17215  L_L93  L_L253  0.0034
K_K17216  L_L93  L_L254  0.0033
K_K17217  L_L93  L_L255  0.0032
K_K17218  L_L93  L_L256  0.0030
K_K17219  L_L93  L_L257  0.0029
K_K17220  L_L93  L_L258  0.0028
K_K17221  L_L93  L_L259  0.0027
K_K17222  L_L93  L_L260  0.0026
K_K17223  L_L93  L_L261  0.0025
K_K17224  L_L93  L_L262  0.0024
K_K17225  L_L93  L_L263  0.0024
K_K17226  L_L93  L_L264  0.0023
K_K17227  L_L93  L_L265  0.0022
K_K17228  L_L93  L_L266  0.0022
K_K17229  L_L93  L_L267  0.0021
K_K17230  L_L93  L_L268  0.0020
K_K17231  L_L93  L_L269  0.0020
K_K17232  L_L93  L_L270  0.0019
K_K17233  L_L93  L_L271  0.0019
K_K17234  L_L93  L_L272  0.0018
K_K17235  L_L93  L_L273  0.0018
K_K17236  L_L93  L_L274  0.0018
K_K17237  L_L93  L_L275  0.0017
K_K17238  L_L93  L_L276  0.0017
* *  Branch  NTMP0000000093 - NTMP0000000094
R_R94  NTMP0000000093  nU_94  32.914993m  TC=0,0
V_Ui94  nU_94  nR_94  STIMULUS=U_IND_0000000094
R_V187  nR_94  nV_187  23.280268m  TC=0,0
L_V187  nR_94  nV_187  0.014646uH
R_V188  nV_187  nV_188  7.852787m  TC=0,0
L_V188  nV_187  nV_188  0.073723uH
L_L94  nV_188  NTMP0000000094  6.519695uH
K_K17239  L_L94  L_L95  0.1050
K_K17240  L_L94  L_L96  0.0397
K_K17241  L_L94  L_L97  0.0258
K_K17242  L_L94  L_L98  0.0192
K_K17243  L_L94  L_L99  0.0153
K_K17244  L_L94  L_L100  0.0127
K_K17245  L_L94  L_L101  0.0109
K_K17246  L_L94  L_L102  0.0095
K_K17247  L_L94  L_L103  0.0084
K_K17248  L_L94  L_L104  0.0076
K_K17249  L_L94  L_L105  0.0069
K_K17250  L_L94  L_L106  0.0063
K_K17251  L_L94  L_L107  0.0058
K_K17252  L_L94  L_L108  0.0054
K_K17253  L_L94  L_L109  0.0051
K_K17254  L_L94  L_L110  0.0047
K_K17255  L_L94  L_L111  0.0045
K_K17256  L_L94  L_L112  0.0042
K_K17257  L_L94  L_L113  0.0040
K_K17258  L_L94  L_L114  0.0038
K_K17259  L_L94  L_L115  0.0036
K_K17260  L_L94  L_L116  0.0034
K_K17261  L_L94  L_L117  0.0033
K_K17262  L_L94  L_L118  0.0032
K_K17263  L_L94  L_L119  0.0030
K_K17264  L_L94  L_L120  0.0029
K_K17265  L_L94  L_L121  0.0028
K_K17266  L_L94  L_L122  0.0027
K_K17267  L_L94  L_L123  0.0026
K_K17268  L_L94  L_L124  0.0025
K_K17269  L_L94  L_L125  0.0024
K_K17270  L_L94  L_L126  0.0024
K_K17271  L_L94  L_L127  0.0023
K_K17272  L_L94  L_L128  0.0022
K_K17273  L_L94  L_L129  0.0022
K_K17274  L_L94  L_L130  0.0021
K_K17275  L_L94  L_L131  0.0020
K_K17276  L_L94  L_L132  0.0020
K_K17277  L_L94  L_L133  0.0019
K_K17278  L_L94  L_L134  0.0019
K_K17279  L_L94  L_L135  0.0019
K_K17280  L_L94  L_L136  0.0018
K_K17281  L_L94  L_L137  0.0018
K_K17282  L_L94  L_L138  0.0017
K_K17283  L_L94  L_L157  0.0010
K_K17284  L_L94  L_L158  0.0010
K_K17285  L_L94  L_L159  0.0010
K_K17286  L_L94  L_L160  0.0011
K_K17287  L_L94  L_L161  0.0011
K_K17288  L_L94  L_L162  0.0011
K_K17289  L_L94  L_L163  0.0011
K_K17290  L_L94  L_L164  0.0011
K_K17291  L_L94  L_L165  0.0011
K_K17292  L_L94  L_L166  0.0011
K_K17293  L_L94  L_L167  0.0012
K_K17294  L_L94  L_L168  0.0012
K_K17295  L_L94  L_L169  0.0012
K_K17296  L_L94  L_L170  0.0012
K_K17297  L_L94  L_L171  0.0012
K_K17298  L_L94  L_L172  0.0013
K_K17299  L_L94  L_L173  0.0013
K_K17300  L_L94  L_L174  0.0013
K_K17301  L_L94  L_L175  0.0013
K_K17302  L_L94  L_L176  0.0014
K_K17303  L_L94  L_L177  0.0014
K_K17304  L_L94  L_L178  0.0014
K_K17305  L_L94  L_L179  0.0014
K_K17306  L_L94  L_L180  0.0015
K_K17307  L_L94  L_L181  0.0015
K_K17308  L_L94  L_L182  0.0015
K_K17309  L_L94  L_L183  0.0015
K_K17310  L_L94  L_L184  0.0016
K_K17311  L_L94  L_L185  0.0016
K_K17312  L_L94  L_L186  0.0016
K_K17313  L_L94  L_L187  0.0017
K_K17314  L_L94  L_L188  0.0017
K_K17315  L_L94  L_L189  0.0018
K_K17316  L_L94  L_L190  0.0018
K_K17317  L_L94  L_L191  0.0018
K_K17318  L_L94  L_L192  0.0019
K_K17319  L_L94  L_L193  0.0019
K_K17320  L_L94  L_L194  0.0020
K_K17321  L_L94  L_L195  0.0020
K_K17322  L_L94  L_L196  0.0021
K_K17323  L_L94  L_L197  0.0022
K_K17324  L_L94  L_L198  0.0022
K_K17325  L_L94  L_L199  0.0023
K_K17326  L_L94  L_L200  0.0024
K_K17327  L_L94  L_L201  0.0024
K_K17328  L_L94  L_L202  0.0025
K_K17329  L_L94  L_L203  0.0026
K_K17330  L_L94  L_L204  0.0027
K_K17331  L_L94  L_L205  0.0028
K_K17332  L_L94  L_L206  0.0029
K_K17333  L_L94  L_L207  0.0030
K_K17334  L_L94  L_L208  0.0032
K_K17335  L_L94  L_L209  0.0033
K_K17336  L_L94  L_L210  0.0034
K_K17337  L_L94  L_L211  0.0036
K_K17338  L_L94  L_L212  0.0038
K_K17339  L_L94  L_L213  0.0040
K_K17340  L_L94  L_L214  0.0042
K_K17341  L_L94  L_L215  0.0045
K_K17342  L_L94  L_L216  0.0047
K_K17343  L_L94  L_L217  0.0051
K_K17344  L_L94  L_L218  0.0054
K_K17345  L_L94  L_L219  0.0058
K_K17346  L_L94  L_L220  0.0063
K_K17347  L_L94  L_L221  0.0069
K_K17348  L_L94  L_L222  0.0076
K_K17349  L_L94  L_L223  0.0084
K_K17350  L_L94  L_L224  0.0095
K_K17351  L_L94  L_L225  0.0109
K_K17352  L_L94  L_L226  0.0127
K_K17353  L_L94  L_L227  0.0152
K_K17354  L_L94  L_L228  0.0191
K_K17355  L_L94  L_L229  0.0256
K_K17356  L_L94  L_L230  0.0389
K_K17357  L_L94  L_L231  0.0812
K_K17358  L_L94  L_L232  0.1569
K_K17359  L_L94  L_L233  0.0812
K_K17360  L_L94  L_L234  0.0389
K_K17361  L_L94  L_L235  0.0256
K_K17362  L_L94  L_L236  0.0191
K_K17363  L_L94  L_L237  0.0152
K_K17364  L_L94  L_L238  0.0127
K_K17365  L_L94  L_L239  0.0109
K_K17366  L_L94  L_L240  0.0095
K_K17367  L_L94  L_L241  0.0084
K_K17368  L_L94  L_L242  0.0076
K_K17369  L_L94  L_L243  0.0069
K_K17370  L_L94  L_L244  0.0063
K_K17371  L_L94  L_L245  0.0058
K_K17372  L_L94  L_L246  0.0054
K_K17373  L_L94  L_L247  0.0051
K_K17374  L_L94  L_L248  0.0047
K_K17375  L_L94  L_L249  0.0045
K_K17376  L_L94  L_L250  0.0042
K_K17377  L_L94  L_L251  0.0040
K_K17378  L_L94  L_L252  0.0038
K_K17379  L_L94  L_L253  0.0036
K_K17380  L_L94  L_L254  0.0034
K_K17381  L_L94  L_L255  0.0033
K_K17382  L_L94  L_L256  0.0032
K_K17383  L_L94  L_L257  0.0030
K_K17384  L_L94  L_L258  0.0029
K_K17385  L_L94  L_L259  0.0028
K_K17386  L_L94  L_L260  0.0027
K_K17387  L_L94  L_L261  0.0026
K_K17388  L_L94  L_L262  0.0025
K_K17389  L_L94  L_L263  0.0024
K_K17390  L_L94  L_L264  0.0024
K_K17391  L_L94  L_L265  0.0023
K_K17392  L_L94  L_L266  0.0022
K_K17393  L_L94  L_L267  0.0022
K_K17394  L_L94  L_L268  0.0021
K_K17395  L_L94  L_L269  0.0020
K_K17396  L_L94  L_L270  0.0020
K_K17397  L_L94  L_L271  0.0019
K_K17398  L_L94  L_L272  0.0019
K_K17399  L_L94  L_L273  0.0018
K_K17400  L_L94  L_L274  0.0018
K_K17401  L_L94  L_L275  0.0018
K_K17402  L_L94  L_L276  0.0017
* *  Branch  NTMP0000000094 - NTMP0000000095
R_R95  NTMP0000000094  nU_95  32.914993m  TC=0,0
V_Ui95  nU_95  nR_95  STIMULUS=U_IND_0000000095
R_V189  nR_95  nV_189  23.280268m  TC=0,0
L_V189  nR_95  nV_189  0.014646uH
R_V190  nV_189  nV_190  7.852787m  TC=0,0
L_V190  nV_189  nV_190  0.073723uH
L_L95  nV_190  NTMP0000000095  6.519695uH
K_K17403  L_L95  L_L96  0.1050
K_K17404  L_L95  L_L97  0.0397
K_K17405  L_L95  L_L98  0.0258
K_K17406  L_L95  L_L99  0.0192
K_K17407  L_L95  L_L100  0.0153
K_K17408  L_L95  L_L101  0.0127
K_K17409  L_L95  L_L102  0.0109
K_K17410  L_L95  L_L103  0.0095
K_K17411  L_L95  L_L104  0.0084
K_K17412  L_L95  L_L105  0.0076
K_K17413  L_L95  L_L106  0.0069
K_K17414  L_L95  L_L107  0.0063
K_K17415  L_L95  L_L108  0.0058
K_K17416  L_L95  L_L109  0.0054
K_K17417  L_L95  L_L110  0.0051
K_K17418  L_L95  L_L111  0.0047
K_K17419  L_L95  L_L112  0.0045
K_K17420  L_L95  L_L113  0.0042
K_K17421  L_L95  L_L114  0.0040
K_K17422  L_L95  L_L115  0.0038
K_K17423  L_L95  L_L116  0.0036
K_K17424  L_L95  L_L117  0.0034
K_K17425  L_L95  L_L118  0.0033
K_K17426  L_L95  L_L119  0.0032
K_K17427  L_L95  L_L120  0.0030
K_K17428  L_L95  L_L121  0.0029
K_K17429  L_L95  L_L122  0.0028
K_K17430  L_L95  L_L123  0.0027
K_K17431  L_L95  L_L124  0.0026
K_K17432  L_L95  L_L125  0.0025
K_K17433  L_L95  L_L126  0.0024
K_K17434  L_L95  L_L127  0.0024
K_K17435  L_L95  L_L128  0.0023
K_K17436  L_L95  L_L129  0.0022
K_K17437  L_L95  L_L130  0.0022
K_K17438  L_L95  L_L131  0.0021
K_K17439  L_L95  L_L132  0.0020
K_K17440  L_L95  L_L133  0.0020
K_K17441  L_L95  L_L134  0.0019
K_K17442  L_L95  L_L135  0.0019
K_K17443  L_L95  L_L136  0.0019
K_K17444  L_L95  L_L137  0.0018
K_K17445  L_L95  L_L138  0.0018
K_K17446  L_L95  L_L158  0.0010
K_K17447  L_L95  L_L159  0.0010
K_K17448  L_L95  L_L160  0.0010
K_K17449  L_L95  L_L161  0.0011
K_K17450  L_L95  L_L162  0.0011
K_K17451  L_L95  L_L163  0.0011
K_K17452  L_L95  L_L164  0.0011
K_K17453  L_L95  L_L165  0.0011
K_K17454  L_L95  L_L166  0.0011
K_K17455  L_L95  L_L167  0.0011
K_K17456  L_L95  L_L168  0.0012
K_K17457  L_L95  L_L169  0.0012
K_K17458  L_L95  L_L170  0.0012
K_K17459  L_L95  L_L171  0.0012
K_K17460  L_L95  L_L172  0.0012
K_K17461  L_L95  L_L173  0.0013
K_K17462  L_L95  L_L174  0.0013
K_K17463  L_L95  L_L175  0.0013
K_K17464  L_L95  L_L176  0.0013
K_K17465  L_L95  L_L177  0.0014
K_K17466  L_L95  L_L178  0.0014
K_K17467  L_L95  L_L179  0.0014
K_K17468  L_L95  L_L180  0.0014
K_K17469  L_L95  L_L181  0.0015
K_K17470  L_L95  L_L182  0.0015
K_K17471  L_L95  L_L183  0.0015
K_K17472  L_L95  L_L184  0.0015
K_K17473  L_L95  L_L185  0.0016
K_K17474  L_L95  L_L186  0.0016
K_K17475  L_L95  L_L187  0.0016
K_K17476  L_L95  L_L188  0.0017
K_K17477  L_L95  L_L189  0.0017
K_K17478  L_L95  L_L190  0.0018
K_K17479  L_L95  L_L191  0.0018
K_K17480  L_L95  L_L192  0.0018
K_K17481  L_L95  L_L193  0.0019
K_K17482  L_L95  L_L194  0.0019
K_K17483  L_L95  L_L195  0.0020
K_K17484  L_L95  L_L196  0.0020
K_K17485  L_L95  L_L197  0.0021
K_K17486  L_L95  L_L198  0.0022
K_K17487  L_L95  L_L199  0.0022
K_K17488  L_L95  L_L200  0.0023
K_K17489  L_L95  L_L201  0.0024
K_K17490  L_L95  L_L202  0.0024
K_K17491  L_L95  L_L203  0.0025
K_K17492  L_L95  L_L204  0.0026
K_K17493  L_L95  L_L205  0.0027
K_K17494  L_L95  L_L206  0.0028
K_K17495  L_L95  L_L207  0.0029
K_K17496  L_L95  L_L208  0.0030
K_K17497  L_L95  L_L209  0.0032
K_K17498  L_L95  L_L210  0.0033
K_K17499  L_L95  L_L211  0.0034
K_K17500  L_L95  L_L212  0.0036
K_K17501  L_L95  L_L213  0.0038
K_K17502  L_L95  L_L214  0.0040
K_K17503  L_L95  L_L215  0.0042
K_K17504  L_L95  L_L216  0.0045
K_K17505  L_L95  L_L217  0.0047
K_K17506  L_L95  L_L218  0.0051
K_K17507  L_L95  L_L219  0.0054
K_K17508  L_L95  L_L220  0.0058
K_K17509  L_L95  L_L221  0.0063
K_K17510  L_L95  L_L222  0.0069
K_K17511  L_L95  L_L223  0.0076
K_K17512  L_L95  L_L224  0.0084
K_K17513  L_L95  L_L225  0.0095
K_K17514  L_L95  L_L226  0.0109
K_K17515  L_L95  L_L227  0.0127
K_K17516  L_L95  L_L228  0.0152
K_K17517  L_L95  L_L229  0.0191
K_K17518  L_L95  L_L230  0.0256
K_K17519  L_L95  L_L231  0.0389
K_K17520  L_L95  L_L232  0.0812
K_K17521  L_L95  L_L233  0.1569
K_K17522  L_L95  L_L234  0.0812
K_K17523  L_L95  L_L235  0.0389
K_K17524  L_L95  L_L236  0.0256
K_K17525  L_L95  L_L237  0.0191
K_K17526  L_L95  L_L238  0.0152
K_K17527  L_L95  L_L239  0.0127
K_K17528  L_L95  L_L240  0.0109
K_K17529  L_L95  L_L241  0.0095
K_K17530  L_L95  L_L242  0.0084
K_K17531  L_L95  L_L243  0.0076
K_K17532  L_L95  L_L244  0.0069
K_K17533  L_L95  L_L245  0.0063
K_K17534  L_L95  L_L246  0.0058
K_K17535  L_L95  L_L247  0.0054
K_K17536  L_L95  L_L248  0.0051
K_K17537  L_L95  L_L249  0.0047
K_K17538  L_L95  L_L250  0.0045
K_K17539  L_L95  L_L251  0.0042
K_K17540  L_L95  L_L252  0.0040
K_K17541  L_L95  L_L253  0.0038
K_K17542  L_L95  L_L254  0.0036
K_K17543  L_L95  L_L255  0.0034
K_K17544  L_L95  L_L256  0.0033
K_K17545  L_L95  L_L257  0.0032
K_K17546  L_L95  L_L258  0.0030
K_K17547  L_L95  L_L259  0.0029
K_K17548  L_L95  L_L260  0.0028
K_K17549  L_L95  L_L261  0.0027
K_K17550  L_L95  L_L262  0.0026
K_K17551  L_L95  L_L263  0.0025
K_K17552  L_L95  L_L264  0.0024
K_K17553  L_L95  L_L265  0.0024
K_K17554  L_L95  L_L266  0.0023
K_K17555  L_L95  L_L267  0.0022
K_K17556  L_L95  L_L268  0.0022
K_K17557  L_L95  L_L269  0.0021
K_K17558  L_L95  L_L270  0.0020
K_K17559  L_L95  L_L271  0.0020
K_K17560  L_L95  L_L272  0.0019
K_K17561  L_L95  L_L273  0.0019
K_K17562  L_L95  L_L274  0.0018
K_K17563  L_L95  L_L275  0.0018
K_K17564  L_L95  L_L276  0.0018
* *  Branch  NTMP0000000095 - NTMP0000000096
R_R96  NTMP0000000095  nU_96  32.914993m  TC=0,0
V_Ui96  nU_96  nR_96  STIMULUS=U_IND_0000000096
R_V191  nR_96  nV_191  23.280268m  TC=0,0
L_V191  nR_96  nV_191  0.014646uH
R_V192  nV_191  nV_192  7.852787m  TC=0,0
L_V192  nV_191  nV_192  0.073723uH
L_L96  nV_192  NTMP0000000096  6.519695uH
K_K17565  L_L96  L_L97  0.1050
K_K17566  L_L96  L_L98  0.0397
K_K17567  L_L96  L_L99  0.0258
K_K17568  L_L96  L_L100  0.0192
K_K17569  L_L96  L_L101  0.0153
K_K17570  L_L96  L_L102  0.0127
K_K17571  L_L96  L_L103  0.0109
K_K17572  L_L96  L_L104  0.0095
K_K17573  L_L96  L_L105  0.0084
K_K17574  L_L96  L_L106  0.0076
K_K17575  L_L96  L_L107  0.0069
K_K17576  L_L96  L_L108  0.0063
K_K17577  L_L96  L_L109  0.0058
K_K17578  L_L96  L_L110  0.0054
K_K17579  L_L96  L_L111  0.0051
K_K17580  L_L96  L_L112  0.0047
K_K17581  L_L96  L_L113  0.0045
K_K17582  L_L96  L_L114  0.0042
K_K17583  L_L96  L_L115  0.0040
K_K17584  L_L96  L_L116  0.0038
K_K17585  L_L96  L_L117  0.0036
K_K17586  L_L96  L_L118  0.0034
K_K17587  L_L96  L_L119  0.0033
K_K17588  L_L96  L_L120  0.0032
K_K17589  L_L96  L_L121  0.0030
K_K17590  L_L96  L_L122  0.0029
K_K17591  L_L96  L_L123  0.0028
K_K17592  L_L96  L_L124  0.0027
K_K17593  L_L96  L_L125  0.0026
K_K17594  L_L96  L_L126  0.0025
K_K17595  L_L96  L_L127  0.0024
K_K17596  L_L96  L_L128  0.0024
K_K17597  L_L96  L_L129  0.0023
K_K17598  L_L96  L_L130  0.0022
K_K17599  L_L96  L_L131  0.0022
K_K17600  L_L96  L_L132  0.0021
K_K17601  L_L96  L_L133  0.0020
K_K17602  L_L96  L_L134  0.0020
K_K17603  L_L96  L_L135  0.0019
K_K17604  L_L96  L_L136  0.0019
K_K17605  L_L96  L_L137  0.0019
K_K17606  L_L96  L_L138  0.0018
K_K17607  L_L96  L_L159  0.0010
K_K17608  L_L96  L_L160  0.0010
K_K17609  L_L96  L_L161  0.0010
K_K17610  L_L96  L_L162  0.0011
K_K17611  L_L96  L_L163  0.0011
K_K17612  L_L96  L_L164  0.0011
K_K17613  L_L96  L_L165  0.0011
K_K17614  L_L96  L_L166  0.0011
K_K17615  L_L96  L_L167  0.0011
K_K17616  L_L96  L_L168  0.0011
K_K17617  L_L96  L_L169  0.0012
K_K17618  L_L96  L_L170  0.0012
K_K17619  L_L96  L_L171  0.0012
K_K17620  L_L96  L_L172  0.0012
K_K17621  L_L96  L_L173  0.0012
K_K17622  L_L96  L_L174  0.0013
K_K17623  L_L96  L_L175  0.0013
K_K17624  L_L96  L_L176  0.0013
K_K17625  L_L96  L_L177  0.0013
K_K17626  L_L96  L_L178  0.0014
K_K17627  L_L96  L_L179  0.0014
K_K17628  L_L96  L_L180  0.0014
K_K17629  L_L96  L_L181  0.0014
K_K17630  L_L96  L_L182  0.0015
K_K17631  L_L96  L_L183  0.0015
K_K17632  L_L96  L_L184  0.0015
K_K17633  L_L96  L_L185  0.0015
K_K17634  L_L96  L_L186  0.0016
K_K17635  L_L96  L_L187  0.0016
K_K17636  L_L96  L_L188  0.0016
K_K17637  L_L96  L_L189  0.0017
K_K17638  L_L96  L_L190  0.0017
K_K17639  L_L96  L_L191  0.0018
K_K17640  L_L96  L_L192  0.0018
K_K17641  L_L96  L_L193  0.0018
K_K17642  L_L96  L_L194  0.0019
K_K17643  L_L96  L_L195  0.0019
K_K17644  L_L96  L_L196  0.0020
K_K17645  L_L96  L_L197  0.0020
K_K17646  L_L96  L_L198  0.0021
K_K17647  L_L96  L_L199  0.0022
K_K17648  L_L96  L_L200  0.0022
K_K17649  L_L96  L_L201  0.0023
K_K17650  L_L96  L_L202  0.0024
K_K17651  L_L96  L_L203  0.0024
K_K17652  L_L96  L_L204  0.0025
K_K17653  L_L96  L_L205  0.0026
K_K17654  L_L96  L_L206  0.0027
K_K17655  L_L96  L_L207  0.0028
K_K17656  L_L96  L_L208  0.0029
K_K17657  L_L96  L_L209  0.0030
K_K17658  L_L96  L_L210  0.0032
K_K17659  L_L96  L_L211  0.0033
K_K17660  L_L96  L_L212  0.0034
K_K17661  L_L96  L_L213  0.0036
K_K17662  L_L96  L_L214  0.0038
K_K17663  L_L96  L_L215  0.0040
K_K17664  L_L96  L_L216  0.0042
K_K17665  L_L96  L_L217  0.0045
K_K17666  L_L96  L_L218  0.0047
K_K17667  L_L96  L_L219  0.0051
K_K17668  L_L96  L_L220  0.0054
K_K17669  L_L96  L_L221  0.0058
K_K17670  L_L96  L_L222  0.0063
K_K17671  L_L96  L_L223  0.0069
K_K17672  L_L96  L_L224  0.0076
K_K17673  L_L96  L_L225  0.0084
K_K17674  L_L96  L_L226  0.0095
K_K17675  L_L96  L_L227  0.0109
K_K17676  L_L96  L_L228  0.0127
K_K17677  L_L96  L_L229  0.0152
K_K17678  L_L96  L_L230  0.0191
K_K17679  L_L96  L_L231  0.0256
K_K17680  L_L96  L_L232  0.0389
K_K17681  L_L96  L_L233  0.0812
K_K17682  L_L96  L_L234  0.1569
K_K17683  L_L96  L_L235  0.0812
K_K17684  L_L96  L_L236  0.0389
K_K17685  L_L96  L_L237  0.0256
K_K17686  L_L96  L_L238  0.0191
K_K17687  L_L96  L_L239  0.0152
K_K17688  L_L96  L_L240  0.0127
K_K17689  L_L96  L_L241  0.0109
K_K17690  L_L96  L_L242  0.0095
K_K17691  L_L96  L_L243  0.0084
K_K17692  L_L96  L_L244  0.0076
K_K17693  L_L96  L_L245  0.0069
K_K17694  L_L96  L_L246  0.0063
K_K17695  L_L96  L_L247  0.0058
K_K17696  L_L96  L_L248  0.0054
K_K17697  L_L96  L_L249  0.0051
K_K17698  L_L96  L_L250  0.0047
K_K17699  L_L96  L_L251  0.0045
K_K17700  L_L96  L_L252  0.0042
K_K17701  L_L96  L_L253  0.0040
K_K17702  L_L96  L_L254  0.0038
K_K17703  L_L96  L_L255  0.0036
K_K17704  L_L96  L_L256  0.0034
K_K17705  L_L96  L_L257  0.0033
K_K17706  L_L96  L_L258  0.0032
K_K17707  L_L96  L_L259  0.0030
K_K17708  L_L96  L_L260  0.0029
K_K17709  L_L96  L_L261  0.0028
K_K17710  L_L96  L_L262  0.0027
K_K17711  L_L96  L_L263  0.0026
K_K17712  L_L96  L_L264  0.0025
K_K17713  L_L96  L_L265  0.0024
K_K17714  L_L96  L_L266  0.0024
K_K17715  L_L96  L_L267  0.0023
K_K17716  L_L96  L_L268  0.0022
K_K17717  L_L96  L_L269  0.0022
K_K17718  L_L96  L_L270  0.0021
K_K17719  L_L96  L_L271  0.0020
K_K17720  L_L96  L_L272  0.0020
K_K17721  L_L96  L_L273  0.0019
K_K17722  L_L96  L_L274  0.0019
K_K17723  L_L96  L_L275  0.0018
K_K17724  L_L96  L_L276  0.0018
* *  Branch  NTMP0000000096 - NTMP0000000097
R_R97  NTMP0000000096  nU_97  32.914993m  TC=0,0
V_Ui97  nU_97  nR_97  STIMULUS=U_IND_0000000097
R_V193  nR_97  nV_193  23.280268m  TC=0,0
L_V193  nR_97  nV_193  0.014646uH
R_V194  nV_193  nV_194  7.852787m  TC=0,0
L_V194  nV_193  nV_194  0.073723uH
L_L97  nV_194  NTMP0000000097  6.519695uH
K_K17725  L_L97  L_L98  0.1050
K_K17726  L_L97  L_L99  0.0397
K_K17727  L_L97  L_L100  0.0258
K_K17728  L_L97  L_L101  0.0192
K_K17729  L_L97  L_L102  0.0153
K_K17730  L_L97  L_L103  0.0127
K_K17731  L_L97  L_L104  0.0109
K_K17732  L_L97  L_L105  0.0095
K_K17733  L_L97  L_L106  0.0084
K_K17734  L_L97  L_L107  0.0076
K_K17735  L_L97  L_L108  0.0069
K_K17736  L_L97  L_L109  0.0063
K_K17737  L_L97  L_L110  0.0058
K_K17738  L_L97  L_L111  0.0054
K_K17739  L_L97  L_L112  0.0051
K_K17740  L_L97  L_L113  0.0047
K_K17741  L_L97  L_L114  0.0045
K_K17742  L_L97  L_L115  0.0042
K_K17743  L_L97  L_L116  0.0040
K_K17744  L_L97  L_L117  0.0038
K_K17745  L_L97  L_L118  0.0036
K_K17746  L_L97  L_L119  0.0034
K_K17747  L_L97  L_L120  0.0033
K_K17748  L_L97  L_L121  0.0032
K_K17749  L_L97  L_L122  0.0030
K_K17750  L_L97  L_L123  0.0029
K_K17751  L_L97  L_L124  0.0028
K_K17752  L_L97  L_L125  0.0027
K_K17753  L_L97  L_L126  0.0026
K_K17754  L_L97  L_L127  0.0025
K_K17755  L_L97  L_L128  0.0024
K_K17756  L_L97  L_L129  0.0024
K_K17757  L_L97  L_L130  0.0023
K_K17758  L_L97  L_L131  0.0022
K_K17759  L_L97  L_L132  0.0022
K_K17760  L_L97  L_L133  0.0021
K_K17761  L_L97  L_L134  0.0020
K_K17762  L_L97  L_L135  0.0020
K_K17763  L_L97  L_L136  0.0019
K_K17764  L_L97  L_L137  0.0019
K_K17765  L_L97  L_L138  0.0019
K_K17766  L_L97  L_L160  0.0010
K_K17767  L_L97  L_L161  0.0010
K_K17768  L_L97  L_L162  0.0010
K_K17769  L_L97  L_L163  0.0011
K_K17770  L_L97  L_L164  0.0011
K_K17771  L_L97  L_L165  0.0011
K_K17772  L_L97  L_L166  0.0011
K_K17773  L_L97  L_L167  0.0011
K_K17774  L_L97  L_L168  0.0011
K_K17775  L_L97  L_L169  0.0011
K_K17776  L_L97  L_L170  0.0012
K_K17777  L_L97  L_L171  0.0012
K_K17778  L_L97  L_L172  0.0012
K_K17779  L_L97  L_L173  0.0012
K_K17780  L_L97  L_L174  0.0012
K_K17781  L_L97  L_L175  0.0013
K_K17782  L_L97  L_L176  0.0013
K_K17783  L_L97  L_L177  0.0013
K_K17784  L_L97  L_L178  0.0013
K_K17785  L_L97  L_L179  0.0014
K_K17786  L_L97  L_L180  0.0014
K_K17787  L_L97  L_L181  0.0014
K_K17788  L_L97  L_L182  0.0014
K_K17789  L_L97  L_L183  0.0015
K_K17790  L_L97  L_L184  0.0015
K_K17791  L_L97  L_L185  0.0015
K_K17792  L_L97  L_L186  0.0015
K_K17793  L_L97  L_L187  0.0016
K_K17794  L_L97  L_L188  0.0016
K_K17795  L_L97  L_L189  0.0016
K_K17796  L_L97  L_L190  0.0017
K_K17797  L_L97  L_L191  0.0017
K_K17798  L_L97  L_L192  0.0018
K_K17799  L_L97  L_L193  0.0018
K_K17800  L_L97  L_L194  0.0018
K_K17801  L_L97  L_L195  0.0019
K_K17802  L_L97  L_L196  0.0019
K_K17803  L_L97  L_L197  0.0020
K_K17804  L_L97  L_L198  0.0020
K_K17805  L_L97  L_L199  0.0021
K_K17806  L_L97  L_L200  0.0022
K_K17807  L_L97  L_L201  0.0022
K_K17808  L_L97  L_L202  0.0023
K_K17809  L_L97  L_L203  0.0024
K_K17810  L_L97  L_L204  0.0024
K_K17811  L_L97  L_L205  0.0025
K_K17812  L_L97  L_L206  0.0026
K_K17813  L_L97  L_L207  0.0027
K_K17814  L_L97  L_L208  0.0028
K_K17815  L_L97  L_L209  0.0029
K_K17816  L_L97  L_L210  0.0030
K_K17817  L_L97  L_L211  0.0032
K_K17818  L_L97  L_L212  0.0033
K_K17819  L_L97  L_L213  0.0034
K_K17820  L_L97  L_L214  0.0036
K_K17821  L_L97  L_L215  0.0038
K_K17822  L_L97  L_L216  0.0040
K_K17823  L_L97  L_L217  0.0042
K_K17824  L_L97  L_L218  0.0045
K_K17825  L_L97  L_L219  0.0047
K_K17826  L_L97  L_L220  0.0051
K_K17827  L_L97  L_L221  0.0054
K_K17828  L_L97  L_L222  0.0058
K_K17829  L_L97  L_L223  0.0063
K_K17830  L_L97  L_L224  0.0069
K_K17831  L_L97  L_L225  0.0076
K_K17832  L_L97  L_L226  0.0084
K_K17833  L_L97  L_L227  0.0095
K_K17834  L_L97  L_L228  0.0109
K_K17835  L_L97  L_L229  0.0127
K_K17836  L_L97  L_L230  0.0152
K_K17837  L_L97  L_L231  0.0191
K_K17838  L_L97  L_L232  0.0256
K_K17839  L_L97  L_L233  0.0389
K_K17840  L_L97  L_L234  0.0812
K_K17841  L_L97  L_L235  0.1569
K_K17842  L_L97  L_L236  0.0812
K_K17843  L_L97  L_L237  0.0389
K_K17844  L_L97  L_L238  0.0256
K_K17845  L_L97  L_L239  0.0191
K_K17846  L_L97  L_L240  0.0152
K_K17847  L_L97  L_L241  0.0127
K_K17848  L_L97  L_L242  0.0109
K_K17849  L_L97  L_L243  0.0095
K_K17850  L_L97  L_L244  0.0084
K_K17851  L_L97  L_L245  0.0076
K_K17852  L_L97  L_L246  0.0069
K_K17853  L_L97  L_L247  0.0063
K_K17854  L_L97  L_L248  0.0058
K_K17855  L_L97  L_L249  0.0054
K_K17856  L_L97  L_L250  0.0051
K_K17857  L_L97  L_L251  0.0047
K_K17858  L_L97  L_L252  0.0045
K_K17859  L_L97  L_L253  0.0042
K_K17860  L_L97  L_L254  0.0040
K_K17861  L_L97  L_L255  0.0038
K_K17862  L_L97  L_L256  0.0036
K_K17863  L_L97  L_L257  0.0034
K_K17864  L_L97  L_L258  0.0033
K_K17865  L_L97  L_L259  0.0032
K_K17866  L_L97  L_L260  0.0030
K_K17867  L_L97  L_L261  0.0029
K_K17868  L_L97  L_L262  0.0028
K_K17869  L_L97  L_L263  0.0027
K_K17870  L_L97  L_L264  0.0026
K_K17871  L_L97  L_L265  0.0025
K_K17872  L_L97  L_L266  0.0024
K_K17873  L_L97  L_L267  0.0024
K_K17874  L_L97  L_L268  0.0023
K_K17875  L_L97  L_L269  0.0022
K_K17876  L_L97  L_L270  0.0022
K_K17877  L_L97  L_L271  0.0021
K_K17878  L_L97  L_L272  0.0020
K_K17879  L_L97  L_L273  0.0020
K_K17880  L_L97  L_L274  0.0019
K_K17881  L_L97  L_L275  0.0019
K_K17882  L_L97  L_L276  0.0018
* *  Branch  NTMP0000000097 - NTMP0000000098
R_R98  NTMP0000000097  nU_98  32.914993m  TC=0,0
V_Ui98  nU_98  nR_98  STIMULUS=U_IND_0000000098
R_V195  nR_98  nV_195  23.280268m  TC=0,0
L_V195  nR_98  nV_195  0.014646uH
R_V196  nV_195  nV_196  7.852787m  TC=0,0
L_V196  nV_195  nV_196  0.073723uH
L_L98  nV_196  NTMP0000000098  6.519695uH
K_K17883  L_L98  L_L99  0.1050
K_K17884  L_L98  L_L100  0.0397
K_K17885  L_L98  L_L101  0.0258
K_K17886  L_L98  L_L102  0.0192
K_K17887  L_L98  L_L103  0.0153
K_K17888  L_L98  L_L104  0.0127
K_K17889  L_L98  L_L105  0.0109
K_K17890  L_L98  L_L106  0.0095
K_K17891  L_L98  L_L107  0.0084
K_K17892  L_L98  L_L108  0.0076
K_K17893  L_L98  L_L109  0.0069
K_K17894  L_L98  L_L110  0.0063
K_K17895  L_L98  L_L111  0.0058
K_K17896  L_L98  L_L112  0.0054
K_K17897  L_L98  L_L113  0.0051
K_K17898  L_L98  L_L114  0.0047
K_K17899  L_L98  L_L115  0.0045
K_K17900  L_L98  L_L116  0.0042
K_K17901  L_L98  L_L117  0.0040
K_K17902  L_L98  L_L118  0.0038
K_K17903  L_L98  L_L119  0.0036
K_K17904  L_L98  L_L120  0.0034
K_K17905  L_L98  L_L121  0.0033
K_K17906  L_L98  L_L122  0.0032
K_K17907  L_L98  L_L123  0.0030
K_K17908  L_L98  L_L124  0.0029
K_K17909  L_L98  L_L125  0.0028
K_K17910  L_L98  L_L126  0.0027
K_K17911  L_L98  L_L127  0.0026
K_K17912  L_L98  L_L128  0.0025
K_K17913  L_L98  L_L129  0.0024
K_K17914  L_L98  L_L130  0.0024
K_K17915  L_L98  L_L131  0.0023
K_K17916  L_L98  L_L132  0.0022
K_K17917  L_L98  L_L133  0.0022
K_K17918  L_L98  L_L134  0.0021
K_K17919  L_L98  L_L135  0.0020
K_K17920  L_L98  L_L136  0.0020
K_K17921  L_L98  L_L137  0.0019
K_K17922  L_L98  L_L138  0.0019
K_K17923  L_L98  L_L161  0.0010
K_K17924  L_L98  L_L162  0.0010
K_K17925  L_L98  L_L163  0.0010
K_K17926  L_L98  L_L164  0.0011
K_K17927  L_L98  L_L165  0.0011
K_K17928  L_L98  L_L166  0.0011
K_K17929  L_L98  L_L167  0.0011
K_K17930  L_L98  L_L168  0.0011
K_K17931  L_L98  L_L169  0.0011
K_K17932  L_L98  L_L170  0.0011
K_K17933  L_L98  L_L171  0.0012
K_K17934  L_L98  L_L172  0.0012
K_K17935  L_L98  L_L173  0.0012
K_K17936  L_L98  L_L174  0.0012
K_K17937  L_L98  L_L175  0.0012
K_K17938  L_L98  L_L176  0.0013
K_K17939  L_L98  L_L177  0.0013
K_K17940  L_L98  L_L178  0.0013
K_K17941  L_L98  L_L179  0.0013
K_K17942  L_L98  L_L180  0.0014
K_K17943  L_L98  L_L181  0.0014
K_K17944  L_L98  L_L182  0.0014
K_K17945  L_L98  L_L183  0.0014
K_K17946  L_L98  L_L184  0.0015
K_K17947  L_L98  L_L185  0.0015
K_K17948  L_L98  L_L186  0.0015
K_K17949  L_L98  L_L187  0.0015
K_K17950  L_L98  L_L188  0.0016
K_K17951  L_L98  L_L189  0.0016
K_K17952  L_L98  L_L190  0.0016
K_K17953  L_L98  L_L191  0.0017
K_K17954  L_L98  L_L192  0.0017
K_K17955  L_L98  L_L193  0.0018
K_K17956  L_L98  L_L194  0.0018
K_K17957  L_L98  L_L195  0.0018
K_K17958  L_L98  L_L196  0.0019
K_K17959  L_L98  L_L197  0.0019
K_K17960  L_L98  L_L198  0.0020
K_K17961  L_L98  L_L199  0.0020
K_K17962  L_L98  L_L200  0.0021
K_K17963  L_L98  L_L201  0.0022
K_K17964  L_L98  L_L202  0.0022
K_K17965  L_L98  L_L203  0.0023
K_K17966  L_L98  L_L204  0.0024
K_K17967  L_L98  L_L205  0.0024
K_K17968  L_L98  L_L206  0.0025
K_K17969  L_L98  L_L207  0.0026
K_K17970  L_L98  L_L208  0.0027
K_K17971  L_L98  L_L209  0.0028
K_K17972  L_L98  L_L210  0.0029
K_K17973  L_L98  L_L211  0.0030
K_K17974  L_L98  L_L212  0.0032
K_K17975  L_L98  L_L213  0.0033
K_K17976  L_L98  L_L214  0.0034
K_K17977  L_L98  L_L215  0.0036
K_K17978  L_L98  L_L216  0.0038
K_K17979  L_L98  L_L217  0.0040
K_K17980  L_L98  L_L218  0.0042
K_K17981  L_L98  L_L219  0.0045
K_K17982  L_L98  L_L220  0.0047
K_K17983  L_L98  L_L221  0.0051
K_K17984  L_L98  L_L222  0.0054
K_K17985  L_L98  L_L223  0.0058
K_K17986  L_L98  L_L224  0.0063
K_K17987  L_L98  L_L225  0.0069
K_K17988  L_L98  L_L226  0.0076
K_K17989  L_L98  L_L227  0.0084
K_K17990  L_L98  L_L228  0.0095
K_K17991  L_L98  L_L229  0.0109
K_K17992  L_L98  L_L230  0.0127
K_K17993  L_L98  L_L231  0.0152
K_K17994  L_L98  L_L232  0.0191
K_K17995  L_L98  L_L233  0.0256
K_K17996  L_L98  L_L234  0.0389
K_K17997  L_L98  L_L235  0.0812
K_K17998  L_L98  L_L236  0.1569
K_K17999  L_L98  L_L237  0.0812
K_K18000  L_L98  L_L238  0.0389
K_K18001  L_L98  L_L239  0.0256
K_K18002  L_L98  L_L240  0.0191
K_K18003  L_L98  L_L241  0.0152
K_K18004  L_L98  L_L242  0.0127
K_K18005  L_L98  L_L243  0.0109
K_K18006  L_L98  L_L244  0.0095
K_K18007  L_L98  L_L245  0.0084
K_K18008  L_L98  L_L246  0.0076
K_K18009  L_L98  L_L247  0.0069
K_K18010  L_L98  L_L248  0.0063
K_K18011  L_L98  L_L249  0.0058
K_K18012  L_L98  L_L250  0.0054
K_K18013  L_L98  L_L251  0.0051
K_K18014  L_L98  L_L252  0.0047
K_K18015  L_L98  L_L253  0.0045
K_K18016  L_L98  L_L254  0.0042
K_K18017  L_L98  L_L255  0.0040
K_K18018  L_L98  L_L256  0.0038
K_K18019  L_L98  L_L257  0.0036
K_K18020  L_L98  L_L258  0.0034
K_K18021  L_L98  L_L259  0.0033
K_K18022  L_L98  L_L260  0.0032
K_K18023  L_L98  L_L261  0.0030
K_K18024  L_L98  L_L262  0.0029
K_K18025  L_L98  L_L263  0.0028
K_K18026  L_L98  L_L264  0.0027
K_K18027  L_L98  L_L265  0.0026
K_K18028  L_L98  L_L266  0.0025
K_K18029  L_L98  L_L267  0.0024
K_K18030  L_L98  L_L268  0.0024
K_K18031  L_L98  L_L269  0.0023
K_K18032  L_L98  L_L270  0.0022
K_K18033  L_L98  L_L271  0.0022
K_K18034  L_L98  L_L272  0.0021
K_K18035  L_L98  L_L273  0.0020
K_K18036  L_L98  L_L274  0.0020
K_K18037  L_L98  L_L275  0.0019
K_K18038  L_L98  L_L276  0.0019
* *  Branch  NTMP0000000098 - NTMP0000000099
R_R99  NTMP0000000098  nU_99  32.914993m  TC=0,0
V_Ui99  nU_99  nR_99  STIMULUS=U_IND_0000000099
R_V197  nR_99  nV_197  23.280268m  TC=0,0
L_V197  nR_99  nV_197  0.014646uH
R_V198  nV_197  nV_198  7.852787m  TC=0,0
L_V198  nV_197  nV_198  0.073723uH
L_L99  nV_198  NTMP0000000099  6.519695uH
K_K18039  L_L99  L_L100  0.1050
K_K18040  L_L99  L_L101  0.0397
K_K18041  L_L99  L_L102  0.0258
K_K18042  L_L99  L_L103  0.0192
K_K18043  L_L99  L_L104  0.0153
K_K18044  L_L99  L_L105  0.0127
K_K18045  L_L99  L_L106  0.0109
K_K18046  L_L99  L_L107  0.0095
K_K18047  L_L99  L_L108  0.0084
K_K18048  L_L99  L_L109  0.0076
K_K18049  L_L99  L_L110  0.0069
K_K18050  L_L99  L_L111  0.0063
K_K18051  L_L99  L_L112  0.0058
K_K18052  L_L99  L_L113  0.0054
K_K18053  L_L99  L_L114  0.0051
K_K18054  L_L99  L_L115  0.0047
K_K18055  L_L99  L_L116  0.0045
K_K18056  L_L99  L_L117  0.0042
K_K18057  L_L99  L_L118  0.0040
K_K18058  L_L99  L_L119  0.0038
K_K18059  L_L99  L_L120  0.0036
K_K18060  L_L99  L_L121  0.0034
K_K18061  L_L99  L_L122  0.0033
K_K18062  L_L99  L_L123  0.0032
K_K18063  L_L99  L_L124  0.0030
K_K18064  L_L99  L_L125  0.0029
K_K18065  L_L99  L_L126  0.0028
K_K18066  L_L99  L_L127  0.0027
K_K18067  L_L99  L_L128  0.0026
K_K18068  L_L99  L_L129  0.0025
K_K18069  L_L99  L_L130  0.0024
K_K18070  L_L99  L_L131  0.0024
K_K18071  L_L99  L_L132  0.0023
K_K18072  L_L99  L_L133  0.0022
K_K18073  L_L99  L_L134  0.0022
K_K18074  L_L99  L_L135  0.0021
K_K18075  L_L99  L_L136  0.0020
K_K18076  L_L99  L_L137  0.0020
K_K18077  L_L99  L_L138  0.0019
K_K18078  L_L99  L_L162  0.0010
K_K18079  L_L99  L_L163  0.0010
K_K18080  L_L99  L_L164  0.0010
K_K18081  L_L99  L_L165  0.0011
K_K18082  L_L99  L_L166  0.0011
K_K18083  L_L99  L_L167  0.0011
K_K18084  L_L99  L_L168  0.0011
K_K18085  L_L99  L_L169  0.0011
K_K18086  L_L99  L_L170  0.0011
K_K18087  L_L99  L_L171  0.0011
K_K18088  L_L99  L_L172  0.0012
K_K18089  L_L99  L_L173  0.0012
K_K18090  L_L99  L_L174  0.0012
K_K18091  L_L99  L_L175  0.0012
K_K18092  L_L99  L_L176  0.0012
K_K18093  L_L99  L_L177  0.0013
K_K18094  L_L99  L_L178  0.0013
K_K18095  L_L99  L_L179  0.0013
K_K18096  L_L99  L_L180  0.0013
K_K18097  L_L99  L_L181  0.0014
K_K18098  L_L99  L_L182  0.0014
K_K18099  L_L99  L_L183  0.0014
K_K18100  L_L99  L_L184  0.0014
K_K18101  L_L99  L_L185  0.0015
K_K18102  L_L99  L_L186  0.0015
K_K18103  L_L99  L_L187  0.0015
K_K18104  L_L99  L_L188  0.0015
K_K18105  L_L99  L_L189  0.0016
K_K18106  L_L99  L_L190  0.0016
K_K18107  L_L99  L_L191  0.0016
K_K18108  L_L99  L_L192  0.0017
K_K18109  L_L99  L_L193  0.0017
K_K18110  L_L99  L_L194  0.0018
K_K18111  L_L99  L_L195  0.0018
K_K18112  L_L99  L_L196  0.0018
K_K18113  L_L99  L_L197  0.0019
K_K18114  L_L99  L_L198  0.0019
K_K18115  L_L99  L_L199  0.0020
K_K18116  L_L99  L_L200  0.0020
K_K18117  L_L99  L_L201  0.0021
K_K18118  L_L99  L_L202  0.0022
K_K18119  L_L99  L_L203  0.0022
K_K18120  L_L99  L_L204  0.0023
K_K18121  L_L99  L_L205  0.0024
K_K18122  L_L99  L_L206  0.0024
K_K18123  L_L99  L_L207  0.0025
K_K18124  L_L99  L_L208  0.0026
K_K18125  L_L99  L_L209  0.0027
K_K18126  L_L99  L_L210  0.0028
K_K18127  L_L99  L_L211  0.0029
K_K18128  L_L99  L_L212  0.0030
K_K18129  L_L99  L_L213  0.0032
K_K18130  L_L99  L_L214  0.0033
K_K18131  L_L99  L_L215  0.0034
K_K18132  L_L99  L_L216  0.0036
K_K18133  L_L99  L_L217  0.0038
K_K18134  L_L99  L_L218  0.0040
K_K18135  L_L99  L_L219  0.0042
K_K18136  L_L99  L_L220  0.0045
K_K18137  L_L99  L_L221  0.0047
K_K18138  L_L99  L_L222  0.0051
K_K18139  L_L99  L_L223  0.0054
K_K18140  L_L99  L_L224  0.0058
K_K18141  L_L99  L_L225  0.0063
K_K18142  L_L99  L_L226  0.0069
K_K18143  L_L99  L_L227  0.0076
K_K18144  L_L99  L_L228  0.0084
K_K18145  L_L99  L_L229  0.0095
K_K18146  L_L99  L_L230  0.0109
K_K18147  L_L99  L_L231  0.0127
K_K18148  L_L99  L_L232  0.0152
K_K18149  L_L99  L_L233  0.0191
K_K18150  L_L99  L_L234  0.0256
K_K18151  L_L99  L_L235  0.0389
K_K18152  L_L99  L_L236  0.0812
K_K18153  L_L99  L_L237  0.1569
K_K18154  L_L99  L_L238  0.0812
K_K18155  L_L99  L_L239  0.0389
K_K18156  L_L99  L_L240  0.0256
K_K18157  L_L99  L_L241  0.0191
K_K18158  L_L99  L_L242  0.0152
K_K18159  L_L99  L_L243  0.0127
K_K18160  L_L99  L_L244  0.0109
K_K18161  L_L99  L_L245  0.0095
K_K18162  L_L99  L_L246  0.0084
K_K18163  L_L99  L_L247  0.0076
K_K18164  L_L99  L_L248  0.0069
K_K18165  L_L99  L_L249  0.0063
K_K18166  L_L99  L_L250  0.0058
K_K18167  L_L99  L_L251  0.0054
K_K18168  L_L99  L_L252  0.0051
K_K18169  L_L99  L_L253  0.0047
K_K18170  L_L99  L_L254  0.0045
K_K18171  L_L99  L_L255  0.0042
K_K18172  L_L99  L_L256  0.0040
K_K18173  L_L99  L_L257  0.0038
K_K18174  L_L99  L_L258  0.0036
K_K18175  L_L99  L_L259  0.0034
K_K18176  L_L99  L_L260  0.0033
K_K18177  L_L99  L_L261  0.0032
K_K18178  L_L99  L_L262  0.0030
K_K18179  L_L99  L_L263  0.0029
K_K18180  L_L99  L_L264  0.0028
K_K18181  L_L99  L_L265  0.0027
K_K18182  L_L99  L_L266  0.0026
K_K18183  L_L99  L_L267  0.0025
K_K18184  L_L99  L_L268  0.0024
K_K18185  L_L99  L_L269  0.0024
K_K18186  L_L99  L_L270  0.0023
K_K18187  L_L99  L_L271  0.0022
K_K18188  L_L99  L_L272  0.0022
K_K18189  L_L99  L_L273  0.0021
K_K18190  L_L99  L_L274  0.0020
K_K18191  L_L99  L_L275  0.0020
K_K18192  L_L99  L_L276  0.0019
* *  Branch  NTMP0000000099 - NTMP0000000100
R_R100  NTMP0000000099  nU_100  32.914993m  TC=0,0
V_Ui100  nU_100  nR_100  STIMULUS=U_IND_0000000100
R_V199  nR_100  nV_199  23.280268m  TC=0,0
L_V199  nR_100  nV_199  0.014646uH
R_V200  nV_199  nV_200  7.852787m  TC=0,0
L_V200  nV_199  nV_200  0.073723uH
L_L100  nV_200  NTMP0000000100  6.519695uH
K_K18193  L_L100  L_L101  0.1050
K_K18194  L_L100  L_L102  0.0397
K_K18195  L_L100  L_L103  0.0258
K_K18196  L_L100  L_L104  0.0192
K_K18197  L_L100  L_L105  0.0153
K_K18198  L_L100  L_L106  0.0127
K_K18199  L_L100  L_L107  0.0109
K_K18200  L_L100  L_L108  0.0095
K_K18201  L_L100  L_L109  0.0084
K_K18202  L_L100  L_L110  0.0076
K_K18203  L_L100  L_L111  0.0069
K_K18204  L_L100  L_L112  0.0063
K_K18205  L_L100  L_L113  0.0058
K_K18206  L_L100  L_L114  0.0054
K_K18207  L_L100  L_L115  0.0051
K_K18208  L_L100  L_L116  0.0047
K_K18209  L_L100  L_L117  0.0045
K_K18210  L_L100  L_L118  0.0042
K_K18211  L_L100  L_L119  0.0040
K_K18212  L_L100  L_L120  0.0038
K_K18213  L_L100  L_L121  0.0036
K_K18214  L_L100  L_L122  0.0034
K_K18215  L_L100  L_L123  0.0033
K_K18216  L_L100  L_L124  0.0032
K_K18217  L_L100  L_L125  0.0030
K_K18218  L_L100  L_L126  0.0029
K_K18219  L_L100  L_L127  0.0028
K_K18220  L_L100  L_L128  0.0027
K_K18221  L_L100  L_L129  0.0026
K_K18222  L_L100  L_L130  0.0025
K_K18223  L_L100  L_L131  0.0024
K_K18224  L_L100  L_L132  0.0024
K_K18225  L_L100  L_L133  0.0023
K_K18226  L_L100  L_L134  0.0022
K_K18227  L_L100  L_L135  0.0022
K_K18228  L_L100  L_L136  0.0021
K_K18229  L_L100  L_L137  0.0020
K_K18230  L_L100  L_L138  0.0020
K_K18231  L_L100  L_L163  0.0010
K_K18232  L_L100  L_L164  0.0010
K_K18233  L_L100  L_L165  0.0010
K_K18234  L_L100  L_L166  0.0011
K_K18235  L_L100  L_L167  0.0011
K_K18236  L_L100  L_L168  0.0011
K_K18237  L_L100  L_L169  0.0011
K_K18238  L_L100  L_L170  0.0011
K_K18239  L_L100  L_L171  0.0011
K_K18240  L_L100  L_L172  0.0011
K_K18241  L_L100  L_L173  0.0012
K_K18242  L_L100  L_L174  0.0012
K_K18243  L_L100  L_L175  0.0012
K_K18244  L_L100  L_L176  0.0012
K_K18245  L_L100  L_L177  0.0012
K_K18246  L_L100  L_L178  0.0013
K_K18247  L_L100  L_L179  0.0013
K_K18248  L_L100  L_L180  0.0013
K_K18249  L_L100  L_L181  0.0013
K_K18250  L_L100  L_L182  0.0014
K_K18251  L_L100  L_L183  0.0014
K_K18252  L_L100  L_L184  0.0014
K_K18253  L_L100  L_L185  0.0014
K_K18254  L_L100  L_L186  0.0015
K_K18255  L_L100  L_L187  0.0015
K_K18256  L_L100  L_L188  0.0015
K_K18257  L_L100  L_L189  0.0015
K_K18258  L_L100  L_L190  0.0016
K_K18259  L_L100  L_L191  0.0016
K_K18260  L_L100  L_L192  0.0016
K_K18261  L_L100  L_L193  0.0017
K_K18262  L_L100  L_L194  0.0017
K_K18263  L_L100  L_L195  0.0018
K_K18264  L_L100  L_L196  0.0018
K_K18265  L_L100  L_L197  0.0018
K_K18266  L_L100  L_L198  0.0019
K_K18267  L_L100  L_L199  0.0019
K_K18268  L_L100  L_L200  0.0020
K_K18269  L_L100  L_L201  0.0020
K_K18270  L_L100  L_L202  0.0021
K_K18271  L_L100  L_L203  0.0022
K_K18272  L_L100  L_L204  0.0022
K_K18273  L_L100  L_L205  0.0023
K_K18274  L_L100  L_L206  0.0024
K_K18275  L_L100  L_L207  0.0024
K_K18276  L_L100  L_L208  0.0025
K_K18277  L_L100  L_L209  0.0026
K_K18278  L_L100  L_L210  0.0027
K_K18279  L_L100  L_L211  0.0028
K_K18280  L_L100  L_L212  0.0029
K_K18281  L_L100  L_L213  0.0030
K_K18282  L_L100  L_L214  0.0032
K_K18283  L_L100  L_L215  0.0033
K_K18284  L_L100  L_L216  0.0034
K_K18285  L_L100  L_L217  0.0036
K_K18286  L_L100  L_L218  0.0038
K_K18287  L_L100  L_L219  0.0040
K_K18288  L_L100  L_L220  0.0042
K_K18289  L_L100  L_L221  0.0045
K_K18290  L_L100  L_L222  0.0047
K_K18291  L_L100  L_L223  0.0051
K_K18292  L_L100  L_L224  0.0054
K_K18293  L_L100  L_L225  0.0058
K_K18294  L_L100  L_L226  0.0063
K_K18295  L_L100  L_L227  0.0069
K_K18296  L_L100  L_L228  0.0076
K_K18297  L_L100  L_L229  0.0084
K_K18298  L_L100  L_L230  0.0095
K_K18299  L_L100  L_L231  0.0109
K_K18300  L_L100  L_L232  0.0127
K_K18301  L_L100  L_L233  0.0152
K_K18302  L_L100  L_L234  0.0191
K_K18303  L_L100  L_L235  0.0256
K_K18304  L_L100  L_L236  0.0389
K_K18305  L_L100  L_L237  0.0812
K_K18306  L_L100  L_L238  0.1569
K_K18307  L_L100  L_L239  0.0812
K_K18308  L_L100  L_L240  0.0389
K_K18309  L_L100  L_L241  0.0256
K_K18310  L_L100  L_L242  0.0191
K_K18311  L_L100  L_L243  0.0152
K_K18312  L_L100  L_L244  0.0127
K_K18313  L_L100  L_L245  0.0109
K_K18314  L_L100  L_L246  0.0095
K_K18315  L_L100  L_L247  0.0084
K_K18316  L_L100  L_L248  0.0076
K_K18317  L_L100  L_L249  0.0069
K_K18318  L_L100  L_L250  0.0063
K_K18319  L_L100  L_L251  0.0058
K_K18320  L_L100  L_L252  0.0054
K_K18321  L_L100  L_L253  0.0051
K_K18322  L_L100  L_L254  0.0047
K_K18323  L_L100  L_L255  0.0045
K_K18324  L_L100  L_L256  0.0042
K_K18325  L_L100  L_L257  0.0040
K_K18326  L_L100  L_L258  0.0038
K_K18327  L_L100  L_L259  0.0036
K_K18328  L_L100  L_L260  0.0034
K_K18329  L_L100  L_L261  0.0033
K_K18330  L_L100  L_L262  0.0032
K_K18331  L_L100  L_L263  0.0030
K_K18332  L_L100  L_L264  0.0029
K_K18333  L_L100  L_L265  0.0028
K_K18334  L_L100  L_L266  0.0027
K_K18335  L_L100  L_L267  0.0026
K_K18336  L_L100  L_L268  0.0025
K_K18337  L_L100  L_L269  0.0024
K_K18338  L_L100  L_L270  0.0024
K_K18339  L_L100  L_L271  0.0023
K_K18340  L_L100  L_L272  0.0022
K_K18341  L_L100  L_L273  0.0022
K_K18342  L_L100  L_L274  0.0021
K_K18343  L_L100  L_L275  0.0020
K_K18344  L_L100  L_L276  0.0020
* *  Branch  NTMP0000000100 - NTMP0000000101
R_R101  NTMP0000000100  nU_101  32.914993m  TC=0,0
V_Ui101  nU_101  nR_101  STIMULUS=U_IND_0000000101
R_V201  nR_101  nV_201  23.280268m  TC=0,0
L_V201  nR_101  nV_201  0.014646uH
R_V202  nV_201  nV_202  7.852787m  TC=0,0
L_V202  nV_201  nV_202  0.073723uH
L_L101  nV_202  NTMP0000000101  6.519695uH
K_K18345  L_L101  L_L102  0.1050
K_K18346  L_L101  L_L103  0.0397
K_K18347  L_L101  L_L104  0.0258
K_K18348  L_L101  L_L105  0.0192
K_K18349  L_L101  L_L106  0.0153
K_K18350  L_L101  L_L107  0.0127
K_K18351  L_L101  L_L108  0.0109
K_K18352  L_L101  L_L109  0.0095
K_K18353  L_L101  L_L110  0.0084
K_K18354  L_L101  L_L111  0.0076
K_K18355  L_L101  L_L112  0.0069
K_K18356  L_L101  L_L113  0.0063
K_K18357  L_L101  L_L114  0.0058
K_K18358  L_L101  L_L115  0.0054
K_K18359  L_L101  L_L116  0.0051
K_K18360  L_L101  L_L117  0.0047
K_K18361  L_L101  L_L118  0.0045
K_K18362  L_L101  L_L119  0.0042
K_K18363  L_L101  L_L120  0.0040
K_K18364  L_L101  L_L121  0.0038
K_K18365  L_L101  L_L122  0.0036
K_K18366  L_L101  L_L123  0.0034
K_K18367  L_L101  L_L124  0.0033
K_K18368  L_L101  L_L125  0.0032
K_K18369  L_L101  L_L126  0.0030
K_K18370  L_L101  L_L127  0.0029
K_K18371  L_L101  L_L128  0.0028
K_K18372  L_L101  L_L129  0.0027
K_K18373  L_L101  L_L130  0.0026
K_K18374  L_L101  L_L131  0.0025
K_K18375  L_L101  L_L132  0.0024
K_K18376  L_L101  L_L133  0.0024
K_K18377  L_L101  L_L134  0.0023
K_K18378  L_L101  L_L135  0.0022
K_K18379  L_L101  L_L136  0.0022
K_K18380  L_L101  L_L137  0.0021
K_K18381  L_L101  L_L138  0.0020
K_K18382  L_L101  L_L164  0.0010
K_K18383  L_L101  L_L165  0.0010
K_K18384  L_L101  L_L166  0.0010
K_K18385  L_L101  L_L167  0.0011
K_K18386  L_L101  L_L168  0.0011
K_K18387  L_L101  L_L169  0.0011
K_K18388  L_L101  L_L170  0.0011
K_K18389  L_L101  L_L171  0.0011
K_K18390  L_L101  L_L172  0.0011
K_K18391  L_L101  L_L173  0.0011
K_K18392  L_L101  L_L174  0.0012
K_K18393  L_L101  L_L175  0.0012
K_K18394  L_L101  L_L176  0.0012
K_K18395  L_L101  L_L177  0.0012
K_K18396  L_L101  L_L178  0.0012
K_K18397  L_L101  L_L179  0.0013
K_K18398  L_L101  L_L180  0.0013
K_K18399  L_L101  L_L181  0.0013
K_K18400  L_L101  L_L182  0.0013
K_K18401  L_L101  L_L183  0.0014
K_K18402  L_L101  L_L184  0.0014
K_K18403  L_L101  L_L185  0.0014
K_K18404  L_L101  L_L186  0.0014
K_K18405  L_L101  L_L187  0.0015
K_K18406  L_L101  L_L188  0.0015
K_K18407  L_L101  L_L189  0.0015
K_K18408  L_L101  L_L190  0.0015
K_K18409  L_L101  L_L191  0.0016
K_K18410  L_L101  L_L192  0.0016
K_K18411  L_L101  L_L193  0.0016
K_K18412  L_L101  L_L194  0.0017
K_K18413  L_L101  L_L195  0.0017
K_K18414  L_L101  L_L196  0.0018
K_K18415  L_L101  L_L197  0.0018
K_K18416  L_L101  L_L198  0.0018
K_K18417  L_L101  L_L199  0.0019
K_K18418  L_L101  L_L200  0.0019
K_K18419  L_L101  L_L201  0.0020
K_K18420  L_L101  L_L202  0.0020
K_K18421  L_L101  L_L203  0.0021
K_K18422  L_L101  L_L204  0.0022
K_K18423  L_L101  L_L205  0.0022
K_K18424  L_L101  L_L206  0.0023
K_K18425  L_L101  L_L207  0.0024
K_K18426  L_L101  L_L208  0.0024
K_K18427  L_L101  L_L209  0.0025
K_K18428  L_L101  L_L210  0.0026
K_K18429  L_L101  L_L211  0.0027
K_K18430  L_L101  L_L212  0.0028
K_K18431  L_L101  L_L213  0.0029
K_K18432  L_L101  L_L214  0.0030
K_K18433  L_L101  L_L215  0.0032
K_K18434  L_L101  L_L216  0.0033
K_K18435  L_L101  L_L217  0.0034
K_K18436  L_L101  L_L218  0.0036
K_K18437  L_L101  L_L219  0.0038
K_K18438  L_L101  L_L220  0.0040
K_K18439  L_L101  L_L221  0.0042
K_K18440  L_L101  L_L222  0.0045
K_K18441  L_L101  L_L223  0.0047
K_K18442  L_L101  L_L224  0.0051
K_K18443  L_L101  L_L225  0.0054
K_K18444  L_L101  L_L226  0.0058
K_K18445  L_L101  L_L227  0.0063
K_K18446  L_L101  L_L228  0.0069
K_K18447  L_L101  L_L229  0.0076
K_K18448  L_L101  L_L230  0.0084
K_K18449  L_L101  L_L231  0.0095
K_K18450  L_L101  L_L232  0.0109
K_K18451  L_L101  L_L233  0.0127
K_K18452  L_L101  L_L234  0.0152
K_K18453  L_L101  L_L235  0.0191
K_K18454  L_L101  L_L236  0.0256
K_K18455  L_L101  L_L237  0.0389
K_K18456  L_L101  L_L238  0.0812
K_K18457  L_L101  L_L239  0.1569
K_K18458  L_L101  L_L240  0.0812
K_K18459  L_L101  L_L241  0.0389
K_K18460  L_L101  L_L242  0.0256
K_K18461  L_L101  L_L243  0.0191
K_K18462  L_L101  L_L244  0.0152
K_K18463  L_L101  L_L245  0.0127
K_K18464  L_L101  L_L246  0.0109
K_K18465  L_L101  L_L247  0.0095
K_K18466  L_L101  L_L248  0.0084
K_K18467  L_L101  L_L249  0.0076
K_K18468  L_L101  L_L250  0.0069
K_K18469  L_L101  L_L251  0.0063
K_K18470  L_L101  L_L252  0.0058
K_K18471  L_L101  L_L253  0.0054
K_K18472  L_L101  L_L254  0.0051
K_K18473  L_L101  L_L255  0.0047
K_K18474  L_L101  L_L256  0.0045
K_K18475  L_L101  L_L257  0.0042
K_K18476  L_L101  L_L258  0.0040
K_K18477  L_L101  L_L259  0.0038
K_K18478  L_L101  L_L260  0.0036
K_K18479  L_L101  L_L261  0.0034
K_K18480  L_L101  L_L262  0.0033
K_K18481  L_L101  L_L263  0.0032
K_K18482  L_L101  L_L264  0.0030
K_K18483  L_L101  L_L265  0.0029
K_K18484  L_L101  L_L266  0.0028
K_K18485  L_L101  L_L267  0.0027
K_K18486  L_L101  L_L268  0.0026
K_K18487  L_L101  L_L269  0.0025
K_K18488  L_L101  L_L270  0.0024
K_K18489  L_L101  L_L271  0.0024
K_K18490  L_L101  L_L272  0.0023
K_K18491  L_L101  L_L273  0.0022
K_K18492  L_L101  L_L274  0.0022
K_K18493  L_L101  L_L275  0.0021
K_K18494  L_L101  L_L276  0.0020
* *  Branch  NTMP0000000101 - NTMP0000000102
R_R102  NTMP0000000101  nU_102  32.914993m  TC=0,0
V_Ui102  nU_102  nR_102  STIMULUS=U_IND_0000000102
R_V203  nR_102  nV_203  23.280268m  TC=0,0
L_V203  nR_102  nV_203  0.014646uH
R_V204  nV_203  nV_204  7.852787m  TC=0,0
L_V204  nV_203  nV_204  0.073723uH
L_L102  nV_204  NTMP0000000102  6.519695uH
K_K18495  L_L102  L_L103  0.1050
K_K18496  L_L102  L_L104  0.0397
K_K18497  L_L102  L_L105  0.0258
K_K18498  L_L102  L_L106  0.0192
K_K18499  L_L102  L_L107  0.0153
K_K18500  L_L102  L_L108  0.0127
K_K18501  L_L102  L_L109  0.0109
K_K18502  L_L102  L_L110  0.0095
K_K18503  L_L102  L_L111  0.0084
K_K18504  L_L102  L_L112  0.0076
K_K18505  L_L102  L_L113  0.0069
K_K18506  L_L102  L_L114  0.0063
K_K18507  L_L102  L_L115  0.0058
K_K18508  L_L102  L_L116  0.0054
K_K18509  L_L102  L_L117  0.0051
K_K18510  L_L102  L_L118  0.0047
K_K18511  L_L102  L_L119  0.0045
K_K18512  L_L102  L_L120  0.0042
K_K18513  L_L102  L_L121  0.0040
K_K18514  L_L102  L_L122  0.0038
K_K18515  L_L102  L_L123  0.0036
K_K18516  L_L102  L_L124  0.0034
K_K18517  L_L102  L_L125  0.0033
K_K18518  L_L102  L_L126  0.0032
K_K18519  L_L102  L_L127  0.0030
K_K18520  L_L102  L_L128  0.0029
K_K18521  L_L102  L_L129  0.0028
K_K18522  L_L102  L_L130  0.0027
K_K18523  L_L102  L_L131  0.0026
K_K18524  L_L102  L_L132  0.0025
K_K18525  L_L102  L_L133  0.0024
K_K18526  L_L102  L_L134  0.0024
K_K18527  L_L102  L_L135  0.0023
K_K18528  L_L102  L_L136  0.0022
K_K18529  L_L102  L_L137  0.0022
K_K18530  L_L102  L_L138  0.0021
K_K18531  L_L102  L_L165  0.0010
K_K18532  L_L102  L_L166  0.0010
K_K18533  L_L102  L_L167  0.0010
K_K18534  L_L102  L_L168  0.0011
K_K18535  L_L102  L_L169  0.0011
K_K18536  L_L102  L_L170  0.0011
K_K18537  L_L102  L_L171  0.0011
K_K18538  L_L102  L_L172  0.0011
K_K18539  L_L102  L_L173  0.0011
K_K18540  L_L102  L_L174  0.0011
K_K18541  L_L102  L_L175  0.0012
K_K18542  L_L102  L_L176  0.0012
K_K18543  L_L102  L_L177  0.0012
K_K18544  L_L102  L_L178  0.0012
K_K18545  L_L102  L_L179  0.0012
K_K18546  L_L102  L_L180  0.0013
K_K18547  L_L102  L_L181  0.0013
K_K18548  L_L102  L_L182  0.0013
K_K18549  L_L102  L_L183  0.0013
K_K18550  L_L102  L_L184  0.0014
K_K18551  L_L102  L_L185  0.0014
K_K18552  L_L102  L_L186  0.0014
K_K18553  L_L102  L_L187  0.0014
K_K18554  L_L102  L_L188  0.0015
K_K18555  L_L102  L_L189  0.0015
K_K18556  L_L102  L_L190  0.0015
K_K18557  L_L102  L_L191  0.0015
K_K18558  L_L102  L_L192  0.0016
K_K18559  L_L102  L_L193  0.0016
K_K18560  L_L102  L_L194  0.0016
K_K18561  L_L102  L_L195  0.0017
K_K18562  L_L102  L_L196  0.0017
K_K18563  L_L102  L_L197  0.0018
K_K18564  L_L102  L_L198  0.0018
K_K18565  L_L102  L_L199  0.0018
K_K18566  L_L102  L_L200  0.0019
K_K18567  L_L102  L_L201  0.0019
K_K18568  L_L102  L_L202  0.0020
K_K18569  L_L102  L_L203  0.0020
K_K18570  L_L102  L_L204  0.0021
K_K18571  L_L102  L_L205  0.0022
K_K18572  L_L102  L_L206  0.0022
K_K18573  L_L102  L_L207  0.0023
K_K18574  L_L102  L_L208  0.0024
K_K18575  L_L102  L_L209  0.0024
K_K18576  L_L102  L_L210  0.0025
K_K18577  L_L102  L_L211  0.0026
K_K18578  L_L102  L_L212  0.0027
K_K18579  L_L102  L_L213  0.0028
K_K18580  L_L102  L_L214  0.0029
K_K18581  L_L102  L_L215  0.0030
K_K18582  L_L102  L_L216  0.0032
K_K18583  L_L102  L_L217  0.0033
K_K18584  L_L102  L_L218  0.0034
K_K18585  L_L102  L_L219  0.0036
K_K18586  L_L102  L_L220  0.0038
K_K18587  L_L102  L_L221  0.0040
K_K18588  L_L102  L_L222  0.0042
K_K18589  L_L102  L_L223  0.0045
K_K18590  L_L102  L_L224  0.0047
K_K18591  L_L102  L_L225  0.0051
K_K18592  L_L102  L_L226  0.0054
K_K18593  L_L102  L_L227  0.0058
K_K18594  L_L102  L_L228  0.0063
K_K18595  L_L102  L_L229  0.0069
K_K18596  L_L102  L_L230  0.0076
K_K18597  L_L102  L_L231  0.0084
K_K18598  L_L102  L_L232  0.0095
K_K18599  L_L102  L_L233  0.0109
K_K18600  L_L102  L_L234  0.0127
K_K18601  L_L102  L_L235  0.0152
K_K18602  L_L102  L_L236  0.0191
K_K18603  L_L102  L_L237  0.0256
K_K18604  L_L102  L_L238  0.0389
K_K18605  L_L102  L_L239  0.0812
K_K18606  L_L102  L_L240  0.1569
K_K18607  L_L102  L_L241  0.0812
K_K18608  L_L102  L_L242  0.0389
K_K18609  L_L102  L_L243  0.0256
K_K18610  L_L102  L_L244  0.0191
K_K18611  L_L102  L_L245  0.0152
K_K18612  L_L102  L_L246  0.0127
K_K18613  L_L102  L_L247  0.0109
K_K18614  L_L102  L_L248  0.0095
K_K18615  L_L102  L_L249  0.0084
K_K18616  L_L102  L_L250  0.0076
K_K18617  L_L102  L_L251  0.0069
K_K18618  L_L102  L_L252  0.0063
K_K18619  L_L102  L_L253  0.0058
K_K18620  L_L102  L_L254  0.0054
K_K18621  L_L102  L_L255  0.0051
K_K18622  L_L102  L_L256  0.0047
K_K18623  L_L102  L_L257  0.0045
K_K18624  L_L102  L_L258  0.0042
K_K18625  L_L102  L_L259  0.0040
K_K18626  L_L102  L_L260  0.0038
K_K18627  L_L102  L_L261  0.0036
K_K18628  L_L102  L_L262  0.0034
K_K18629  L_L102  L_L263  0.0033
K_K18630  L_L102  L_L264  0.0032
K_K18631  L_L102  L_L265  0.0030
K_K18632  L_L102  L_L266  0.0029
K_K18633  L_L102  L_L267  0.0028
K_K18634  L_L102  L_L268  0.0027
K_K18635  L_L102  L_L269  0.0026
K_K18636  L_L102  L_L270  0.0025
K_K18637  L_L102  L_L271  0.0024
K_K18638  L_L102  L_L272  0.0024
K_K18639  L_L102  L_L273  0.0023
K_K18640  L_L102  L_L274  0.0022
K_K18641  L_L102  L_L275  0.0022
K_K18642  L_L102  L_L276  0.0021
* *  Branch  NTMP0000000102 - NTMP0000000103
R_R103  NTMP0000000102  nU_103  32.914993m  TC=0,0
V_Ui103  nU_103  nR_103  STIMULUS=U_IND_0000000103
R_V205  nR_103  nV_205  23.280268m  TC=0,0
L_V205  nR_103  nV_205  0.014646uH
R_V206  nV_205  nV_206  7.852787m  TC=0,0
L_V206  nV_205  nV_206  0.073723uH
L_L103  nV_206  NTMP0000000103  6.519695uH
K_K18643  L_L103  L_L104  0.1050
K_K18644  L_L103  L_L105  0.0397
K_K18645  L_L103  L_L106  0.0258
K_K18646  L_L103  L_L107  0.0192
K_K18647  L_L103  L_L108  0.0153
K_K18648  L_L103  L_L109  0.0127
K_K18649  L_L103  L_L110  0.0109
K_K18650  L_L103  L_L111  0.0095
K_K18651  L_L103  L_L112  0.0084
K_K18652  L_L103  L_L113  0.0076
K_K18653  L_L103  L_L114  0.0069
K_K18654  L_L103  L_L115  0.0063
K_K18655  L_L103  L_L116  0.0058
K_K18656  L_L103  L_L117  0.0054
K_K18657  L_L103  L_L118  0.0051
K_K18658  L_L103  L_L119  0.0047
K_K18659  L_L103  L_L120  0.0045
K_K18660  L_L103  L_L121  0.0042
K_K18661  L_L103  L_L122  0.0040
K_K18662  L_L103  L_L123  0.0038
K_K18663  L_L103  L_L124  0.0036
K_K18664  L_L103  L_L125  0.0034
K_K18665  L_L103  L_L126  0.0033
K_K18666  L_L103  L_L127  0.0032
K_K18667  L_L103  L_L128  0.0030
K_K18668  L_L103  L_L129  0.0029
K_K18669  L_L103  L_L130  0.0028
K_K18670  L_L103  L_L131  0.0027
K_K18671  L_L103  L_L132  0.0026
K_K18672  L_L103  L_L133  0.0025
K_K18673  L_L103  L_L134  0.0024
K_K18674  L_L103  L_L135  0.0024
K_K18675  L_L103  L_L136  0.0023
K_K18676  L_L103  L_L137  0.0022
K_K18677  L_L103  L_L138  0.0022
K_K18678  L_L103  L_L166  0.0010
K_K18679  L_L103  L_L167  0.0010
K_K18680  L_L103  L_L168  0.0010
K_K18681  L_L103  L_L169  0.0011
K_K18682  L_L103  L_L170  0.0011
K_K18683  L_L103  L_L171  0.0011
K_K18684  L_L103  L_L172  0.0011
K_K18685  L_L103  L_L173  0.0011
K_K18686  L_L103  L_L174  0.0011
K_K18687  L_L103  L_L175  0.0011
K_K18688  L_L103  L_L176  0.0012
K_K18689  L_L103  L_L177  0.0012
K_K18690  L_L103  L_L178  0.0012
K_K18691  L_L103  L_L179  0.0012
K_K18692  L_L103  L_L180  0.0012
K_K18693  L_L103  L_L181  0.0013
K_K18694  L_L103  L_L182  0.0013
K_K18695  L_L103  L_L183  0.0013
K_K18696  L_L103  L_L184  0.0013
K_K18697  L_L103  L_L185  0.0014
K_K18698  L_L103  L_L186  0.0014
K_K18699  L_L103  L_L187  0.0014
K_K18700  L_L103  L_L188  0.0014
K_K18701  L_L103  L_L189  0.0015
K_K18702  L_L103  L_L190  0.0015
K_K18703  L_L103  L_L191  0.0015
K_K18704  L_L103  L_L192  0.0015
K_K18705  L_L103  L_L193  0.0016
K_K18706  L_L103  L_L194  0.0016
K_K18707  L_L103  L_L195  0.0016
K_K18708  L_L103  L_L196  0.0017
K_K18709  L_L103  L_L197  0.0017
K_K18710  L_L103  L_L198  0.0018
K_K18711  L_L103  L_L199  0.0018
K_K18712  L_L103  L_L200  0.0018
K_K18713  L_L103  L_L201  0.0019
K_K18714  L_L103  L_L202  0.0019
K_K18715  L_L103  L_L203  0.0020
K_K18716  L_L103  L_L204  0.0020
K_K18717  L_L103  L_L205  0.0021
K_K18718  L_L103  L_L206  0.0022
K_K18719  L_L103  L_L207  0.0022
K_K18720  L_L103  L_L208  0.0023
K_K18721  L_L103  L_L209  0.0024
K_K18722  L_L103  L_L210  0.0024
K_K18723  L_L103  L_L211  0.0025
K_K18724  L_L103  L_L212  0.0026
K_K18725  L_L103  L_L213  0.0027
K_K18726  L_L103  L_L214  0.0028
K_K18727  L_L103  L_L215  0.0029
K_K18728  L_L103  L_L216  0.0030
K_K18729  L_L103  L_L217  0.0032
K_K18730  L_L103  L_L218  0.0033
K_K18731  L_L103  L_L219  0.0034
K_K18732  L_L103  L_L220  0.0036
K_K18733  L_L103  L_L221  0.0038
K_K18734  L_L103  L_L222  0.0040
K_K18735  L_L103  L_L223  0.0042
K_K18736  L_L103  L_L224  0.0045
K_K18737  L_L103  L_L225  0.0047
K_K18738  L_L103  L_L226  0.0051
K_K18739  L_L103  L_L227  0.0054
K_K18740  L_L103  L_L228  0.0058
K_K18741  L_L103  L_L229  0.0063
K_K18742  L_L103  L_L230  0.0069
K_K18743  L_L103  L_L231  0.0076
K_K18744  L_L103  L_L232  0.0084
K_K18745  L_L103  L_L233  0.0095
K_K18746  L_L103  L_L234  0.0109
K_K18747  L_L103  L_L235  0.0127
K_K18748  L_L103  L_L236  0.0152
K_K18749  L_L103  L_L237  0.0191
K_K18750  L_L103  L_L238  0.0256
K_K18751  L_L103  L_L239  0.0389
K_K18752  L_L103  L_L240  0.0812
K_K18753  L_L103  L_L241  0.1569
K_K18754  L_L103  L_L242  0.0812
K_K18755  L_L103  L_L243  0.0389
K_K18756  L_L103  L_L244  0.0256
K_K18757  L_L103  L_L245  0.0191
K_K18758  L_L103  L_L246  0.0152
K_K18759  L_L103  L_L247  0.0127
K_K18760  L_L103  L_L248  0.0109
K_K18761  L_L103  L_L249  0.0095
K_K18762  L_L103  L_L250  0.0084
K_K18763  L_L103  L_L251  0.0076
K_K18764  L_L103  L_L252  0.0069
K_K18765  L_L103  L_L253  0.0063
K_K18766  L_L103  L_L254  0.0058
K_K18767  L_L103  L_L255  0.0054
K_K18768  L_L103  L_L256  0.0051
K_K18769  L_L103  L_L257  0.0047
K_K18770  L_L103  L_L258  0.0045
K_K18771  L_L103  L_L259  0.0042
K_K18772  L_L103  L_L260  0.0040
K_K18773  L_L103  L_L261  0.0038
K_K18774  L_L103  L_L262  0.0036
K_K18775  L_L103  L_L263  0.0034
K_K18776  L_L103  L_L264  0.0033
K_K18777  L_L103  L_L265  0.0032
K_K18778  L_L103  L_L266  0.0030
K_K18779  L_L103  L_L267  0.0029
K_K18780  L_L103  L_L268  0.0028
K_K18781  L_L103  L_L269  0.0027
K_K18782  L_L103  L_L270  0.0026
K_K18783  L_L103  L_L271  0.0025
K_K18784  L_L103  L_L272  0.0024
K_K18785  L_L103  L_L273  0.0024
K_K18786  L_L103  L_L274  0.0023
K_K18787  L_L103  L_L275  0.0022
K_K18788  L_L103  L_L276  0.0022
* *  Branch  NTMP0000000103 - NTMP0000000104
R_R104  NTMP0000000103  nU_104  32.914993m  TC=0,0
V_Ui104  nU_104  nR_104  STIMULUS=U_IND_0000000104
R_V207  nR_104  nV_207  23.280268m  TC=0,0
L_V207  nR_104  nV_207  0.014646uH
R_V208  nV_207  nV_208  7.852787m  TC=0,0
L_V208  nV_207  nV_208  0.073723uH
L_L104  nV_208  NTMP0000000104  6.519695uH
K_K18789  L_L104  L_L105  0.1050
K_K18790  L_L104  L_L106  0.0397
K_K18791  L_L104  L_L107  0.0258
K_K18792  L_L104  L_L108  0.0192
K_K18793  L_L104  L_L109  0.0153
K_K18794  L_L104  L_L110  0.0127
K_K18795  L_L104  L_L111  0.0109
K_K18796  L_L104  L_L112  0.0095
K_K18797  L_L104  L_L113  0.0084
K_K18798  L_L104  L_L114  0.0076
K_K18799  L_L104  L_L115  0.0069
K_K18800  L_L104  L_L116  0.0063
K_K18801  L_L104  L_L117  0.0058
K_K18802  L_L104  L_L118  0.0054
K_K18803  L_L104  L_L119  0.0051
K_K18804  L_L104  L_L120  0.0047
K_K18805  L_L104  L_L121  0.0045
K_K18806  L_L104  L_L122  0.0042
K_K18807  L_L104  L_L123  0.0040
K_K18808  L_L104  L_L124  0.0038
K_K18809  L_L104  L_L125  0.0036
K_K18810  L_L104  L_L126  0.0034
K_K18811  L_L104  L_L127  0.0033
K_K18812  L_L104  L_L128  0.0032
K_K18813  L_L104  L_L129  0.0030
K_K18814  L_L104  L_L130  0.0029
K_K18815  L_L104  L_L131  0.0028
K_K18816  L_L104  L_L132  0.0027
K_K18817  L_L104  L_L133  0.0026
K_K18818  L_L104  L_L134  0.0025
K_K18819  L_L104  L_L135  0.0024
K_K18820  L_L104  L_L136  0.0024
K_K18821  L_L104  L_L137  0.0023
K_K18822  L_L104  L_L138  0.0022
K_K18823  L_L104  L_L167  0.0010
K_K18824  L_L104  L_L168  0.0010
K_K18825  L_L104  L_L169  0.0010
K_K18826  L_L104  L_L170  0.0011
K_K18827  L_L104  L_L171  0.0011
K_K18828  L_L104  L_L172  0.0011
K_K18829  L_L104  L_L173  0.0011
K_K18830  L_L104  L_L174  0.0011
K_K18831  L_L104  L_L175  0.0011
K_K18832  L_L104  L_L176  0.0011
K_K18833  L_L104  L_L177  0.0012
K_K18834  L_L104  L_L178  0.0012
K_K18835  L_L104  L_L179  0.0012
K_K18836  L_L104  L_L180  0.0012
K_K18837  L_L104  L_L181  0.0012
K_K18838  L_L104  L_L182  0.0013
K_K18839  L_L104  L_L183  0.0013
K_K18840  L_L104  L_L184  0.0013
K_K18841  L_L104  L_L185  0.0013
K_K18842  L_L104  L_L186  0.0014
K_K18843  L_L104  L_L187  0.0014
K_K18844  L_L104  L_L188  0.0014
K_K18845  L_L104  L_L189  0.0014
K_K18846  L_L104  L_L190  0.0015
K_K18847  L_L104  L_L191  0.0015
K_K18848  L_L104  L_L192  0.0015
K_K18849  L_L104  L_L193  0.0015
K_K18850  L_L104  L_L194  0.0016
K_K18851  L_L104  L_L195  0.0016
K_K18852  L_L104  L_L196  0.0016
K_K18853  L_L104  L_L197  0.0017
K_K18854  L_L104  L_L198  0.0017
K_K18855  L_L104  L_L199  0.0018
K_K18856  L_L104  L_L200  0.0018
K_K18857  L_L104  L_L201  0.0018
K_K18858  L_L104  L_L202  0.0019
K_K18859  L_L104  L_L203  0.0019
K_K18860  L_L104  L_L204  0.0020
K_K18861  L_L104  L_L205  0.0020
K_K18862  L_L104  L_L206  0.0021
K_K18863  L_L104  L_L207  0.0022
K_K18864  L_L104  L_L208  0.0022
K_K18865  L_L104  L_L209  0.0023
K_K18866  L_L104  L_L210  0.0024
K_K18867  L_L104  L_L211  0.0024
K_K18868  L_L104  L_L212  0.0025
K_K18869  L_L104  L_L213  0.0026
K_K18870  L_L104  L_L214  0.0027
K_K18871  L_L104  L_L215  0.0028
K_K18872  L_L104  L_L216  0.0029
K_K18873  L_L104  L_L217  0.0030
K_K18874  L_L104  L_L218  0.0032
K_K18875  L_L104  L_L219  0.0033
K_K18876  L_L104  L_L220  0.0034
K_K18877  L_L104  L_L221  0.0036
K_K18878  L_L104  L_L222  0.0038
K_K18879  L_L104  L_L223  0.0040
K_K18880  L_L104  L_L224  0.0042
K_K18881  L_L104  L_L225  0.0045
K_K18882  L_L104  L_L226  0.0047
K_K18883  L_L104  L_L227  0.0051
K_K18884  L_L104  L_L228  0.0054
K_K18885  L_L104  L_L229  0.0058
K_K18886  L_L104  L_L230  0.0063
K_K18887  L_L104  L_L231  0.0069
K_K18888  L_L104  L_L232  0.0076
K_K18889  L_L104  L_L233  0.0084
K_K18890  L_L104  L_L234  0.0095
K_K18891  L_L104  L_L235  0.0109
K_K18892  L_L104  L_L236  0.0127
K_K18893  L_L104  L_L237  0.0152
K_K18894  L_L104  L_L238  0.0191
K_K18895  L_L104  L_L239  0.0256
K_K18896  L_L104  L_L240  0.0389
K_K18897  L_L104  L_L241  0.0812
K_K18898  L_L104  L_L242  0.1569
K_K18899  L_L104  L_L243  0.0812
K_K18900  L_L104  L_L244  0.0389
K_K18901  L_L104  L_L245  0.0256
K_K18902  L_L104  L_L246  0.0191
K_K18903  L_L104  L_L247  0.0152
K_K18904  L_L104  L_L248  0.0127
K_K18905  L_L104  L_L249  0.0109
K_K18906  L_L104  L_L250  0.0095
K_K18907  L_L104  L_L251  0.0084
K_K18908  L_L104  L_L252  0.0076
K_K18909  L_L104  L_L253  0.0069
K_K18910  L_L104  L_L254  0.0063
K_K18911  L_L104  L_L255  0.0058
K_K18912  L_L104  L_L256  0.0054
K_K18913  L_L104  L_L257  0.0051
K_K18914  L_L104  L_L258  0.0047
K_K18915  L_L104  L_L259  0.0045
K_K18916  L_L104  L_L260  0.0042
K_K18917  L_L104  L_L261  0.0040
K_K18918  L_L104  L_L262  0.0038
K_K18919  L_L104  L_L263  0.0036
K_K18920  L_L104  L_L264  0.0034
K_K18921  L_L104  L_L265  0.0033
K_K18922  L_L104  L_L266  0.0032
K_K18923  L_L104  L_L267  0.0030
K_K18924  L_L104  L_L268  0.0029
K_K18925  L_L104  L_L269  0.0028
K_K18926  L_L104  L_L270  0.0027
K_K18927  L_L104  L_L271  0.0026
K_K18928  L_L104  L_L272  0.0025
K_K18929  L_L104  L_L273  0.0024
K_K18930  L_L104  L_L274  0.0024
K_K18931  L_L104  L_L275  0.0023
K_K18932  L_L104  L_L276  0.0022
* *  Branch  NTMP0000000104 - NTMP0000000105
R_R105  NTMP0000000104  nU_105  32.914993m  TC=0,0
V_Ui105  nU_105  nR_105  STIMULUS=U_IND_0000000105
R_V209  nR_105  nV_209  23.280268m  TC=0,0
L_V209  nR_105  nV_209  0.014646uH
R_V210  nV_209  nV_210  7.852787m  TC=0,0
L_V210  nV_209  nV_210  0.073723uH
L_L105  nV_210  NTMP0000000105  6.519695uH
K_K18933  L_L105  L_L106  0.1050
K_K18934  L_L105  L_L107  0.0397
K_K18935  L_L105  L_L108  0.0258
K_K18936  L_L105  L_L109  0.0192
K_K18937  L_L105  L_L110  0.0153
K_K18938  L_L105  L_L111  0.0127
K_K18939  L_L105  L_L112  0.0109
K_K18940  L_L105  L_L113  0.0095
K_K18941  L_L105  L_L114  0.0084
K_K18942  L_L105  L_L115  0.0076
K_K18943  L_L105  L_L116  0.0069
K_K18944  L_L105  L_L117  0.0063
K_K18945  L_L105  L_L118  0.0058
K_K18946  L_L105  L_L119  0.0054
K_K18947  L_L105  L_L120  0.0051
K_K18948  L_L105  L_L121  0.0047
K_K18949  L_L105  L_L122  0.0045
K_K18950  L_L105  L_L123  0.0042
K_K18951  L_L105  L_L124  0.0040
K_K18952  L_L105  L_L125  0.0038
K_K18953  L_L105  L_L126  0.0036
K_K18954  L_L105  L_L127  0.0034
K_K18955  L_L105  L_L128  0.0033
K_K18956  L_L105  L_L129  0.0032
K_K18957  L_L105  L_L130  0.0030
K_K18958  L_L105  L_L131  0.0029
K_K18959  L_L105  L_L132  0.0028
K_K18960  L_L105  L_L133  0.0027
K_K18961  L_L105  L_L134  0.0026
K_K18962  L_L105  L_L135  0.0025
K_K18963  L_L105  L_L136  0.0024
K_K18964  L_L105  L_L137  0.0024
K_K18965  L_L105  L_L138  0.0023
K_K18966  L_L105  L_L168  0.0010
K_K18967  L_L105  L_L169  0.0010
K_K18968  L_L105  L_L170  0.0010
K_K18969  L_L105  L_L171  0.0011
K_K18970  L_L105  L_L172  0.0011
K_K18971  L_L105  L_L173  0.0011
K_K18972  L_L105  L_L174  0.0011
K_K18973  L_L105  L_L175  0.0011
K_K18974  L_L105  L_L176  0.0011
K_K18975  L_L105  L_L177  0.0011
K_K18976  L_L105  L_L178  0.0012
K_K18977  L_L105  L_L179  0.0012
K_K18978  L_L105  L_L180  0.0012
K_K18979  L_L105  L_L181  0.0012
K_K18980  L_L105  L_L182  0.0012
K_K18981  L_L105  L_L183  0.0013
K_K18982  L_L105  L_L184  0.0013
K_K18983  L_L105  L_L185  0.0013
K_K18984  L_L105  L_L186  0.0013
K_K18985  L_L105  L_L187  0.0014
K_K18986  L_L105  L_L188  0.0014
K_K18987  L_L105  L_L189  0.0014
K_K18988  L_L105  L_L190  0.0014
K_K18989  L_L105  L_L191  0.0015
K_K18990  L_L105  L_L192  0.0015
K_K18991  L_L105  L_L193  0.0015
K_K18992  L_L105  L_L194  0.0015
K_K18993  L_L105  L_L195  0.0016
K_K18994  L_L105  L_L196  0.0016
K_K18995  L_L105  L_L197  0.0016
K_K18996  L_L105  L_L198  0.0017
K_K18997  L_L105  L_L199  0.0017
K_K18998  L_L105  L_L200  0.0018
K_K18999  L_L105  L_L201  0.0018
K_K19000  L_L105  L_L202  0.0018
K_K19001  L_L105  L_L203  0.0019
K_K19002  L_L105  L_L204  0.0019
K_K19003  L_L105  L_L205  0.0020
K_K19004  L_L105  L_L206  0.0020
K_K19005  L_L105  L_L207  0.0021
K_K19006  L_L105  L_L208  0.0022
K_K19007  L_L105  L_L209  0.0022
K_K19008  L_L105  L_L210  0.0023
K_K19009  L_L105  L_L211  0.0024
K_K19010  L_L105  L_L212  0.0024
K_K19011  L_L105  L_L213  0.0025
K_K19012  L_L105  L_L214  0.0026
K_K19013  L_L105  L_L215  0.0027
K_K19014  L_L105  L_L216  0.0028
K_K19015  L_L105  L_L217  0.0029
K_K19016  L_L105  L_L218  0.0030
K_K19017  L_L105  L_L219  0.0032
K_K19018  L_L105  L_L220  0.0033
K_K19019  L_L105  L_L221  0.0034
K_K19020  L_L105  L_L222  0.0036
K_K19021  L_L105  L_L223  0.0038
K_K19022  L_L105  L_L224  0.0040
K_K19023  L_L105  L_L225  0.0042
K_K19024  L_L105  L_L226  0.0045
K_K19025  L_L105  L_L227  0.0047
K_K19026  L_L105  L_L228  0.0051
K_K19027  L_L105  L_L229  0.0054
K_K19028  L_L105  L_L230  0.0058
K_K19029  L_L105  L_L231  0.0063
K_K19030  L_L105  L_L232  0.0069
K_K19031  L_L105  L_L233  0.0076
K_K19032  L_L105  L_L234  0.0084
K_K19033  L_L105  L_L235  0.0095
K_K19034  L_L105  L_L236  0.0109
K_K19035  L_L105  L_L237  0.0127
K_K19036  L_L105  L_L238  0.0152
K_K19037  L_L105  L_L239  0.0191
K_K19038  L_L105  L_L240  0.0256
K_K19039  L_L105  L_L241  0.0389
K_K19040  L_L105  L_L242  0.0812
K_K19041  L_L105  L_L243  0.1569
K_K19042  L_L105  L_L244  0.0812
K_K19043  L_L105  L_L245  0.0389
K_K19044  L_L105  L_L246  0.0256
K_K19045  L_L105  L_L247  0.0191
K_K19046  L_L105  L_L248  0.0152
K_K19047  L_L105  L_L249  0.0127
K_K19048  L_L105  L_L250  0.0109
K_K19049  L_L105  L_L251  0.0095
K_K19050  L_L105  L_L252  0.0084
K_K19051  L_L105  L_L253  0.0076
K_K19052  L_L105  L_L254  0.0069
K_K19053  L_L105  L_L255  0.0063
K_K19054  L_L105  L_L256  0.0058
K_K19055  L_L105  L_L257  0.0054
K_K19056  L_L105  L_L258  0.0051
K_K19057  L_L105  L_L259  0.0047
K_K19058  L_L105  L_L260  0.0045
K_K19059  L_L105  L_L261  0.0042
K_K19060  L_L105  L_L262  0.0040
K_K19061  L_L105  L_L263  0.0038
K_K19062  L_L105  L_L264  0.0036
K_K19063  L_L105  L_L265  0.0034
K_K19064  L_L105  L_L266  0.0033
K_K19065  L_L105  L_L267  0.0032
K_K19066  L_L105  L_L268  0.0030
K_K19067  L_L105  L_L269  0.0029
K_K19068  L_L105  L_L270  0.0028
K_K19069  L_L105  L_L271  0.0027
K_K19070  L_L105  L_L272  0.0026
K_K19071  L_L105  L_L273  0.0025
K_K19072  L_L105  L_L274  0.0024
K_K19073  L_L105  L_L275  0.0024
K_K19074  L_L105  L_L276  0.0023
* *  Branch  NTMP0000000105 - NTMP0000000106
R_R106  NTMP0000000105  nU_106  32.914993m  TC=0,0
V_Ui106  nU_106  nR_106  STIMULUS=U_IND_0000000106
R_V211  nR_106  nV_211  23.280268m  TC=0,0
L_V211  nR_106  nV_211  0.014646uH
R_V212  nV_211  nV_212  7.852787m  TC=0,0
L_V212  nV_211  nV_212  0.073723uH
L_L106  nV_212  NTMP0000000106  6.519695uH
K_K19075  L_L106  L_L107  0.1050
K_K19076  L_L106  L_L108  0.0397
K_K19077  L_L106  L_L109  0.0258
K_K19078  L_L106  L_L110  0.0192
K_K19079  L_L106  L_L111  0.0153
K_K19080  L_L106  L_L112  0.0127
K_K19081  L_L106  L_L113  0.0109
K_K19082  L_L106  L_L114  0.0095
K_K19083  L_L106  L_L115  0.0084
K_K19084  L_L106  L_L116  0.0076
K_K19085  L_L106  L_L117  0.0069
K_K19086  L_L106  L_L118  0.0063
K_K19087  L_L106  L_L119  0.0058
K_K19088  L_L106  L_L120  0.0054
K_K19089  L_L106  L_L121  0.0051
K_K19090  L_L106  L_L122  0.0047
K_K19091  L_L106  L_L123  0.0045
K_K19092  L_L106  L_L124  0.0042
K_K19093  L_L106  L_L125  0.0040
K_K19094  L_L106  L_L126  0.0038
K_K19095  L_L106  L_L127  0.0036
K_K19096  L_L106  L_L128  0.0034
K_K19097  L_L106  L_L129  0.0033
K_K19098  L_L106  L_L130  0.0032
K_K19099  L_L106  L_L131  0.0030
K_K19100  L_L106  L_L132  0.0029
K_K19101  L_L106  L_L133  0.0028
K_K19102  L_L106  L_L134  0.0027
K_K19103  L_L106  L_L135  0.0026
K_K19104  L_L106  L_L136  0.0025
K_K19105  L_L106  L_L137  0.0024
K_K19106  L_L106  L_L138  0.0024
K_K19107  L_L106  L_L169  0.0010
K_K19108  L_L106  L_L170  0.0010
K_K19109  L_L106  L_L171  0.0010
K_K19110  L_L106  L_L172  0.0011
K_K19111  L_L106  L_L173  0.0011
K_K19112  L_L106  L_L174  0.0011
K_K19113  L_L106  L_L175  0.0011
K_K19114  L_L106  L_L176  0.0011
K_K19115  L_L106  L_L177  0.0011
K_K19116  L_L106  L_L178  0.0011
K_K19117  L_L106  L_L179  0.0012
K_K19118  L_L106  L_L180  0.0012
K_K19119  L_L106  L_L181  0.0012
K_K19120  L_L106  L_L182  0.0012
K_K19121  L_L106  L_L183  0.0012
K_K19122  L_L106  L_L184  0.0013
K_K19123  L_L106  L_L185  0.0013
K_K19124  L_L106  L_L186  0.0013
K_K19125  L_L106  L_L187  0.0013
K_K19126  L_L106  L_L188  0.0014
K_K19127  L_L106  L_L189  0.0014
K_K19128  L_L106  L_L190  0.0014
K_K19129  L_L106  L_L191  0.0014
K_K19130  L_L106  L_L192  0.0015
K_K19131  L_L106  L_L193  0.0015
K_K19132  L_L106  L_L194  0.0015
K_K19133  L_L106  L_L195  0.0015
K_K19134  L_L106  L_L196  0.0016
K_K19135  L_L106  L_L197  0.0016
K_K19136  L_L106  L_L198  0.0016
K_K19137  L_L106  L_L199  0.0017
K_K19138  L_L106  L_L200  0.0017
K_K19139  L_L106  L_L201  0.0018
K_K19140  L_L106  L_L202  0.0018
K_K19141  L_L106  L_L203  0.0018
K_K19142  L_L106  L_L204  0.0019
K_K19143  L_L106  L_L205  0.0019
K_K19144  L_L106  L_L206  0.0020
K_K19145  L_L106  L_L207  0.0020
K_K19146  L_L106  L_L208  0.0021
K_K19147  L_L106  L_L209  0.0022
K_K19148  L_L106  L_L210  0.0022
K_K19149  L_L106  L_L211  0.0023
K_K19150  L_L106  L_L212  0.0024
K_K19151  L_L106  L_L213  0.0024
K_K19152  L_L106  L_L214  0.0025
K_K19153  L_L106  L_L215  0.0026
K_K19154  L_L106  L_L216  0.0027
K_K19155  L_L106  L_L217  0.0028
K_K19156  L_L106  L_L218  0.0029
K_K19157  L_L106  L_L219  0.0030
K_K19158  L_L106  L_L220  0.0032
K_K19159  L_L106  L_L221  0.0033
K_K19160  L_L106  L_L222  0.0034
K_K19161  L_L106  L_L223  0.0036
K_K19162  L_L106  L_L224  0.0038
K_K19163  L_L106  L_L225  0.0040
K_K19164  L_L106  L_L226  0.0042
K_K19165  L_L106  L_L227  0.0045
K_K19166  L_L106  L_L228  0.0047
K_K19167  L_L106  L_L229  0.0051
K_K19168  L_L106  L_L230  0.0054
K_K19169  L_L106  L_L231  0.0058
K_K19170  L_L106  L_L232  0.0063
K_K19171  L_L106  L_L233  0.0069
K_K19172  L_L106  L_L234  0.0076
K_K19173  L_L106  L_L235  0.0084
K_K19174  L_L106  L_L236  0.0095
K_K19175  L_L106  L_L237  0.0109
K_K19176  L_L106  L_L238  0.0127
K_K19177  L_L106  L_L239  0.0152
K_K19178  L_L106  L_L240  0.0191
K_K19179  L_L106  L_L241  0.0256
K_K19180  L_L106  L_L242  0.0389
K_K19181  L_L106  L_L243  0.0812
K_K19182  L_L106  L_L244  0.1569
K_K19183  L_L106  L_L245  0.0812
K_K19184  L_L106  L_L246  0.0389
K_K19185  L_L106  L_L247  0.0256
K_K19186  L_L106  L_L248  0.0191
K_K19187  L_L106  L_L249  0.0152
K_K19188  L_L106  L_L250  0.0127
K_K19189  L_L106  L_L251  0.0109
K_K19190  L_L106  L_L252  0.0095
K_K19191  L_L106  L_L253  0.0084
K_K19192  L_L106  L_L254  0.0076
K_K19193  L_L106  L_L255  0.0069
K_K19194  L_L106  L_L256  0.0063
K_K19195  L_L106  L_L257  0.0058
K_K19196  L_L106  L_L258  0.0054
K_K19197  L_L106  L_L259  0.0051
K_K19198  L_L106  L_L260  0.0047
K_K19199  L_L106  L_L261  0.0045
K_K19200  L_L106  L_L262  0.0042
K_K19201  L_L106  L_L263  0.0040
K_K19202  L_L106  L_L264  0.0038
K_K19203  L_L106  L_L265  0.0036
K_K19204  L_L106  L_L266  0.0034
K_K19205  L_L106  L_L267  0.0033
K_K19206  L_L106  L_L268  0.0032
K_K19207  L_L106  L_L269  0.0030
K_K19208  L_L106  L_L270  0.0029
K_K19209  L_L106  L_L271  0.0028
K_K19210  L_L106  L_L272  0.0027
K_K19211  L_L106  L_L273  0.0026
K_K19212  L_L106  L_L274  0.0025
K_K19213  L_L106  L_L275  0.0024
K_K19214  L_L106  L_L276  0.0024
* *  Branch  NTMP0000000106 - NTMP0000000107
R_R107  NTMP0000000106  nU_107  32.914993m  TC=0,0
V_Ui107  nU_107  nR_107  STIMULUS=U_IND_0000000107
R_V213  nR_107  nV_213  23.280268m  TC=0,0
L_V213  nR_107  nV_213  0.014646uH
R_V214  nV_213  nV_214  7.852787m  TC=0,0
L_V214  nV_213  nV_214  0.073723uH
L_L107  nV_214  NTMP0000000107  6.519695uH
K_K19215  L_L107  L_L108  0.1050
K_K19216  L_L107  L_L109  0.0397
K_K19217  L_L107  L_L110  0.0258
K_K19218  L_L107  L_L111  0.0192
K_K19219  L_L107  L_L112  0.0153
K_K19220  L_L107  L_L113  0.0127
K_K19221  L_L107  L_L114  0.0109
K_K19222  L_L107  L_L115  0.0095
K_K19223  L_L107  L_L116  0.0084
K_K19224  L_L107  L_L117  0.0076
K_K19225  L_L107  L_L118  0.0069
K_K19226  L_L107  L_L119  0.0063
K_K19227  L_L107  L_L120  0.0058
K_K19228  L_L107  L_L121  0.0054
K_K19229  L_L107  L_L122  0.0051
K_K19230  L_L107  L_L123  0.0047
K_K19231  L_L107  L_L124  0.0045
K_K19232  L_L107  L_L125  0.0042
K_K19233  L_L107  L_L126  0.0040
K_K19234  L_L107  L_L127  0.0038
K_K19235  L_L107  L_L128  0.0036
K_K19236  L_L107  L_L129  0.0034
K_K19237  L_L107  L_L130  0.0033
K_K19238  L_L107  L_L131  0.0032
K_K19239  L_L107  L_L132  0.0030
K_K19240  L_L107  L_L133  0.0029
K_K19241  L_L107  L_L134  0.0028
K_K19242  L_L107  L_L135  0.0027
K_K19243  L_L107  L_L136  0.0026
K_K19244  L_L107  L_L137  0.0025
K_K19245  L_L107  L_L138  0.0024
K_K19246  L_L107  L_L170  0.0010
K_K19247  L_L107  L_L171  0.0010
K_K19248  L_L107  L_L172  0.0010
K_K19249  L_L107  L_L173  0.0011
K_K19250  L_L107  L_L174  0.0011
K_K19251  L_L107  L_L175  0.0011
K_K19252  L_L107  L_L176  0.0011
K_K19253  L_L107  L_L177  0.0011
K_K19254  L_L107  L_L178  0.0011
K_K19255  L_L107  L_L179  0.0011
K_K19256  L_L107  L_L180  0.0012
K_K19257  L_L107  L_L181  0.0012
K_K19258  L_L107  L_L182  0.0012
K_K19259  L_L107  L_L183  0.0012
K_K19260  L_L107  L_L184  0.0012
K_K19261  L_L107  L_L185  0.0013
K_K19262  L_L107  L_L186  0.0013
K_K19263  L_L107  L_L187  0.0013
K_K19264  L_L107  L_L188  0.0013
K_K19265  L_L107  L_L189  0.0014
K_K19266  L_L107  L_L190  0.0014
K_K19267  L_L107  L_L191  0.0014
K_K19268  L_L107  L_L192  0.0014
K_K19269  L_L107  L_L193  0.0015
K_K19270  L_L107  L_L194  0.0015
K_K19271  L_L107  L_L195  0.0015
K_K19272  L_L107  L_L196  0.0015
K_K19273  L_L107  L_L197  0.0016
K_K19274  L_L107  L_L198  0.0016
K_K19275  L_L107  L_L199  0.0016
K_K19276  L_L107  L_L200  0.0017
K_K19277  L_L107  L_L201  0.0017
K_K19278  L_L107  L_L202  0.0018
K_K19279  L_L107  L_L203  0.0018
K_K19280  L_L107  L_L204  0.0018
K_K19281  L_L107  L_L205  0.0019
K_K19282  L_L107  L_L206  0.0019
K_K19283  L_L107  L_L207  0.0020
K_K19284  L_L107  L_L208  0.0020
K_K19285  L_L107  L_L209  0.0021
K_K19286  L_L107  L_L210  0.0022
K_K19287  L_L107  L_L211  0.0022
K_K19288  L_L107  L_L212  0.0023
K_K19289  L_L107  L_L213  0.0024
K_K19290  L_L107  L_L214  0.0024
K_K19291  L_L107  L_L215  0.0025
K_K19292  L_L107  L_L216  0.0026
K_K19293  L_L107  L_L217  0.0027
K_K19294  L_L107  L_L218  0.0028
K_K19295  L_L107  L_L219  0.0029
K_K19296  L_L107  L_L220  0.0030
K_K19297  L_L107  L_L221  0.0032
K_K19298  L_L107  L_L222  0.0033
K_K19299  L_L107  L_L223  0.0034
K_K19300  L_L107  L_L224  0.0036
K_K19301  L_L107  L_L225  0.0038
K_K19302  L_L107  L_L226  0.0040
K_K19303  L_L107  L_L227  0.0042
K_K19304  L_L107  L_L228  0.0045
K_K19305  L_L107  L_L229  0.0047
K_K19306  L_L107  L_L230  0.0051
K_K19307  L_L107  L_L231  0.0054
K_K19308  L_L107  L_L232  0.0058
K_K19309  L_L107  L_L233  0.0063
K_K19310  L_L107  L_L234  0.0069
K_K19311  L_L107  L_L235  0.0076
K_K19312  L_L107  L_L236  0.0084
K_K19313  L_L107  L_L237  0.0095
K_K19314  L_L107  L_L238  0.0109
K_K19315  L_L107  L_L239  0.0127
K_K19316  L_L107  L_L240  0.0152
K_K19317  L_L107  L_L241  0.0191
K_K19318  L_L107  L_L242  0.0256
K_K19319  L_L107  L_L243  0.0389
K_K19320  L_L107  L_L244  0.0812
K_K19321  L_L107  L_L245  0.1569
K_K19322  L_L107  L_L246  0.0812
K_K19323  L_L107  L_L247  0.0389
K_K19324  L_L107  L_L248  0.0256
K_K19325  L_L107  L_L249  0.0191
K_K19326  L_L107  L_L250  0.0152
K_K19327  L_L107  L_L251  0.0127
K_K19328  L_L107  L_L252  0.0109
K_K19329  L_L107  L_L253  0.0095
K_K19330  L_L107  L_L254  0.0084
K_K19331  L_L107  L_L255  0.0076
K_K19332  L_L107  L_L256  0.0069
K_K19333  L_L107  L_L257  0.0063
K_K19334  L_L107  L_L258  0.0058
K_K19335  L_L107  L_L259  0.0054
K_K19336  L_L107  L_L260  0.0051
K_K19337  L_L107  L_L261  0.0047
K_K19338  L_L107  L_L262  0.0045
K_K19339  L_L107  L_L263  0.0042
K_K19340  L_L107  L_L264  0.0040
K_K19341  L_L107  L_L265  0.0038
K_K19342  L_L107  L_L266  0.0036
K_K19343  L_L107  L_L267  0.0034
K_K19344  L_L107  L_L268  0.0033
K_K19345  L_L107  L_L269  0.0032
K_K19346  L_L107  L_L270  0.0030
K_K19347  L_L107  L_L271  0.0029
K_K19348  L_L107  L_L272  0.0028
K_K19349  L_L107  L_L273  0.0027
K_K19350  L_L107  L_L274  0.0026
K_K19351  L_L107  L_L275  0.0025
K_K19352  L_L107  L_L276  0.0024
* *  Branch  NTMP0000000107 - NTMP0000000108
R_R108  NTMP0000000107  nU_108  32.914993m  TC=0,0
V_Ui108  nU_108  nR_108  STIMULUS=U_IND_0000000108
R_V215  nR_108  nV_215  23.280268m  TC=0,0
L_V215  nR_108  nV_215  0.014646uH
R_V216  nV_215  nV_216  7.852787m  TC=0,0
L_V216  nV_215  nV_216  0.073723uH
L_L108  nV_216  NTMP0000000108  6.519695uH
K_K19353  L_L108  L_L109  0.1050
K_K19354  L_L108  L_L110  0.0397
K_K19355  L_L108  L_L111  0.0258
K_K19356  L_L108  L_L112  0.0192
K_K19357  L_L108  L_L113  0.0153
K_K19358  L_L108  L_L114  0.0127
K_K19359  L_L108  L_L115  0.0109
K_K19360  L_L108  L_L116  0.0095
K_K19361  L_L108  L_L117  0.0084
K_K19362  L_L108  L_L118  0.0076
K_K19363  L_L108  L_L119  0.0069
K_K19364  L_L108  L_L120  0.0063
K_K19365  L_L108  L_L121  0.0058
K_K19366  L_L108  L_L122  0.0054
K_K19367  L_L108  L_L123  0.0051
K_K19368  L_L108  L_L124  0.0047
K_K19369  L_L108  L_L125  0.0045
K_K19370  L_L108  L_L126  0.0042
K_K19371  L_L108  L_L127  0.0040
K_K19372  L_L108  L_L128  0.0038
K_K19373  L_L108  L_L129  0.0036
K_K19374  L_L108  L_L130  0.0034
K_K19375  L_L108  L_L131  0.0033
K_K19376  L_L108  L_L132  0.0032
K_K19377  L_L108  L_L133  0.0030
K_K19378  L_L108  L_L134  0.0029
K_K19379  L_L108  L_L135  0.0028
K_K19380  L_L108  L_L136  0.0027
K_K19381  L_L108  L_L137  0.0026
K_K19382  L_L108  L_L138  0.0025
K_K19383  L_L108  L_L171  0.0010
K_K19384  L_L108  L_L172  0.0010
K_K19385  L_L108  L_L173  0.0010
K_K19386  L_L108  L_L174  0.0011
K_K19387  L_L108  L_L175  0.0011
K_K19388  L_L108  L_L176  0.0011
K_K19389  L_L108  L_L177  0.0011
K_K19390  L_L108  L_L178  0.0011
K_K19391  L_L108  L_L179  0.0011
K_K19392  L_L108  L_L180  0.0011
K_K19393  L_L108  L_L181  0.0012
K_K19394  L_L108  L_L182  0.0012
K_K19395  L_L108  L_L183  0.0012
K_K19396  L_L108  L_L184  0.0012
K_K19397  L_L108  L_L185  0.0012
K_K19398  L_L108  L_L186  0.0013
K_K19399  L_L108  L_L187  0.0013
K_K19400  L_L108  L_L188  0.0013
K_K19401  L_L108  L_L189  0.0013
K_K19402  L_L108  L_L190  0.0014
K_K19403  L_L108  L_L191  0.0014
K_K19404  L_L108  L_L192  0.0014
K_K19405  L_L108  L_L193  0.0014
K_K19406  L_L108  L_L194  0.0015
K_K19407  L_L108  L_L195  0.0015
K_K19408  L_L108  L_L196  0.0015
K_K19409  L_L108  L_L197  0.0015
K_K19410  L_L108  L_L198  0.0016
K_K19411  L_L108  L_L199  0.0016
K_K19412  L_L108  L_L200  0.0016
K_K19413  L_L108  L_L201  0.0017
K_K19414  L_L108  L_L202  0.0017
K_K19415  L_L108  L_L203  0.0018
K_K19416  L_L108  L_L204  0.0018
K_K19417  L_L108  L_L205  0.0018
K_K19418  L_L108  L_L206  0.0019
K_K19419  L_L108  L_L207  0.0019
K_K19420  L_L108  L_L208  0.0020
K_K19421  L_L108  L_L209  0.0020
K_K19422  L_L108  L_L210  0.0021
K_K19423  L_L108  L_L211  0.0022
K_K19424  L_L108  L_L212  0.0022
K_K19425  L_L108  L_L213  0.0023
K_K19426  L_L108  L_L214  0.0024
K_K19427  L_L108  L_L215  0.0024
K_K19428  L_L108  L_L216  0.0025
K_K19429  L_L108  L_L217  0.0026
K_K19430  L_L108  L_L218  0.0027
K_K19431  L_L108  L_L219  0.0028
K_K19432  L_L108  L_L220  0.0029
K_K19433  L_L108  L_L221  0.0030
K_K19434  L_L108  L_L222  0.0032
K_K19435  L_L108  L_L223  0.0033
K_K19436  L_L108  L_L224  0.0034
K_K19437  L_L108  L_L225  0.0036
K_K19438  L_L108  L_L226  0.0038
K_K19439  L_L108  L_L227  0.0040
K_K19440  L_L108  L_L228  0.0042
K_K19441  L_L108  L_L229  0.0045
K_K19442  L_L108  L_L230  0.0047
K_K19443  L_L108  L_L231  0.0051
K_K19444  L_L108  L_L232  0.0054
K_K19445  L_L108  L_L233  0.0058
K_K19446  L_L108  L_L234  0.0063
K_K19447  L_L108  L_L235  0.0069
K_K19448  L_L108  L_L236  0.0076
K_K19449  L_L108  L_L237  0.0084
K_K19450  L_L108  L_L238  0.0095
K_K19451  L_L108  L_L239  0.0109
K_K19452  L_L108  L_L240  0.0127
K_K19453  L_L108  L_L241  0.0152
K_K19454  L_L108  L_L242  0.0191
K_K19455  L_L108  L_L243  0.0256
K_K19456  L_L108  L_L244  0.0389
K_K19457  L_L108  L_L245  0.0812
K_K19458  L_L108  L_L246  0.1569
K_K19459  L_L108  L_L247  0.0812
K_K19460  L_L108  L_L248  0.0389
K_K19461  L_L108  L_L249  0.0256
K_K19462  L_L108  L_L250  0.0191
K_K19463  L_L108  L_L251  0.0152
K_K19464  L_L108  L_L252  0.0127
K_K19465  L_L108  L_L253  0.0109
K_K19466  L_L108  L_L254  0.0095
K_K19467  L_L108  L_L255  0.0084
K_K19468  L_L108  L_L256  0.0076
K_K19469  L_L108  L_L257  0.0069
K_K19470  L_L108  L_L258  0.0063
K_K19471  L_L108  L_L259  0.0058
K_K19472  L_L108  L_L260  0.0054
K_K19473  L_L108  L_L261  0.0051
K_K19474  L_L108  L_L262  0.0047
K_K19475  L_L108  L_L263  0.0045
K_K19476  L_L108  L_L264  0.0042
K_K19477  L_L108  L_L265  0.0040
K_K19478  L_L108  L_L266  0.0038
K_K19479  L_L108  L_L267  0.0036
K_K19480  L_L108  L_L268  0.0034
K_K19481  L_L108  L_L269  0.0033
K_K19482  L_L108  L_L270  0.0032
K_K19483  L_L108  L_L271  0.0030
K_K19484  L_L108  L_L272  0.0029
K_K19485  L_L108  L_L273  0.0028
K_K19486  L_L108  L_L274  0.0027
K_K19487  L_L108  L_L275  0.0026
K_K19488  L_L108  L_L276  0.0025
* *  Branch  NTMP0000000108 - NTMP0000000109
R_R109  NTMP0000000108  nU_109  32.914993m  TC=0,0
V_Ui109  nU_109  nR_109  STIMULUS=U_IND_0000000109
R_V217  nR_109  nV_217  23.280268m  TC=0,0
L_V217  nR_109  nV_217  0.014646uH
R_V218  nV_217  nV_218  7.852787m  TC=0,0
L_V218  nV_217  nV_218  0.073723uH
L_L109  nV_218  NTMP0000000109  6.519695uH
K_K19489  L_L109  L_L110  0.1050
K_K19490  L_L109  L_L111  0.0397
K_K19491  L_L109  L_L112  0.0258
K_K19492  L_L109  L_L113  0.0192
K_K19493  L_L109  L_L114  0.0153
K_K19494  L_L109  L_L115  0.0127
K_K19495  L_L109  L_L116  0.0109
K_K19496  L_L109  L_L117  0.0095
K_K19497  L_L109  L_L118  0.0084
K_K19498  L_L109  L_L119  0.0076
K_K19499  L_L109  L_L120  0.0069
K_K19500  L_L109  L_L121  0.0063
K_K19501  L_L109  L_L122  0.0058
K_K19502  L_L109  L_L123  0.0054
K_K19503  L_L109  L_L124  0.0051
K_K19504  L_L109  L_L125  0.0047
K_K19505  L_L109  L_L126  0.0045
K_K19506  L_L109  L_L127  0.0042
K_K19507  L_L109  L_L128  0.0040
K_K19508  L_L109  L_L129  0.0038
K_K19509  L_L109  L_L130  0.0036
K_K19510  L_L109  L_L131  0.0034
K_K19511  L_L109  L_L132  0.0033
K_K19512  L_L109  L_L133  0.0032
K_K19513  L_L109  L_L134  0.0030
K_K19514  L_L109  L_L135  0.0029
K_K19515  L_L109  L_L136  0.0028
K_K19516  L_L109  L_L137  0.0027
K_K19517  L_L109  L_L138  0.0026
K_K19518  L_L109  L_L172  0.0010
K_K19519  L_L109  L_L173  0.0010
K_K19520  L_L109  L_L174  0.0010
K_K19521  L_L109  L_L175  0.0011
K_K19522  L_L109  L_L176  0.0011
K_K19523  L_L109  L_L177  0.0011
K_K19524  L_L109  L_L178  0.0011
K_K19525  L_L109  L_L179  0.0011
K_K19526  L_L109  L_L180  0.0011
K_K19527  L_L109  L_L181  0.0011
K_K19528  L_L109  L_L182  0.0012
K_K19529  L_L109  L_L183  0.0012
K_K19530  L_L109  L_L184  0.0012
K_K19531  L_L109  L_L185  0.0012
K_K19532  L_L109  L_L186  0.0012
K_K19533  L_L109  L_L187  0.0013
K_K19534  L_L109  L_L188  0.0013
K_K19535  L_L109  L_L189  0.0013
K_K19536  L_L109  L_L190  0.0013
K_K19537  L_L109  L_L191  0.0014
K_K19538  L_L109  L_L192  0.0014
K_K19539  L_L109  L_L193  0.0014
K_K19540  L_L109  L_L194  0.0014
K_K19541  L_L109  L_L195  0.0015
K_K19542  L_L109  L_L196  0.0015
K_K19543  L_L109  L_L197  0.0015
K_K19544  L_L109  L_L198  0.0015
K_K19545  L_L109  L_L199  0.0016
K_K19546  L_L109  L_L200  0.0016
K_K19547  L_L109  L_L201  0.0016
K_K19548  L_L109  L_L202  0.0017
K_K19549  L_L109  L_L203  0.0017
K_K19550  L_L109  L_L204  0.0018
K_K19551  L_L109  L_L205  0.0018
K_K19552  L_L109  L_L206  0.0018
K_K19553  L_L109  L_L207  0.0019
K_K19554  L_L109  L_L208  0.0019
K_K19555  L_L109  L_L209  0.0020
K_K19556  L_L109  L_L210  0.0020
K_K19557  L_L109  L_L211  0.0021
K_K19558  L_L109  L_L212  0.0022
K_K19559  L_L109  L_L213  0.0022
K_K19560  L_L109  L_L214  0.0023
K_K19561  L_L109  L_L215  0.0024
K_K19562  L_L109  L_L216  0.0024
K_K19563  L_L109  L_L217  0.0025
K_K19564  L_L109  L_L218  0.0026
K_K19565  L_L109  L_L219  0.0027
K_K19566  L_L109  L_L220  0.0028
K_K19567  L_L109  L_L221  0.0029
K_K19568  L_L109  L_L222  0.0030
K_K19569  L_L109  L_L223  0.0032
K_K19570  L_L109  L_L224  0.0033
K_K19571  L_L109  L_L225  0.0034
K_K19572  L_L109  L_L226  0.0036
K_K19573  L_L109  L_L227  0.0038
K_K19574  L_L109  L_L228  0.0040
K_K19575  L_L109  L_L229  0.0042
K_K19576  L_L109  L_L230  0.0045
K_K19577  L_L109  L_L231  0.0047
K_K19578  L_L109  L_L232  0.0051
K_K19579  L_L109  L_L233  0.0054
K_K19580  L_L109  L_L234  0.0058
K_K19581  L_L109  L_L235  0.0063
K_K19582  L_L109  L_L236  0.0069
K_K19583  L_L109  L_L237  0.0076
K_K19584  L_L109  L_L238  0.0084
K_K19585  L_L109  L_L239  0.0095
K_K19586  L_L109  L_L240  0.0109
K_K19587  L_L109  L_L241  0.0127
K_K19588  L_L109  L_L242  0.0152
K_K19589  L_L109  L_L243  0.0191
K_K19590  L_L109  L_L244  0.0256
K_K19591  L_L109  L_L245  0.0389
K_K19592  L_L109  L_L246  0.0812
K_K19593  L_L109  L_L247  0.1569
K_K19594  L_L109  L_L248  0.0812
K_K19595  L_L109  L_L249  0.0389
K_K19596  L_L109  L_L250  0.0256
K_K19597  L_L109  L_L251  0.0191
K_K19598  L_L109  L_L252  0.0152
K_K19599  L_L109  L_L253  0.0127
K_K19600  L_L109  L_L254  0.0109
K_K19601  L_L109  L_L255  0.0095
K_K19602  L_L109  L_L256  0.0084
K_K19603  L_L109  L_L257  0.0076
K_K19604  L_L109  L_L258  0.0069
K_K19605  L_L109  L_L259  0.0063
K_K19606  L_L109  L_L260  0.0058
K_K19607  L_L109  L_L261  0.0054
K_K19608  L_L109  L_L262  0.0051
K_K19609  L_L109  L_L263  0.0047
K_K19610  L_L109  L_L264  0.0045
K_K19611  L_L109  L_L265  0.0042
K_K19612  L_L109  L_L266  0.0040
K_K19613  L_L109  L_L267  0.0038
K_K19614  L_L109  L_L268  0.0036
K_K19615  L_L109  L_L269  0.0034
K_K19616  L_L109  L_L270  0.0033
K_K19617  L_L109  L_L271  0.0032
K_K19618  L_L109  L_L272  0.0030
K_K19619  L_L109  L_L273  0.0029
K_K19620  L_L109  L_L274  0.0028
K_K19621  L_L109  L_L275  0.0027
K_K19622  L_L109  L_L276  0.0026
* *  Branch  NTMP0000000109 - NTMP0000000110
R_R110  NTMP0000000109  nU_110  32.914993m  TC=0,0
V_Ui110  nU_110  nR_110  STIMULUS=U_IND_0000000110
R_V219  nR_110  nV_219  23.280268m  TC=0,0
L_V219  nR_110  nV_219  0.014646uH
R_V220  nV_219  nV_220  7.852787m  TC=0,0
L_V220  nV_219  nV_220  0.073723uH
L_L110  nV_220  NTMP0000000110  6.519695uH
K_K19623  L_L110  L_L111  0.1050
K_K19624  L_L110  L_L112  0.0397
K_K19625  L_L110  L_L113  0.0258
K_K19626  L_L110  L_L114  0.0192
K_K19627  L_L110  L_L115  0.0153
K_K19628  L_L110  L_L116  0.0127
K_K19629  L_L110  L_L117  0.0109
K_K19630  L_L110  L_L118  0.0095
K_K19631  L_L110  L_L119  0.0084
K_K19632  L_L110  L_L120  0.0076
K_K19633  L_L110  L_L121  0.0069
K_K19634  L_L110  L_L122  0.0063
K_K19635  L_L110  L_L123  0.0058
K_K19636  L_L110  L_L124  0.0054
K_K19637  L_L110  L_L125  0.0051
K_K19638  L_L110  L_L126  0.0047
K_K19639  L_L110  L_L127  0.0045
K_K19640  L_L110  L_L128  0.0042
K_K19641  L_L110  L_L129  0.0040
K_K19642  L_L110  L_L130  0.0038
K_K19643  L_L110  L_L131  0.0036
K_K19644  L_L110  L_L132  0.0034
K_K19645  L_L110  L_L133  0.0033
K_K19646  L_L110  L_L134  0.0032
K_K19647  L_L110  L_L135  0.0030
K_K19648  L_L110  L_L136  0.0029
K_K19649  L_L110  L_L137  0.0028
K_K19650  L_L110  L_L138  0.0027
K_K19651  L_L110  L_L173  0.0010
K_K19652  L_L110  L_L174  0.0010
K_K19653  L_L110  L_L175  0.0010
K_K19654  L_L110  L_L176  0.0011
K_K19655  L_L110  L_L177  0.0011
K_K19656  L_L110  L_L178  0.0011
K_K19657  L_L110  L_L179  0.0011
K_K19658  L_L110  L_L180  0.0011
K_K19659  L_L110  L_L181  0.0011
K_K19660  L_L110  L_L182  0.0011
K_K19661  L_L110  L_L183  0.0012
K_K19662  L_L110  L_L184  0.0012
K_K19663  L_L110  L_L185  0.0012
K_K19664  L_L110  L_L186  0.0012
K_K19665  L_L110  L_L187  0.0012
K_K19666  L_L110  L_L188  0.0013
K_K19667  L_L110  L_L189  0.0013
K_K19668  L_L110  L_L190  0.0013
K_K19669  L_L110  L_L191  0.0013
K_K19670  L_L110  L_L192  0.0014
K_K19671  L_L110  L_L193  0.0014
K_K19672  L_L110  L_L194  0.0014
K_K19673  L_L110  L_L195  0.0014
K_K19674  L_L110  L_L196  0.0015
K_K19675  L_L110  L_L197  0.0015
K_K19676  L_L110  L_L198  0.0015
K_K19677  L_L110  L_L199  0.0015
K_K19678  L_L110  L_L200  0.0016
K_K19679  L_L110  L_L201  0.0016
K_K19680  L_L110  L_L202  0.0016
K_K19681  L_L110  L_L203  0.0017
K_K19682  L_L110  L_L204  0.0017
K_K19683  L_L110  L_L205  0.0018
K_K19684  L_L110  L_L206  0.0018
K_K19685  L_L110  L_L207  0.0018
K_K19686  L_L110  L_L208  0.0019
K_K19687  L_L110  L_L209  0.0019
K_K19688  L_L110  L_L210  0.0020
K_K19689  L_L110  L_L211  0.0020
K_K19690  L_L110  L_L212  0.0021
K_K19691  L_L110  L_L213  0.0022
K_K19692  L_L110  L_L214  0.0022
K_K19693  L_L110  L_L215  0.0023
K_K19694  L_L110  L_L216  0.0024
K_K19695  L_L110  L_L217  0.0024
K_K19696  L_L110  L_L218  0.0025
K_K19697  L_L110  L_L219  0.0026
K_K19698  L_L110  L_L220  0.0027
K_K19699  L_L110  L_L221  0.0028
K_K19700  L_L110  L_L222  0.0029
K_K19701  L_L110  L_L223  0.0030
K_K19702  L_L110  L_L224  0.0032
K_K19703  L_L110  L_L225  0.0033
K_K19704  L_L110  L_L226  0.0034
K_K19705  L_L110  L_L227  0.0036
K_K19706  L_L110  L_L228  0.0038
K_K19707  L_L110  L_L229  0.0040
K_K19708  L_L110  L_L230  0.0042
K_K19709  L_L110  L_L231  0.0045
K_K19710  L_L110  L_L232  0.0047
K_K19711  L_L110  L_L233  0.0051
K_K19712  L_L110  L_L234  0.0054
K_K19713  L_L110  L_L235  0.0058
K_K19714  L_L110  L_L236  0.0063
K_K19715  L_L110  L_L237  0.0069
K_K19716  L_L110  L_L238  0.0076
K_K19717  L_L110  L_L239  0.0084
K_K19718  L_L110  L_L240  0.0095
K_K19719  L_L110  L_L241  0.0109
K_K19720  L_L110  L_L242  0.0127
K_K19721  L_L110  L_L243  0.0152
K_K19722  L_L110  L_L244  0.0191
K_K19723  L_L110  L_L245  0.0256
K_K19724  L_L110  L_L246  0.0389
K_K19725  L_L110  L_L247  0.0812
K_K19726  L_L110  L_L248  0.1569
K_K19727  L_L110  L_L249  0.0812
K_K19728  L_L110  L_L250  0.0389
K_K19729  L_L110  L_L251  0.0256
K_K19730  L_L110  L_L252  0.0191
K_K19731  L_L110  L_L253  0.0152
K_K19732  L_L110  L_L254  0.0127
K_K19733  L_L110  L_L255  0.0109
K_K19734  L_L110  L_L256  0.0095
K_K19735  L_L110  L_L257  0.0084
K_K19736  L_L110  L_L258  0.0076
K_K19737  L_L110  L_L259  0.0069
K_K19738  L_L110  L_L260  0.0063
K_K19739  L_L110  L_L261  0.0058
K_K19740  L_L110  L_L262  0.0054
K_K19741  L_L110  L_L263  0.0051
K_K19742  L_L110  L_L264  0.0047
K_K19743  L_L110  L_L265  0.0045
K_K19744  L_L110  L_L266  0.0042
K_K19745  L_L110  L_L267  0.0040
K_K19746  L_L110  L_L268  0.0038
K_K19747  L_L110  L_L269  0.0036
K_K19748  L_L110  L_L270  0.0034
K_K19749  L_L110  L_L271  0.0033
K_K19750  L_L110  L_L272  0.0032
K_K19751  L_L110  L_L273  0.0030
K_K19752  L_L110  L_L274  0.0029
K_K19753  L_L110  L_L275  0.0028
K_K19754  L_L110  L_L276  0.0027
* *  Branch  NTMP0000000110 - NTMP0000000111
R_R111  NTMP0000000110  nU_111  32.914993m  TC=0,0
V_Ui111  nU_111  nR_111  STIMULUS=U_IND_0000000111
R_V221  nR_111  nV_221  23.280268m  TC=0,0
L_V221  nR_111  nV_221  0.014646uH
R_V222  nV_221  nV_222  7.852787m  TC=0,0
L_V222  nV_221  nV_222  0.073723uH
L_L111  nV_222  NTMP0000000111  6.519695uH
K_K19755  L_L111  L_L112  0.1050
K_K19756  L_L111  L_L113  0.0397
K_K19757  L_L111  L_L114  0.0258
K_K19758  L_L111  L_L115  0.0192
K_K19759  L_L111  L_L116  0.0153
K_K19760  L_L111  L_L117  0.0127
K_K19761  L_L111  L_L118  0.0109
K_K19762  L_L111  L_L119  0.0095
K_K19763  L_L111  L_L120  0.0084
K_K19764  L_L111  L_L121  0.0076
K_K19765  L_L111  L_L122  0.0069
K_K19766  L_L111  L_L123  0.0063
K_K19767  L_L111  L_L124  0.0058
K_K19768  L_L111  L_L125  0.0054
K_K19769  L_L111  L_L126  0.0051
K_K19770  L_L111  L_L127  0.0047
K_K19771  L_L111  L_L128  0.0045
K_K19772  L_L111  L_L129  0.0042
K_K19773  L_L111  L_L130  0.0040
K_K19774  L_L111  L_L131  0.0038
K_K19775  L_L111  L_L132  0.0036
K_K19776  L_L111  L_L133  0.0034
K_K19777  L_L111  L_L134  0.0033
K_K19778  L_L111  L_L135  0.0032
K_K19779  L_L111  L_L136  0.0030
K_K19780  L_L111  L_L137  0.0029
K_K19781  L_L111  L_L138  0.0028
K_K19782  L_L111  L_L174  0.0010
K_K19783  L_L111  L_L175  0.0010
K_K19784  L_L111  L_L176  0.0010
K_K19785  L_L111  L_L177  0.0011
K_K19786  L_L111  L_L178  0.0011
K_K19787  L_L111  L_L179  0.0011
K_K19788  L_L111  L_L180  0.0011
K_K19789  L_L111  L_L181  0.0011
K_K19790  L_L111  L_L182  0.0011
K_K19791  L_L111  L_L183  0.0011
K_K19792  L_L111  L_L184  0.0012
K_K19793  L_L111  L_L185  0.0012
K_K19794  L_L111  L_L186  0.0012
K_K19795  L_L111  L_L187  0.0012
K_K19796  L_L111  L_L188  0.0012
K_K19797  L_L111  L_L189  0.0013
K_K19798  L_L111  L_L190  0.0013
K_K19799  L_L111  L_L191  0.0013
K_K19800  L_L111  L_L192  0.0013
K_K19801  L_L111  L_L193  0.0014
K_K19802  L_L111  L_L194  0.0014
K_K19803  L_L111  L_L195  0.0014
K_K19804  L_L111  L_L196  0.0014
K_K19805  L_L111  L_L197  0.0015
K_K19806  L_L111  L_L198  0.0015
K_K19807  L_L111  L_L199  0.0015
K_K19808  L_L111  L_L200  0.0015
K_K19809  L_L111  L_L201  0.0016
K_K19810  L_L111  L_L202  0.0016
K_K19811  L_L111  L_L203  0.0016
K_K19812  L_L111  L_L204  0.0017
K_K19813  L_L111  L_L205  0.0017
K_K19814  L_L111  L_L206  0.0018
K_K19815  L_L111  L_L207  0.0018
K_K19816  L_L111  L_L208  0.0018
K_K19817  L_L111  L_L209  0.0019
K_K19818  L_L111  L_L210  0.0019
K_K19819  L_L111  L_L211  0.0020
K_K19820  L_L111  L_L212  0.0020
K_K19821  L_L111  L_L213  0.0021
K_K19822  L_L111  L_L214  0.0022
K_K19823  L_L111  L_L215  0.0022
K_K19824  L_L111  L_L216  0.0023
K_K19825  L_L111  L_L217  0.0024
K_K19826  L_L111  L_L218  0.0024
K_K19827  L_L111  L_L219  0.0025
K_K19828  L_L111  L_L220  0.0026
K_K19829  L_L111  L_L221  0.0027
K_K19830  L_L111  L_L222  0.0028
K_K19831  L_L111  L_L223  0.0029
K_K19832  L_L111  L_L224  0.0030
K_K19833  L_L111  L_L225  0.0032
K_K19834  L_L111  L_L226  0.0033
K_K19835  L_L111  L_L227  0.0034
K_K19836  L_L111  L_L228  0.0036
K_K19837  L_L111  L_L229  0.0038
K_K19838  L_L111  L_L230  0.0040
K_K19839  L_L111  L_L231  0.0042
K_K19840  L_L111  L_L232  0.0045
K_K19841  L_L111  L_L233  0.0047
K_K19842  L_L111  L_L234  0.0051
K_K19843  L_L111  L_L235  0.0054
K_K19844  L_L111  L_L236  0.0058
K_K19845  L_L111  L_L237  0.0063
K_K19846  L_L111  L_L238  0.0069
K_K19847  L_L111  L_L239  0.0076
K_K19848  L_L111  L_L240  0.0084
K_K19849  L_L111  L_L241  0.0095
K_K19850  L_L111  L_L242  0.0109
K_K19851  L_L111  L_L243  0.0127
K_K19852  L_L111  L_L244  0.0152
K_K19853  L_L111  L_L245  0.0191
K_K19854  L_L111  L_L246  0.0256
K_K19855  L_L111  L_L247  0.0389
K_K19856  L_L111  L_L248  0.0812
K_K19857  L_L111  L_L249  0.1569
K_K19858  L_L111  L_L250  0.0812
K_K19859  L_L111  L_L251  0.0389
K_K19860  L_L111  L_L252  0.0256
K_K19861  L_L111  L_L253  0.0191
K_K19862  L_L111  L_L254  0.0152
K_K19863  L_L111  L_L255  0.0127
K_K19864  L_L111  L_L256  0.0109
K_K19865  L_L111  L_L257  0.0095
K_K19866  L_L111  L_L258  0.0084
K_K19867  L_L111  L_L259  0.0076
K_K19868  L_L111  L_L260  0.0069
K_K19869  L_L111  L_L261  0.0063
K_K19870  L_L111  L_L262  0.0058
K_K19871  L_L111  L_L263  0.0054
K_K19872  L_L111  L_L264  0.0051
K_K19873  L_L111  L_L265  0.0047
K_K19874  L_L111  L_L266  0.0045
K_K19875  L_L111  L_L267  0.0042
K_K19876  L_L111  L_L268  0.0040
K_K19877  L_L111  L_L269  0.0038
K_K19878  L_L111  L_L270  0.0036
K_K19879  L_L111  L_L271  0.0034
K_K19880  L_L111  L_L272  0.0033
K_K19881  L_L111  L_L273  0.0032
K_K19882  L_L111  L_L274  0.0030
K_K19883  L_L111  L_L275  0.0029
K_K19884  L_L111  L_L276  0.0028
* *  Branch  NTMP0000000111 - NTMP0000000112
R_R112  NTMP0000000111  nU_112  32.914993m  TC=0,0
V_Ui112  nU_112  nR_112  STIMULUS=U_IND_0000000112
R_V223  nR_112  nV_223  23.280268m  TC=0,0
L_V223  nR_112  nV_223  0.014646uH
R_V224  nV_223  nV_224  7.852787m  TC=0,0
L_V224  nV_223  nV_224  0.073723uH
L_L112  nV_224  NTMP0000000112  6.519695uH
K_K19885  L_L112  L_L113  0.1050
K_K19886  L_L112  L_L114  0.0397
K_K19887  L_L112  L_L115  0.0258
K_K19888  L_L112  L_L116  0.0192
K_K19889  L_L112  L_L117  0.0153
K_K19890  L_L112  L_L118  0.0127
K_K19891  L_L112  L_L119  0.0109
K_K19892  L_L112  L_L120  0.0095
K_K19893  L_L112  L_L121  0.0084
K_K19894  L_L112  L_L122  0.0076
K_K19895  L_L112  L_L123  0.0069
K_K19896  L_L112  L_L124  0.0063
K_K19897  L_L112  L_L125  0.0058
K_K19898  L_L112  L_L126  0.0054
K_K19899  L_L112  L_L127  0.0051
K_K19900  L_L112  L_L128  0.0047
K_K19901  L_L112  L_L129  0.0045
K_K19902  L_L112  L_L130  0.0042
K_K19903  L_L112  L_L131  0.0040
K_K19904  L_L112  L_L132  0.0038
K_K19905  L_L112  L_L133  0.0036
K_K19906  L_L112  L_L134  0.0034
K_K19907  L_L112  L_L135  0.0033
K_K19908  L_L112  L_L136  0.0032
K_K19909  L_L112  L_L137  0.0030
K_K19910  L_L112  L_L138  0.0029
K_K19911  L_L112  L_L175  0.0010
K_K19912  L_L112  L_L176  0.0010
K_K19913  L_L112  L_L177  0.0010
K_K19914  L_L112  L_L178  0.0011
K_K19915  L_L112  L_L179  0.0011
K_K19916  L_L112  L_L180  0.0011
K_K19917  L_L112  L_L181  0.0011
K_K19918  L_L112  L_L182  0.0011
K_K19919  L_L112  L_L183  0.0011
K_K19920  L_L112  L_L184  0.0011
K_K19921  L_L112  L_L185  0.0012
K_K19922  L_L112  L_L186  0.0012
K_K19923  L_L112  L_L187  0.0012
K_K19924  L_L112  L_L188  0.0012
K_K19925  L_L112  L_L189  0.0012
K_K19926  L_L112  L_L190  0.0013
K_K19927  L_L112  L_L191  0.0013
K_K19928  L_L112  L_L192  0.0013
K_K19929  L_L112  L_L193  0.0013
K_K19930  L_L112  L_L194  0.0014
K_K19931  L_L112  L_L195  0.0014
K_K19932  L_L112  L_L196  0.0014
K_K19933  L_L112  L_L197  0.0014
K_K19934  L_L112  L_L198  0.0015
K_K19935  L_L112  L_L199  0.0015
K_K19936  L_L112  L_L200  0.0015
K_K19937  L_L112  L_L201  0.0015
K_K19938  L_L112  L_L202  0.0016
K_K19939  L_L112  L_L203  0.0016
K_K19940  L_L112  L_L204  0.0016
K_K19941  L_L112  L_L205  0.0017
K_K19942  L_L112  L_L206  0.0017
K_K19943  L_L112  L_L207  0.0018
K_K19944  L_L112  L_L208  0.0018
K_K19945  L_L112  L_L209  0.0018
K_K19946  L_L112  L_L210  0.0019
K_K19947  L_L112  L_L211  0.0019
K_K19948  L_L112  L_L212  0.0020
K_K19949  L_L112  L_L213  0.0020
K_K19950  L_L112  L_L214  0.0021
K_K19951  L_L112  L_L215  0.0022
K_K19952  L_L112  L_L216  0.0022
K_K19953  L_L112  L_L217  0.0023
K_K19954  L_L112  L_L218  0.0024
K_K19955  L_L112  L_L219  0.0024
K_K19956  L_L112  L_L220  0.0025
K_K19957  L_L112  L_L221  0.0026
K_K19958  L_L112  L_L222  0.0027
K_K19959  L_L112  L_L223  0.0028
K_K19960  L_L112  L_L224  0.0029
K_K19961  L_L112  L_L225  0.0030
K_K19962  L_L112  L_L226  0.0032
K_K19963  L_L112  L_L227  0.0033
K_K19964  L_L112  L_L228  0.0034
K_K19965  L_L112  L_L229  0.0036
K_K19966  L_L112  L_L230  0.0038
K_K19967  L_L112  L_L231  0.0040
K_K19968  L_L112  L_L232  0.0042
K_K19969  L_L112  L_L233  0.0045
K_K19970  L_L112  L_L234  0.0047
K_K19971  L_L112  L_L235  0.0051
K_K19972  L_L112  L_L236  0.0054
K_K19973  L_L112  L_L237  0.0058
K_K19974  L_L112  L_L238  0.0063
K_K19975  L_L112  L_L239  0.0069
K_K19976  L_L112  L_L240  0.0076
K_K19977  L_L112  L_L241  0.0084
K_K19978  L_L112  L_L242  0.0095
K_K19979  L_L112  L_L243  0.0109
K_K19980  L_L112  L_L244  0.0127
K_K19981  L_L112  L_L245  0.0152
K_K19982  L_L112  L_L246  0.0191
K_K19983  L_L112  L_L247  0.0256
K_K19984  L_L112  L_L248  0.0389
K_K19985  L_L112  L_L249  0.0812
K_K19986  L_L112  L_L250  0.1569
K_K19987  L_L112  L_L251  0.0812
K_K19988  L_L112  L_L252  0.0389
K_K19989  L_L112  L_L253  0.0256
K_K19990  L_L112  L_L254  0.0191
K_K19991  L_L112  L_L255  0.0152
K_K19992  L_L112  L_L256  0.0127
K_K19993  L_L112  L_L257  0.0109
K_K19994  L_L112  L_L258  0.0095
K_K19995  L_L112  L_L259  0.0084
K_K19996  L_L112  L_L260  0.0076
K_K19997  L_L112  L_L261  0.0069
K_K19998  L_L112  L_L262  0.0063
K_K19999  L_L112  L_L263  0.0058
K_K20000  L_L112  L_L264  0.0054
K_K20001  L_L112  L_L265  0.0051
K_K20002  L_L112  L_L266  0.0047
K_K20003  L_L112  L_L267  0.0045
K_K20004  L_L112  L_L268  0.0042
K_K20005  L_L112  L_L269  0.0040
K_K20006  L_L112  L_L270  0.0038
K_K20007  L_L112  L_L271  0.0036
K_K20008  L_L112  L_L272  0.0034
K_K20009  L_L112  L_L273  0.0033
K_K20010  L_L112  L_L274  0.0032
K_K20011  L_L112  L_L275  0.0030
K_K20012  L_L112  L_L276  0.0029
* *  Branch  NTMP0000000112 - NTMP0000000113
R_R113  NTMP0000000112  nU_113  32.914993m  TC=0,0
V_Ui113  nU_113  nR_113  STIMULUS=U_IND_0000000113
R_V225  nR_113  nV_225  23.280268m  TC=0,0
L_V225  nR_113  nV_225  0.014646uH
R_V226  nV_225  nV_226  7.852787m  TC=0,0
L_V226  nV_225  nV_226  0.073723uH
L_L113  nV_226  NTMP0000000113  6.519695uH
K_K20013  L_L113  L_L114  0.1050
K_K20014  L_L113  L_L115  0.0397
K_K20015  L_L113  L_L116  0.0258
K_K20016  L_L113  L_L117  0.0192
K_K20017  L_L113  L_L118  0.0153
K_K20018  L_L113  L_L119  0.0127
K_K20019  L_L113  L_L120  0.0109
K_K20020  L_L113  L_L121  0.0095
K_K20021  L_L113  L_L122  0.0084
K_K20022  L_L113  L_L123  0.0076
K_K20023  L_L113  L_L124  0.0069
K_K20024  L_L113  L_L125  0.0063
K_K20025  L_L113  L_L126  0.0058
K_K20026  L_L113  L_L127  0.0054
K_K20027  L_L113  L_L128  0.0051
K_K20028  L_L113  L_L129  0.0047
K_K20029  L_L113  L_L130  0.0045
K_K20030  L_L113  L_L131  0.0042
K_K20031  L_L113  L_L132  0.0040
K_K20032  L_L113  L_L133  0.0038
K_K20033  L_L113  L_L134  0.0036
K_K20034  L_L113  L_L135  0.0034
K_K20035  L_L113  L_L136  0.0033
K_K20036  L_L113  L_L137  0.0032
K_K20037  L_L113  L_L138  0.0030
K_K20038  L_L113  L_L176  0.0010
K_K20039  L_L113  L_L177  0.0010
K_K20040  L_L113  L_L178  0.0010
K_K20041  L_L113  L_L179  0.0011
K_K20042  L_L113  L_L180  0.0011
K_K20043  L_L113  L_L181  0.0011
K_K20044  L_L113  L_L182  0.0011
K_K20045  L_L113  L_L183  0.0011
K_K20046  L_L113  L_L184  0.0011
K_K20047  L_L113  L_L185  0.0011
K_K20048  L_L113  L_L186  0.0012
K_K20049  L_L113  L_L187  0.0012
K_K20050  L_L113  L_L188  0.0012
K_K20051  L_L113  L_L189  0.0012
K_K20052  L_L113  L_L190  0.0012
K_K20053  L_L113  L_L191  0.0013
K_K20054  L_L113  L_L192  0.0013
K_K20055  L_L113  L_L193  0.0013
K_K20056  L_L113  L_L194  0.0013
K_K20057  L_L113  L_L195  0.0014
K_K20058  L_L113  L_L196  0.0014
K_K20059  L_L113  L_L197  0.0014
K_K20060  L_L113  L_L198  0.0014
K_K20061  L_L113  L_L199  0.0015
K_K20062  L_L113  L_L200  0.0015
K_K20063  L_L113  L_L201  0.0015
K_K20064  L_L113  L_L202  0.0015
K_K20065  L_L113  L_L203  0.0016
K_K20066  L_L113  L_L204  0.0016
K_K20067  L_L113  L_L205  0.0016
K_K20068  L_L113  L_L206  0.0017
K_K20069  L_L113  L_L207  0.0017
K_K20070  L_L113  L_L208  0.0018
K_K20071  L_L113  L_L209  0.0018
K_K20072  L_L113  L_L210  0.0018
K_K20073  L_L113  L_L211  0.0019
K_K20074  L_L113  L_L212  0.0019
K_K20075  L_L113  L_L213  0.0020
K_K20076  L_L113  L_L214  0.0020
K_K20077  L_L113  L_L215  0.0021
K_K20078  L_L113  L_L216  0.0022
K_K20079  L_L113  L_L217  0.0022
K_K20080  L_L113  L_L218  0.0023
K_K20081  L_L113  L_L219  0.0024
K_K20082  L_L113  L_L220  0.0024
K_K20083  L_L113  L_L221  0.0025
K_K20084  L_L113  L_L222  0.0026
K_K20085  L_L113  L_L223  0.0027
K_K20086  L_L113  L_L224  0.0028
K_K20087  L_L113  L_L225  0.0029
K_K20088  L_L113  L_L226  0.0030
K_K20089  L_L113  L_L227  0.0032
K_K20090  L_L113  L_L228  0.0033
K_K20091  L_L113  L_L229  0.0034
K_K20092  L_L113  L_L230  0.0036
K_K20093  L_L113  L_L231  0.0038
K_K20094  L_L113  L_L232  0.0040
K_K20095  L_L113  L_L233  0.0042
K_K20096  L_L113  L_L234  0.0045
K_K20097  L_L113  L_L235  0.0047
K_K20098  L_L113  L_L236  0.0051
K_K20099  L_L113  L_L237  0.0054
K_K20100  L_L113  L_L238  0.0058
K_K20101  L_L113  L_L239  0.0063
K_K20102  L_L113  L_L240  0.0069
K_K20103  L_L113  L_L241  0.0076
K_K20104  L_L113  L_L242  0.0084
K_K20105  L_L113  L_L243  0.0095
K_K20106  L_L113  L_L244  0.0109
K_K20107  L_L113  L_L245  0.0127
K_K20108  L_L113  L_L246  0.0152
K_K20109  L_L113  L_L247  0.0191
K_K20110  L_L113  L_L248  0.0256
K_K20111  L_L113  L_L249  0.0389
K_K20112  L_L113  L_L250  0.0812
K_K20113  L_L113  L_L251  0.1569
K_K20114  L_L113  L_L252  0.0812
K_K20115  L_L113  L_L253  0.0389
K_K20116  L_L113  L_L254  0.0256
K_K20117  L_L113  L_L255  0.0191
K_K20118  L_L113  L_L256  0.0152
K_K20119  L_L113  L_L257  0.0127
K_K20120  L_L113  L_L258  0.0109
K_K20121  L_L113  L_L259  0.0095
K_K20122  L_L113  L_L260  0.0084
K_K20123  L_L113  L_L261  0.0076
K_K20124  L_L113  L_L262  0.0069
K_K20125  L_L113  L_L263  0.0063
K_K20126  L_L113  L_L264  0.0058
K_K20127  L_L113  L_L265  0.0054
K_K20128  L_L113  L_L266  0.0051
K_K20129  L_L113  L_L267  0.0047
K_K20130  L_L113  L_L268  0.0045
K_K20131  L_L113  L_L269  0.0042
K_K20132  L_L113  L_L270  0.0040
K_K20133  L_L113  L_L271  0.0038
K_K20134  L_L113  L_L272  0.0036
K_K20135  L_L113  L_L273  0.0034
K_K20136  L_L113  L_L274  0.0033
K_K20137  L_L113  L_L275  0.0032
K_K20138  L_L113  L_L276  0.0030
* *  Branch  NTMP0000000113 - NTMP0000000114
R_R114  NTMP0000000113  nU_114  32.914993m  TC=0,0
V_Ui114  nU_114  nR_114  STIMULUS=U_IND_0000000114
R_V227  nR_114  nV_227  23.280268m  TC=0,0
L_V227  nR_114  nV_227  0.014646uH
R_V228  nV_227  nV_228  7.852787m  TC=0,0
L_V228  nV_227  nV_228  0.073723uH
L_L114  nV_228  NTMP0000000114  6.519695uH
K_K20139  L_L114  L_L115  0.1050
K_K20140  L_L114  L_L116  0.0397
K_K20141  L_L114  L_L117  0.0258
K_K20142  L_L114  L_L118  0.0192
K_K20143  L_L114  L_L119  0.0153
K_K20144  L_L114  L_L120  0.0127
K_K20145  L_L114  L_L121  0.0109
K_K20146  L_L114  L_L122  0.0095
K_K20147  L_L114  L_L123  0.0084
K_K20148  L_L114  L_L124  0.0076
K_K20149  L_L114  L_L125  0.0069
K_K20150  L_L114  L_L126  0.0063
K_K20151  L_L114  L_L127  0.0058
K_K20152  L_L114  L_L128  0.0054
K_K20153  L_L114  L_L129  0.0051
K_K20154  L_L114  L_L130  0.0047
K_K20155  L_L114  L_L131  0.0045
K_K20156  L_L114  L_L132  0.0042
K_K20157  L_L114  L_L133  0.0040
K_K20158  L_L114  L_L134  0.0038
K_K20159  L_L114  L_L135  0.0036
K_K20160  L_L114  L_L136  0.0034
K_K20161  L_L114  L_L137  0.0033
K_K20162  L_L114  L_L138  0.0032
K_K20163  L_L114  L_L177  0.0010
K_K20164  L_L114  L_L178  0.0010
K_K20165  L_L114  L_L179  0.0010
K_K20166  L_L114  L_L180  0.0011
K_K20167  L_L114  L_L181  0.0011
K_K20168  L_L114  L_L182  0.0011
K_K20169  L_L114  L_L183  0.0011
K_K20170  L_L114  L_L184  0.0011
K_K20171  L_L114  L_L185  0.0011
K_K20172  L_L114  L_L186  0.0011
K_K20173  L_L114  L_L187  0.0012
K_K20174  L_L114  L_L188  0.0012
K_K20175  L_L114  L_L189  0.0012
K_K20176  L_L114  L_L190  0.0012
K_K20177  L_L114  L_L191  0.0012
K_K20178  L_L114  L_L192  0.0013
K_K20179  L_L114  L_L193  0.0013
K_K20180  L_L114  L_L194  0.0013
K_K20181  L_L114  L_L195  0.0013
K_K20182  L_L114  L_L196  0.0014
K_K20183  L_L114  L_L197  0.0014
K_K20184  L_L114  L_L198  0.0014
K_K20185  L_L114  L_L199  0.0014
K_K20186  L_L114  L_L200  0.0015
K_K20187  L_L114  L_L201  0.0015
K_K20188  L_L114  L_L202  0.0015
K_K20189  L_L114  L_L203  0.0015
K_K20190  L_L114  L_L204  0.0016
K_K20191  L_L114  L_L205  0.0016
K_K20192  L_L114  L_L206  0.0016
K_K20193  L_L114  L_L207  0.0017
K_K20194  L_L114  L_L208  0.0017
K_K20195  L_L114  L_L209  0.0018
K_K20196  L_L114  L_L210  0.0018
K_K20197  L_L114  L_L211  0.0018
K_K20198  L_L114  L_L212  0.0019
K_K20199  L_L114  L_L213  0.0019
K_K20200  L_L114  L_L214  0.0020
K_K20201  L_L114  L_L215  0.0020
K_K20202  L_L114  L_L216  0.0021
K_K20203  L_L114  L_L217  0.0022
K_K20204  L_L114  L_L218  0.0022
K_K20205  L_L114  L_L219  0.0023
K_K20206  L_L114  L_L220  0.0024
K_K20207  L_L114  L_L221  0.0024
K_K20208  L_L114  L_L222  0.0025
K_K20209  L_L114  L_L223  0.0026
K_K20210  L_L114  L_L224  0.0027
K_K20211  L_L114  L_L225  0.0028
K_K20212  L_L114  L_L226  0.0029
K_K20213  L_L114  L_L227  0.0030
K_K20214  L_L114  L_L228  0.0032
K_K20215  L_L114  L_L229  0.0033
K_K20216  L_L114  L_L230  0.0034
K_K20217  L_L114  L_L231  0.0036
K_K20218  L_L114  L_L232  0.0038
K_K20219  L_L114  L_L233  0.0040
K_K20220  L_L114  L_L234  0.0042
K_K20221  L_L114  L_L235  0.0045
K_K20222  L_L114  L_L236  0.0047
K_K20223  L_L114  L_L237  0.0051
K_K20224  L_L114  L_L238  0.0054
K_K20225  L_L114  L_L239  0.0058
K_K20226  L_L114  L_L240  0.0063
K_K20227  L_L114  L_L241  0.0069
K_K20228  L_L114  L_L242  0.0076
K_K20229  L_L114  L_L243  0.0084
K_K20230  L_L114  L_L244  0.0095
K_K20231  L_L114  L_L245  0.0109
K_K20232  L_L114  L_L246  0.0127
K_K20233  L_L114  L_L247  0.0152
K_K20234  L_L114  L_L248  0.0191
K_K20235  L_L114  L_L249  0.0256
K_K20236  L_L114  L_L250  0.0389
K_K20237  L_L114  L_L251  0.0812
K_K20238  L_L114  L_L252  0.1569
K_K20239  L_L114  L_L253  0.0812
K_K20240  L_L114  L_L254  0.0389
K_K20241  L_L114  L_L255  0.0256
K_K20242  L_L114  L_L256  0.0191
K_K20243  L_L114  L_L257  0.0152
K_K20244  L_L114  L_L258  0.0127
K_K20245  L_L114  L_L259  0.0109
K_K20246  L_L114  L_L260  0.0095
K_K20247  L_L114  L_L261  0.0084
K_K20248  L_L114  L_L262  0.0076
K_K20249  L_L114  L_L263  0.0069
K_K20250  L_L114  L_L264  0.0063
K_K20251  L_L114  L_L265  0.0058
K_K20252  L_L114  L_L266  0.0054
K_K20253  L_L114  L_L267  0.0051
K_K20254  L_L114  L_L268  0.0047
K_K20255  L_L114  L_L269  0.0045
K_K20256  L_L114  L_L270  0.0042
K_K20257  L_L114  L_L271  0.0040
K_K20258  L_L114  L_L272  0.0038
K_K20259  L_L114  L_L273  0.0036
K_K20260  L_L114  L_L274  0.0034
K_K20261  L_L114  L_L275  0.0033
K_K20262  L_L114  L_L276  0.0032
* *  Branch  NTMP0000000114 - NTMP0000000115
R_R115  NTMP0000000114  nU_115  32.914993m  TC=0,0
V_Ui115  nU_115  nR_115  STIMULUS=U_IND_0000000115
R_V229  nR_115  nV_229  23.280268m  TC=0,0
L_V229  nR_115  nV_229  0.014646uH
R_V230  nV_229  nV_230  7.852787m  TC=0,0
L_V230  nV_229  nV_230  0.073723uH
L_L115  nV_230  NTMP0000000115  6.519695uH
K_K20263  L_L115  L_L116  0.1050
K_K20264  L_L115  L_L117  0.0397
K_K20265  L_L115  L_L118  0.0258
K_K20266  L_L115  L_L119  0.0192
K_K20267  L_L115  L_L120  0.0153
K_K20268  L_L115  L_L121  0.0127
K_K20269  L_L115  L_L122  0.0109
K_K20270  L_L115  L_L123  0.0095
K_K20271  L_L115  L_L124  0.0084
K_K20272  L_L115  L_L125  0.0076
K_K20273  L_L115  L_L126  0.0069
K_K20274  L_L115  L_L127  0.0063
K_K20275  L_L115  L_L128  0.0058
K_K20276  L_L115  L_L129  0.0054
K_K20277  L_L115  L_L130  0.0051
K_K20278  L_L115  L_L131  0.0047
K_K20279  L_L115  L_L132  0.0045
K_K20280  L_L115  L_L133  0.0042
K_K20281  L_L115  L_L134  0.0040
K_K20282  L_L115  L_L135  0.0038
K_K20283  L_L115  L_L136  0.0036
K_K20284  L_L115  L_L137  0.0034
K_K20285  L_L115  L_L138  0.0033
K_K20286  L_L115  L_L178  0.0010
K_K20287  L_L115  L_L179  0.0010
K_K20288  L_L115  L_L180  0.0010
K_K20289  L_L115  L_L181  0.0011
K_K20290  L_L115  L_L182  0.0011
K_K20291  L_L115  L_L183  0.0011
K_K20292  L_L115  L_L184  0.0011
K_K20293  L_L115  L_L185  0.0011
K_K20294  L_L115  L_L186  0.0011
K_K20295  L_L115  L_L187  0.0011
K_K20296  L_L115  L_L188  0.0012
K_K20297  L_L115  L_L189  0.0012
K_K20298  L_L115  L_L190  0.0012
K_K20299  L_L115  L_L191  0.0012
K_K20300  L_L115  L_L192  0.0012
K_K20301  L_L115  L_L193  0.0013
K_K20302  L_L115  L_L194  0.0013
K_K20303  L_L115  L_L195  0.0013
K_K20304  L_L115  L_L196  0.0013
K_K20305  L_L115  L_L197  0.0014
K_K20306  L_L115  L_L198  0.0014
K_K20307  L_L115  L_L199  0.0014
K_K20308  L_L115  L_L200  0.0014
K_K20309  L_L115  L_L201  0.0015
K_K20310  L_L115  L_L202  0.0015
K_K20311  L_L115  L_L203  0.0015
K_K20312  L_L115  L_L204  0.0015
K_K20313  L_L115  L_L205  0.0016
K_K20314  L_L115  L_L206  0.0016
K_K20315  L_L115  L_L207  0.0016
K_K20316  L_L115  L_L208  0.0017
K_K20317  L_L115  L_L209  0.0017
K_K20318  L_L115  L_L210  0.0018
K_K20319  L_L115  L_L211  0.0018
K_K20320  L_L115  L_L212  0.0018
K_K20321  L_L115  L_L213  0.0019
K_K20322  L_L115  L_L214  0.0019
K_K20323  L_L115  L_L215  0.0020
K_K20324  L_L115  L_L216  0.0020
K_K20325  L_L115  L_L217  0.0021
K_K20326  L_L115  L_L218  0.0022
K_K20327  L_L115  L_L219  0.0022
K_K20328  L_L115  L_L220  0.0023
K_K20329  L_L115  L_L221  0.0024
K_K20330  L_L115  L_L222  0.0024
K_K20331  L_L115  L_L223  0.0025
K_K20332  L_L115  L_L224  0.0026
K_K20333  L_L115  L_L225  0.0027
K_K20334  L_L115  L_L226  0.0028
K_K20335  L_L115  L_L227  0.0029
K_K20336  L_L115  L_L228  0.0030
K_K20337  L_L115  L_L229  0.0032
K_K20338  L_L115  L_L230  0.0033
K_K20339  L_L115  L_L231  0.0034
K_K20340  L_L115  L_L232  0.0036
K_K20341  L_L115  L_L233  0.0038
K_K20342  L_L115  L_L234  0.0040
K_K20343  L_L115  L_L235  0.0042
K_K20344  L_L115  L_L236  0.0045
K_K20345  L_L115  L_L237  0.0047
K_K20346  L_L115  L_L238  0.0051
K_K20347  L_L115  L_L239  0.0054
K_K20348  L_L115  L_L240  0.0058
K_K20349  L_L115  L_L241  0.0063
K_K20350  L_L115  L_L242  0.0069
K_K20351  L_L115  L_L243  0.0076
K_K20352  L_L115  L_L244  0.0084
K_K20353  L_L115  L_L245  0.0095
K_K20354  L_L115  L_L246  0.0109
K_K20355  L_L115  L_L247  0.0127
K_K20356  L_L115  L_L248  0.0152
K_K20357  L_L115  L_L249  0.0191
K_K20358  L_L115  L_L250  0.0256
K_K20359  L_L115  L_L251  0.0389
K_K20360  L_L115  L_L252  0.0812
K_K20361  L_L115  L_L253  0.1569
K_K20362  L_L115  L_L254  0.0812
K_K20363  L_L115  L_L255  0.0389
K_K20364  L_L115  L_L256  0.0256
K_K20365  L_L115  L_L257  0.0191
K_K20366  L_L115  L_L258  0.0152
K_K20367  L_L115  L_L259  0.0127
K_K20368  L_L115  L_L260  0.0109
K_K20369  L_L115  L_L261  0.0095
K_K20370  L_L115  L_L262  0.0084
K_K20371  L_L115  L_L263  0.0076
K_K20372  L_L115  L_L264  0.0069
K_K20373  L_L115  L_L265  0.0063
K_K20374  L_L115  L_L266  0.0058
K_K20375  L_L115  L_L267  0.0054
K_K20376  L_L115  L_L268  0.0051
K_K20377  L_L115  L_L269  0.0047
K_K20378  L_L115  L_L270  0.0045
K_K20379  L_L115  L_L271  0.0042
K_K20380  L_L115  L_L272  0.0040
K_K20381  L_L115  L_L273  0.0038
K_K20382  L_L115  L_L274  0.0036
K_K20383  L_L115  L_L275  0.0034
K_K20384  L_L115  L_L276  0.0033
* *  Branch  NTMP0000000115 - NTMP0000000116
R_R116  NTMP0000000115  nU_116  32.914993m  TC=0,0
V_Ui116  nU_116  nR_116  STIMULUS=U_IND_0000000116
R_V231  nR_116  nV_231  23.280268m  TC=0,0
L_V231  nR_116  nV_231  0.014646uH
R_V232  nV_231  nV_232  7.852787m  TC=0,0
L_V232  nV_231  nV_232  0.073723uH
L_L116  nV_232  NTMP0000000116  6.519695uH
K_K20385  L_L116  L_L117  0.1050
K_K20386  L_L116  L_L118  0.0397
K_K20387  L_L116  L_L119  0.0258
K_K20388  L_L116  L_L120  0.0192
K_K20389  L_L116  L_L121  0.0153
K_K20390  L_L116  L_L122  0.0127
K_K20391  L_L116  L_L123  0.0109
K_K20392  L_L116  L_L124  0.0095
K_K20393  L_L116  L_L125  0.0084
K_K20394  L_L116  L_L126  0.0076
K_K20395  L_L116  L_L127  0.0069
K_K20396  L_L116  L_L128  0.0063
K_K20397  L_L116  L_L129  0.0058
K_K20398  L_L116  L_L130  0.0054
K_K20399  L_L116  L_L131  0.0051
K_K20400  L_L116  L_L132  0.0047
K_K20401  L_L116  L_L133  0.0045
K_K20402  L_L116  L_L134  0.0042
K_K20403  L_L116  L_L135  0.0040
K_K20404  L_L116  L_L136  0.0038
K_K20405  L_L116  L_L137  0.0036
K_K20406  L_L116  L_L138  0.0034
K_K20407  L_L116  L_L179  0.0010
K_K20408  L_L116  L_L180  0.0010
K_K20409  L_L116  L_L181  0.0010
K_K20410  L_L116  L_L182  0.0011
K_K20411  L_L116  L_L183  0.0011
K_K20412  L_L116  L_L184  0.0011
K_K20413  L_L116  L_L185  0.0011
K_K20414  L_L116  L_L186  0.0011
K_K20415  L_L116  L_L187  0.0011
K_K20416  L_L116  L_L188  0.0011
K_K20417  L_L116  L_L189  0.0012
K_K20418  L_L116  L_L190  0.0012
K_K20419  L_L116  L_L191  0.0012
K_K20420  L_L116  L_L192  0.0012
K_K20421  L_L116  L_L193  0.0012
K_K20422  L_L116  L_L194  0.0013
K_K20423  L_L116  L_L195  0.0013
K_K20424  L_L116  L_L196  0.0013
K_K20425  L_L116  L_L197  0.0013
K_K20426  L_L116  L_L198  0.0014
K_K20427  L_L116  L_L199  0.0014
K_K20428  L_L116  L_L200  0.0014
K_K20429  L_L116  L_L201  0.0014
K_K20430  L_L116  L_L202  0.0015
K_K20431  L_L116  L_L203  0.0015
K_K20432  L_L116  L_L204  0.0015
K_K20433  L_L116  L_L205  0.0015
K_K20434  L_L116  L_L206  0.0016
K_K20435  L_L116  L_L207  0.0016
K_K20436  L_L116  L_L208  0.0016
K_K20437  L_L116  L_L209  0.0017
K_K20438  L_L116  L_L210  0.0017
K_K20439  L_L116  L_L211  0.0018
K_K20440  L_L116  L_L212  0.0018
K_K20441  L_L116  L_L213  0.0018
K_K20442  L_L116  L_L214  0.0019
K_K20443  L_L116  L_L215  0.0019
K_K20444  L_L116  L_L216  0.0020
K_K20445  L_L116  L_L217  0.0020
K_K20446  L_L116  L_L218  0.0021
K_K20447  L_L116  L_L219  0.0022
K_K20448  L_L116  L_L220  0.0022
K_K20449  L_L116  L_L221  0.0023
K_K20450  L_L116  L_L222  0.0024
K_K20451  L_L116  L_L223  0.0024
K_K20452  L_L116  L_L224  0.0025
K_K20453  L_L116  L_L225  0.0026
K_K20454  L_L116  L_L226  0.0027
K_K20455  L_L116  L_L227  0.0028
K_K20456  L_L116  L_L228  0.0029
K_K20457  L_L116  L_L229  0.0030
K_K20458  L_L116  L_L230  0.0032
K_K20459  L_L116  L_L231  0.0033
K_K20460  L_L116  L_L232  0.0034
K_K20461  L_L116  L_L233  0.0036
K_K20462  L_L116  L_L234  0.0038
K_K20463  L_L116  L_L235  0.0040
K_K20464  L_L116  L_L236  0.0042
K_K20465  L_L116  L_L237  0.0045
K_K20466  L_L116  L_L238  0.0047
K_K20467  L_L116  L_L239  0.0051
K_K20468  L_L116  L_L240  0.0054
K_K20469  L_L116  L_L241  0.0058
K_K20470  L_L116  L_L242  0.0063
K_K20471  L_L116  L_L243  0.0069
K_K20472  L_L116  L_L244  0.0076
K_K20473  L_L116  L_L245  0.0084
K_K20474  L_L116  L_L246  0.0095
K_K20475  L_L116  L_L247  0.0109
K_K20476  L_L116  L_L248  0.0127
K_K20477  L_L116  L_L249  0.0152
K_K20478  L_L116  L_L250  0.0191
K_K20479  L_L116  L_L251  0.0256
K_K20480  L_L116  L_L252  0.0389
K_K20481  L_L116  L_L253  0.0812
K_K20482  L_L116  L_L254  0.1569
K_K20483  L_L116  L_L255  0.0812
K_K20484  L_L116  L_L256  0.0389
K_K20485  L_L116  L_L257  0.0256
K_K20486  L_L116  L_L258  0.0191
K_K20487  L_L116  L_L259  0.0152
K_K20488  L_L116  L_L260  0.0127
K_K20489  L_L116  L_L261  0.0109
K_K20490  L_L116  L_L262  0.0095
K_K20491  L_L116  L_L263  0.0084
K_K20492  L_L116  L_L264  0.0076
K_K20493  L_L116  L_L265  0.0069
K_K20494  L_L116  L_L266  0.0063
K_K20495  L_L116  L_L267  0.0058
K_K20496  L_L116  L_L268  0.0054
K_K20497  L_L116  L_L269  0.0051
K_K20498  L_L116  L_L270  0.0047
K_K20499  L_L116  L_L271  0.0045
K_K20500  L_L116  L_L272  0.0042
K_K20501  L_L116  L_L273  0.0040
K_K20502  L_L116  L_L274  0.0038
K_K20503  L_L116  L_L275  0.0036
K_K20504  L_L116  L_L276  0.0034
* *  Branch  NTMP0000000116 - NTMP0000000117
R_R117  NTMP0000000116  nU_117  32.914993m  TC=0,0
V_Ui117  nU_117  nR_117  STIMULUS=U_IND_0000000117
R_V233  nR_117  nV_233  23.280268m  TC=0,0
L_V233  nR_117  nV_233  0.014646uH
R_V234  nV_233  nV_234  7.852787m  TC=0,0
L_V234  nV_233  nV_234  0.073723uH
L_L117  nV_234  NTMP0000000117  6.519695uH
K_K20505  L_L117  L_L118  0.1050
K_K20506  L_L117  L_L119  0.0397
K_K20507  L_L117  L_L120  0.0258
K_K20508  L_L117  L_L121  0.0192
K_K20509  L_L117  L_L122  0.0153
K_K20510  L_L117  L_L123  0.0127
K_K20511  L_L117  L_L124  0.0109
K_K20512  L_L117  L_L125  0.0095
K_K20513  L_L117  L_L126  0.0084
K_K20514  L_L117  L_L127  0.0076
K_K20515  L_L117  L_L128  0.0069
K_K20516  L_L117  L_L129  0.0063
K_K20517  L_L117  L_L130  0.0058
K_K20518  L_L117  L_L131  0.0054
K_K20519  L_L117  L_L132  0.0051
K_K20520  L_L117  L_L133  0.0047
K_K20521  L_L117  L_L134  0.0045
K_K20522  L_L117  L_L135  0.0042
K_K20523  L_L117  L_L136  0.0040
K_K20524  L_L117  L_L137  0.0038
K_K20525  L_L117  L_L138  0.0036
K_K20526  L_L117  L_L180  0.0010
K_K20527  L_L117  L_L181  0.0010
K_K20528  L_L117  L_L182  0.0010
K_K20529  L_L117  L_L183  0.0011
K_K20530  L_L117  L_L184  0.0011
K_K20531  L_L117  L_L185  0.0011
K_K20532  L_L117  L_L186  0.0011
K_K20533  L_L117  L_L187  0.0011
K_K20534  L_L117  L_L188  0.0011
K_K20535  L_L117  L_L189  0.0011
K_K20536  L_L117  L_L190  0.0012
K_K20537  L_L117  L_L191  0.0012
K_K20538  L_L117  L_L192  0.0012
K_K20539  L_L117  L_L193  0.0012
K_K20540  L_L117  L_L194  0.0012
K_K20541  L_L117  L_L195  0.0013
K_K20542  L_L117  L_L196  0.0013
K_K20543  L_L117  L_L197  0.0013
K_K20544  L_L117  L_L198  0.0013
K_K20545  L_L117  L_L199  0.0014
K_K20546  L_L117  L_L200  0.0014
K_K20547  L_L117  L_L201  0.0014
K_K20548  L_L117  L_L202  0.0014
K_K20549  L_L117  L_L203  0.0015
K_K20550  L_L117  L_L204  0.0015
K_K20551  L_L117  L_L205  0.0015
K_K20552  L_L117  L_L206  0.0015
K_K20553  L_L117  L_L207  0.0016
K_K20554  L_L117  L_L208  0.0016
K_K20555  L_L117  L_L209  0.0016
K_K20556  L_L117  L_L210  0.0017
K_K20557  L_L117  L_L211  0.0017
K_K20558  L_L117  L_L212  0.0018
K_K20559  L_L117  L_L213  0.0018
K_K20560  L_L117  L_L214  0.0018
K_K20561  L_L117  L_L215  0.0019
K_K20562  L_L117  L_L216  0.0019
K_K20563  L_L117  L_L217  0.0020
K_K20564  L_L117  L_L218  0.0020
K_K20565  L_L117  L_L219  0.0021
K_K20566  L_L117  L_L220  0.0022
K_K20567  L_L117  L_L221  0.0022
K_K20568  L_L117  L_L222  0.0023
K_K20569  L_L117  L_L223  0.0024
K_K20570  L_L117  L_L224  0.0024
K_K20571  L_L117  L_L225  0.0025
K_K20572  L_L117  L_L226  0.0026
K_K20573  L_L117  L_L227  0.0027
K_K20574  L_L117  L_L228  0.0028
K_K20575  L_L117  L_L229  0.0029
K_K20576  L_L117  L_L230  0.0030
K_K20577  L_L117  L_L231  0.0032
K_K20578  L_L117  L_L232  0.0033
K_K20579  L_L117  L_L233  0.0034
K_K20580  L_L117  L_L234  0.0036
K_K20581  L_L117  L_L235  0.0038
K_K20582  L_L117  L_L236  0.0040
K_K20583  L_L117  L_L237  0.0042
K_K20584  L_L117  L_L238  0.0045
K_K20585  L_L117  L_L239  0.0047
K_K20586  L_L117  L_L240  0.0051
K_K20587  L_L117  L_L241  0.0054
K_K20588  L_L117  L_L242  0.0058
K_K20589  L_L117  L_L243  0.0063
K_K20590  L_L117  L_L244  0.0069
K_K20591  L_L117  L_L245  0.0076
K_K20592  L_L117  L_L246  0.0084
K_K20593  L_L117  L_L247  0.0095
K_K20594  L_L117  L_L248  0.0109
K_K20595  L_L117  L_L249  0.0127
K_K20596  L_L117  L_L250  0.0152
K_K20597  L_L117  L_L251  0.0191
K_K20598  L_L117  L_L252  0.0256
K_K20599  L_L117  L_L253  0.0389
K_K20600  L_L117  L_L254  0.0812
K_K20601  L_L117  L_L255  0.1569
K_K20602  L_L117  L_L256  0.0812
K_K20603  L_L117  L_L257  0.0389
K_K20604  L_L117  L_L258  0.0256
K_K20605  L_L117  L_L259  0.0191
K_K20606  L_L117  L_L260  0.0152
K_K20607  L_L117  L_L261  0.0127
K_K20608  L_L117  L_L262  0.0109
K_K20609  L_L117  L_L263  0.0095
K_K20610  L_L117  L_L264  0.0084
K_K20611  L_L117  L_L265  0.0076
K_K20612  L_L117  L_L266  0.0069
K_K20613  L_L117  L_L267  0.0063
K_K20614  L_L117  L_L268  0.0058
K_K20615  L_L117  L_L269  0.0054
K_K20616  L_L117  L_L270  0.0051
K_K20617  L_L117  L_L271  0.0047
K_K20618  L_L117  L_L272  0.0045
K_K20619  L_L117  L_L273  0.0042
K_K20620  L_L117  L_L274  0.0040
K_K20621  L_L117  L_L275  0.0038
K_K20622  L_L117  L_L276  0.0036
* *  Branch  NTMP0000000117 - NTMP0000000118
R_R118  NTMP0000000117  nU_118  32.914993m  TC=0,0
V_Ui118  nU_118  nR_118  STIMULUS=U_IND_0000000118
R_V235  nR_118  nV_235  23.280268m  TC=0,0
L_V235  nR_118  nV_235  0.014646uH
R_V236  nV_235  nV_236  7.852787m  TC=0,0
L_V236  nV_235  nV_236  0.073723uH
L_L118  nV_236  NTMP0000000118  6.519695uH
K_K20623  L_L118  L_L119  0.1050
K_K20624  L_L118  L_L120  0.0397
K_K20625  L_L118  L_L121  0.0258
K_K20626  L_L118  L_L122  0.0192
K_K20627  L_L118  L_L123  0.0153
K_K20628  L_L118  L_L124  0.0127
K_K20629  L_L118  L_L125  0.0109
K_K20630  L_L118  L_L126  0.0095
K_K20631  L_L118  L_L127  0.0084
K_K20632  L_L118  L_L128  0.0076
K_K20633  L_L118  L_L129  0.0069
K_K20634  L_L118  L_L130  0.0063
K_K20635  L_L118  L_L131  0.0058
K_K20636  L_L118  L_L132  0.0054
K_K20637  L_L118  L_L133  0.0051
K_K20638  L_L118  L_L134  0.0047
K_K20639  L_L118  L_L135  0.0045
K_K20640  L_L118  L_L136  0.0042
K_K20641  L_L118  L_L137  0.0040
K_K20642  L_L118  L_L138  0.0038
K_K20643  L_L118  L_L181  0.0010
K_K20644  L_L118  L_L182  0.0010
K_K20645  L_L118  L_L183  0.0010
K_K20646  L_L118  L_L184  0.0011
K_K20647  L_L118  L_L185  0.0011
K_K20648  L_L118  L_L186  0.0011
K_K20649  L_L118  L_L187  0.0011
K_K20650  L_L118  L_L188  0.0011
K_K20651  L_L118  L_L189  0.0011
K_K20652  L_L118  L_L190  0.0011
K_K20653  L_L118  L_L191  0.0012
K_K20654  L_L118  L_L192  0.0012
K_K20655  L_L118  L_L193  0.0012
K_K20656  L_L118  L_L194  0.0012
K_K20657  L_L118  L_L195  0.0012
K_K20658  L_L118  L_L196  0.0013
K_K20659  L_L118  L_L197  0.0013
K_K20660  L_L118  L_L198  0.0013
K_K20661  L_L118  L_L199  0.0013
K_K20662  L_L118  L_L200  0.0014
K_K20663  L_L118  L_L201  0.0014
K_K20664  L_L118  L_L202  0.0014
K_K20665  L_L118  L_L203  0.0014
K_K20666  L_L118  L_L204  0.0015
K_K20667  L_L118  L_L205  0.0015
K_K20668  L_L118  L_L206  0.0015
K_K20669  L_L118  L_L207  0.0015
K_K20670  L_L118  L_L208  0.0016
K_K20671  L_L118  L_L209  0.0016
K_K20672  L_L118  L_L210  0.0016
K_K20673  L_L118  L_L211  0.0017
K_K20674  L_L118  L_L212  0.0017
K_K20675  L_L118  L_L213  0.0018
K_K20676  L_L118  L_L214  0.0018
K_K20677  L_L118  L_L215  0.0018
K_K20678  L_L118  L_L216  0.0019
K_K20679  L_L118  L_L217  0.0019
K_K20680  L_L118  L_L218  0.0020
K_K20681  L_L118  L_L219  0.0020
K_K20682  L_L118  L_L220  0.0021
K_K20683  L_L118  L_L221  0.0022
K_K20684  L_L118  L_L222  0.0022
K_K20685  L_L118  L_L223  0.0023
K_K20686  L_L118  L_L224  0.0024
K_K20687  L_L118  L_L225  0.0024
K_K20688  L_L118  L_L226  0.0025
K_K20689  L_L118  L_L227  0.0026
K_K20690  L_L118  L_L228  0.0027
K_K20691  L_L118  L_L229  0.0028
K_K20692  L_L118  L_L230  0.0029
K_K20693  L_L118  L_L231  0.0030
K_K20694  L_L118  L_L232  0.0032
K_K20695  L_L118  L_L233  0.0033
K_K20696  L_L118  L_L234  0.0034
K_K20697  L_L118  L_L235  0.0036
K_K20698  L_L118  L_L236  0.0038
K_K20699  L_L118  L_L237  0.0040
K_K20700  L_L118  L_L238  0.0042
K_K20701  L_L118  L_L239  0.0045
K_K20702  L_L118  L_L240  0.0047
K_K20703  L_L118  L_L241  0.0051
K_K20704  L_L118  L_L242  0.0054
K_K20705  L_L118  L_L243  0.0058
K_K20706  L_L118  L_L244  0.0063
K_K20707  L_L118  L_L245  0.0069
K_K20708  L_L118  L_L246  0.0076
K_K20709  L_L118  L_L247  0.0084
K_K20710  L_L118  L_L248  0.0095
K_K20711  L_L118  L_L249  0.0109
K_K20712  L_L118  L_L250  0.0127
K_K20713  L_L118  L_L251  0.0152
K_K20714  L_L118  L_L252  0.0191
K_K20715  L_L118  L_L253  0.0256
K_K20716  L_L118  L_L254  0.0389
K_K20717  L_L118  L_L255  0.0812
K_K20718  L_L118  L_L256  0.1569
K_K20719  L_L118  L_L257  0.0812
K_K20720  L_L118  L_L258  0.0389
K_K20721  L_L118  L_L259  0.0256
K_K20722  L_L118  L_L260  0.0191
K_K20723  L_L118  L_L261  0.0152
K_K20724  L_L118  L_L262  0.0127
K_K20725  L_L118  L_L263  0.0109
K_K20726  L_L118  L_L264  0.0095
K_K20727  L_L118  L_L265  0.0084
K_K20728  L_L118  L_L266  0.0076
K_K20729  L_L118  L_L267  0.0069
K_K20730  L_L118  L_L268  0.0063
K_K20731  L_L118  L_L269  0.0058
K_K20732  L_L118  L_L270  0.0054
K_K20733  L_L118  L_L271  0.0051
K_K20734  L_L118  L_L272  0.0047
K_K20735  L_L118  L_L273  0.0045
K_K20736  L_L118  L_L274  0.0042
K_K20737  L_L118  L_L275  0.0040
K_K20738  L_L118  L_L276  0.0038
* *  Branch  NTMP0000000118 - NTMP0000000119
R_R119  NTMP0000000118  nU_119  32.914993m  TC=0,0
V_Ui119  nU_119  nR_119  STIMULUS=U_IND_0000000119
R_V237  nR_119  nV_237  23.280268m  TC=0,0
L_V237  nR_119  nV_237  0.014646uH
R_V238  nV_237  nV_238  7.852787m  TC=0,0
L_V238  nV_237  nV_238  0.073723uH
L_L119  nV_238  NTMP0000000119  6.519695uH
K_K20739  L_L119  L_L120  0.1050
K_K20740  L_L119  L_L121  0.0397
K_K20741  L_L119  L_L122  0.0258
K_K20742  L_L119  L_L123  0.0192
K_K20743  L_L119  L_L124  0.0153
K_K20744  L_L119  L_L125  0.0127
K_K20745  L_L119  L_L126  0.0109
K_K20746  L_L119  L_L127  0.0095
K_K20747  L_L119  L_L128  0.0084
K_K20748  L_L119  L_L129  0.0076
K_K20749  L_L119  L_L130  0.0069
K_K20750  L_L119  L_L131  0.0063
K_K20751  L_L119  L_L132  0.0058
K_K20752  L_L119  L_L133  0.0054
K_K20753  L_L119  L_L134  0.0051
K_K20754  L_L119  L_L135  0.0047
K_K20755  L_L119  L_L136  0.0045
K_K20756  L_L119  L_L137  0.0042
K_K20757  L_L119  L_L138  0.0040
K_K20758  L_L119  L_L182  0.0010
K_K20759  L_L119  L_L183  0.0010
K_K20760  L_L119  L_L184  0.0010
K_K20761  L_L119  L_L185  0.0011
K_K20762  L_L119  L_L186  0.0011
K_K20763  L_L119  L_L187  0.0011
K_K20764  L_L119  L_L188  0.0011
K_K20765  L_L119  L_L189  0.0011
K_K20766  L_L119  L_L190  0.0011
K_K20767  L_L119  L_L191  0.0011
K_K20768  L_L119  L_L192  0.0012
K_K20769  L_L119  L_L193  0.0012
K_K20770  L_L119  L_L194  0.0012
K_K20771  L_L119  L_L195  0.0012
K_K20772  L_L119  L_L196  0.0012
K_K20773  L_L119  L_L197  0.0013
K_K20774  L_L119  L_L198  0.0013
K_K20775  L_L119  L_L199  0.0013
K_K20776  L_L119  L_L200  0.0013
K_K20777  L_L119  L_L201  0.0014
K_K20778  L_L119  L_L202  0.0014
K_K20779  L_L119  L_L203  0.0014
K_K20780  L_L119  L_L204  0.0014
K_K20781  L_L119  L_L205  0.0015
K_K20782  L_L119  L_L206  0.0015
K_K20783  L_L119  L_L207  0.0015
K_K20784  L_L119  L_L208  0.0015
K_K20785  L_L119  L_L209  0.0016
K_K20786  L_L119  L_L210  0.0016
K_K20787  L_L119  L_L211  0.0016
K_K20788  L_L119  L_L212  0.0017
K_K20789  L_L119  L_L213  0.0017
K_K20790  L_L119  L_L214  0.0018
K_K20791  L_L119  L_L215  0.0018
K_K20792  L_L119  L_L216  0.0018
K_K20793  L_L119  L_L217  0.0019
K_K20794  L_L119  L_L218  0.0019
K_K20795  L_L119  L_L219  0.0020
K_K20796  L_L119  L_L220  0.0020
K_K20797  L_L119  L_L221  0.0021
K_K20798  L_L119  L_L222  0.0022
K_K20799  L_L119  L_L223  0.0022
K_K20800  L_L119  L_L224  0.0023
K_K20801  L_L119  L_L225  0.0024
K_K20802  L_L119  L_L226  0.0024
K_K20803  L_L119  L_L227  0.0025
K_K20804  L_L119  L_L228  0.0026
K_K20805  L_L119  L_L229  0.0027
K_K20806  L_L119  L_L230  0.0028
K_K20807  L_L119  L_L231  0.0029
K_K20808  L_L119  L_L232  0.0030
K_K20809  L_L119  L_L233  0.0032
K_K20810  L_L119  L_L234  0.0033
K_K20811  L_L119  L_L235  0.0034
K_K20812  L_L119  L_L236  0.0036
K_K20813  L_L119  L_L237  0.0038
K_K20814  L_L119  L_L238  0.0040
K_K20815  L_L119  L_L239  0.0042
K_K20816  L_L119  L_L240  0.0045
K_K20817  L_L119  L_L241  0.0047
K_K20818  L_L119  L_L242  0.0051
K_K20819  L_L119  L_L243  0.0054
K_K20820  L_L119  L_L244  0.0058
K_K20821  L_L119  L_L245  0.0063
K_K20822  L_L119  L_L246  0.0069
K_K20823  L_L119  L_L247  0.0076
K_K20824  L_L119  L_L248  0.0084
K_K20825  L_L119  L_L249  0.0095
K_K20826  L_L119  L_L250  0.0109
K_K20827  L_L119  L_L251  0.0127
K_K20828  L_L119  L_L252  0.0152
K_K20829  L_L119  L_L253  0.0191
K_K20830  L_L119  L_L254  0.0256
K_K20831  L_L119  L_L255  0.0389
K_K20832  L_L119  L_L256  0.0812
K_K20833  L_L119  L_L257  0.1569
K_K20834  L_L119  L_L258  0.0812
K_K20835  L_L119  L_L259  0.0389
K_K20836  L_L119  L_L260  0.0256
K_K20837  L_L119  L_L261  0.0191
K_K20838  L_L119  L_L262  0.0152
K_K20839  L_L119  L_L263  0.0127
K_K20840  L_L119  L_L264  0.0109
K_K20841  L_L119  L_L265  0.0095
K_K20842  L_L119  L_L266  0.0084
K_K20843  L_L119  L_L267  0.0076
K_K20844  L_L119  L_L268  0.0069
K_K20845  L_L119  L_L269  0.0063
K_K20846  L_L119  L_L270  0.0058
K_K20847  L_L119  L_L271  0.0054
K_K20848  L_L119  L_L272  0.0051
K_K20849  L_L119  L_L273  0.0047
K_K20850  L_L119  L_L274  0.0045
K_K20851  L_L119  L_L275  0.0042
K_K20852  L_L119  L_L276  0.0040
* *  Branch  NTMP0000000119 - NTMP0000000120
R_R120  NTMP0000000119  nU_120  32.914993m  TC=0,0
V_Ui120  nU_120  nR_120  STIMULUS=U_IND_0000000120
R_V239  nR_120  nV_239  23.280268m  TC=0,0
L_V239  nR_120  nV_239  0.014646uH
R_V240  nV_239  nV_240  7.852787m  TC=0,0
L_V240  nV_239  nV_240  0.073723uH
L_L120  nV_240  NTMP0000000120  6.519695uH
K_K20853  L_L120  L_L121  0.1050
K_K20854  L_L120  L_L122  0.0397
K_K20855  L_L120  L_L123  0.0258
K_K20856  L_L120  L_L124  0.0192
K_K20857  L_L120  L_L125  0.0153
K_K20858  L_L120  L_L126  0.0127
K_K20859  L_L120  L_L127  0.0109
K_K20860  L_L120  L_L128  0.0095
K_K20861  L_L120  L_L129  0.0084
K_K20862  L_L120  L_L130  0.0076
K_K20863  L_L120  L_L131  0.0069
K_K20864  L_L120  L_L132  0.0063
K_K20865  L_L120  L_L133  0.0058
K_K20866  L_L120  L_L134  0.0054
K_K20867  L_L120  L_L135  0.0051
K_K20868  L_L120  L_L136  0.0047
K_K20869  L_L120  L_L137  0.0045
K_K20870  L_L120  L_L138  0.0042
K_K20871  L_L120  L_L183  0.0010
K_K20872  L_L120  L_L184  0.0010
K_K20873  L_L120  L_L185  0.0010
K_K20874  L_L120  L_L186  0.0011
K_K20875  L_L120  L_L187  0.0011
K_K20876  L_L120  L_L188  0.0011
K_K20877  L_L120  L_L189  0.0011
K_K20878  L_L120  L_L190  0.0011
K_K20879  L_L120  L_L191  0.0011
K_K20880  L_L120  L_L192  0.0011
K_K20881  L_L120  L_L193  0.0012
K_K20882  L_L120  L_L194  0.0012
K_K20883  L_L120  L_L195  0.0012
K_K20884  L_L120  L_L196  0.0012
K_K20885  L_L120  L_L197  0.0012
K_K20886  L_L120  L_L198  0.0013
K_K20887  L_L120  L_L199  0.0013
K_K20888  L_L120  L_L200  0.0013
K_K20889  L_L120  L_L201  0.0013
K_K20890  L_L120  L_L202  0.0014
K_K20891  L_L120  L_L203  0.0014
K_K20892  L_L120  L_L204  0.0014
K_K20893  L_L120  L_L205  0.0014
K_K20894  L_L120  L_L206  0.0015
K_K20895  L_L120  L_L207  0.0015
K_K20896  L_L120  L_L208  0.0015
K_K20897  L_L120  L_L209  0.0015
K_K20898  L_L120  L_L210  0.0016
K_K20899  L_L120  L_L211  0.0016
K_K20900  L_L120  L_L212  0.0016
K_K20901  L_L120  L_L213  0.0017
K_K20902  L_L120  L_L214  0.0017
K_K20903  L_L120  L_L215  0.0018
K_K20904  L_L120  L_L216  0.0018
K_K20905  L_L120  L_L217  0.0018
K_K20906  L_L120  L_L218  0.0019
K_K20907  L_L120  L_L219  0.0019
K_K20908  L_L120  L_L220  0.0020
K_K20909  L_L120  L_L221  0.0020
K_K20910  L_L120  L_L222  0.0021
K_K20911  L_L120  L_L223  0.0022
K_K20912  L_L120  L_L224  0.0022
K_K20913  L_L120  L_L225  0.0023
K_K20914  L_L120  L_L226  0.0024
K_K20915  L_L120  L_L227  0.0024
K_K20916  L_L120  L_L228  0.0025
K_K20917  L_L120  L_L229  0.0026
K_K20918  L_L120  L_L230  0.0027
K_K20919  L_L120  L_L231  0.0028
K_K20920  L_L120  L_L232  0.0029
K_K20921  L_L120  L_L233  0.0030
K_K20922  L_L120  L_L234  0.0032
K_K20923  L_L120  L_L235  0.0033
K_K20924  L_L120  L_L236  0.0034
K_K20925  L_L120  L_L237  0.0036
K_K20926  L_L120  L_L238  0.0038
K_K20927  L_L120  L_L239  0.0040
K_K20928  L_L120  L_L240  0.0042
K_K20929  L_L120  L_L241  0.0045
K_K20930  L_L120  L_L242  0.0047
K_K20931  L_L120  L_L243  0.0051
K_K20932  L_L120  L_L244  0.0054
K_K20933  L_L120  L_L245  0.0058
K_K20934  L_L120  L_L246  0.0063
K_K20935  L_L120  L_L247  0.0069
K_K20936  L_L120  L_L248  0.0076
K_K20937  L_L120  L_L249  0.0084
K_K20938  L_L120  L_L250  0.0095
K_K20939  L_L120  L_L251  0.0109
K_K20940  L_L120  L_L252  0.0127
K_K20941  L_L120  L_L253  0.0152
K_K20942  L_L120  L_L254  0.0191
K_K20943  L_L120  L_L255  0.0256
K_K20944  L_L120  L_L256  0.0389
K_K20945  L_L120  L_L257  0.0812
K_K20946  L_L120  L_L258  0.1569
K_K20947  L_L120  L_L259  0.0812
K_K20948  L_L120  L_L260  0.0389
K_K20949  L_L120  L_L261  0.0256
K_K20950  L_L120  L_L262  0.0191
K_K20951  L_L120  L_L263  0.0152
K_K20952  L_L120  L_L264  0.0127
K_K20953  L_L120  L_L265  0.0109
K_K20954  L_L120  L_L266  0.0095
K_K20955  L_L120  L_L267  0.0084
K_K20956  L_L120  L_L268  0.0076
K_K20957  L_L120  L_L269  0.0069
K_K20958  L_L120  L_L270  0.0063
K_K20959  L_L120  L_L271  0.0058
K_K20960  L_L120  L_L272  0.0054
K_K20961  L_L120  L_L273  0.0051
K_K20962  L_L120  L_L274  0.0047
K_K20963  L_L120  L_L275  0.0045
K_K20964  L_L120  L_L276  0.0042
* *  Branch  NTMP0000000120 - NTMP0000000121
R_R121  NTMP0000000120  nU_121  32.914993m  TC=0,0
V_Ui121  nU_121  nR_121  STIMULUS=U_IND_0000000121
R_V241  nR_121  nV_241  23.280268m  TC=0,0
L_V241  nR_121  nV_241  0.014646uH
R_V242  nV_241  nV_242  7.852787m  TC=0,0
L_V242  nV_241  nV_242  0.073723uH
L_L121  nV_242  NTMP0000000121  6.519695uH
K_K20965  L_L121  L_L122  0.1050
K_K20966  L_L121  L_L123  0.0397
K_K20967  L_L121  L_L124  0.0258
K_K20968  L_L121  L_L125  0.0192
K_K20969  L_L121  L_L126  0.0153
K_K20970  L_L121  L_L127  0.0127
K_K20971  L_L121  L_L128  0.0109
K_K20972  L_L121  L_L129  0.0095
K_K20973  L_L121  L_L130  0.0084
K_K20974  L_L121  L_L131  0.0076
K_K20975  L_L121  L_L132  0.0069
K_K20976  L_L121  L_L133  0.0063
K_K20977  L_L121  L_L134  0.0058
K_K20978  L_L121  L_L135  0.0054
K_K20979  L_L121  L_L136  0.0051
K_K20980  L_L121  L_L137  0.0047
K_K20981  L_L121  L_L138  0.0045
K_K20982  L_L121  L_L184  0.0010
K_K20983  L_L121  L_L185  0.0010
K_K20984  L_L121  L_L186  0.0010
K_K20985  L_L121  L_L187  0.0011
K_K20986  L_L121  L_L188  0.0011
K_K20987  L_L121  L_L189  0.0011
K_K20988  L_L121  L_L190  0.0011
K_K20989  L_L121  L_L191  0.0011
K_K20990  L_L121  L_L192  0.0011
K_K20991  L_L121  L_L193  0.0011
K_K20992  L_L121  L_L194  0.0012
K_K20993  L_L121  L_L195  0.0012
K_K20994  L_L121  L_L196  0.0012
K_K20995  L_L121  L_L197  0.0012
K_K20996  L_L121  L_L198  0.0012
K_K20997  L_L121  L_L199  0.0013
K_K20998  L_L121  L_L200  0.0013
K_K20999  L_L121  L_L201  0.0013
K_K21000  L_L121  L_L202  0.0013
K_K21001  L_L121  L_L203  0.0014
K_K21002  L_L121  L_L204  0.0014
K_K21003  L_L121  L_L205  0.0014
K_K21004  L_L121  L_L206  0.0014
K_K21005  L_L121  L_L207  0.0015
K_K21006  L_L121  L_L208  0.0015
K_K21007  L_L121  L_L209  0.0015
K_K21008  L_L121  L_L210  0.0015
K_K21009  L_L121  L_L211  0.0016
K_K21010  L_L121  L_L212  0.0016
K_K21011  L_L121  L_L213  0.0016
K_K21012  L_L121  L_L214  0.0017
K_K21013  L_L121  L_L215  0.0017
K_K21014  L_L121  L_L216  0.0018
K_K21015  L_L121  L_L217  0.0018
K_K21016  L_L121  L_L218  0.0018
K_K21017  L_L121  L_L219  0.0019
K_K21018  L_L121  L_L220  0.0019
K_K21019  L_L121  L_L221  0.0020
K_K21020  L_L121  L_L222  0.0020
K_K21021  L_L121  L_L223  0.0021
K_K21022  L_L121  L_L224  0.0022
K_K21023  L_L121  L_L225  0.0022
K_K21024  L_L121  L_L226  0.0023
K_K21025  L_L121  L_L227  0.0024
K_K21026  L_L121  L_L228  0.0024
K_K21027  L_L121  L_L229  0.0025
K_K21028  L_L121  L_L230  0.0026
K_K21029  L_L121  L_L231  0.0027
K_K21030  L_L121  L_L232  0.0028
K_K21031  L_L121  L_L233  0.0029
K_K21032  L_L121  L_L234  0.0030
K_K21033  L_L121  L_L235  0.0032
K_K21034  L_L121  L_L236  0.0033
K_K21035  L_L121  L_L237  0.0034
K_K21036  L_L121  L_L238  0.0036
K_K21037  L_L121  L_L239  0.0038
K_K21038  L_L121  L_L240  0.0040
K_K21039  L_L121  L_L241  0.0042
K_K21040  L_L121  L_L242  0.0045
K_K21041  L_L121  L_L243  0.0047
K_K21042  L_L121  L_L244  0.0051
K_K21043  L_L121  L_L245  0.0054
K_K21044  L_L121  L_L246  0.0058
K_K21045  L_L121  L_L247  0.0063
K_K21046  L_L121  L_L248  0.0069
K_K21047  L_L121  L_L249  0.0076
K_K21048  L_L121  L_L250  0.0084
K_K21049  L_L121  L_L251  0.0095
K_K21050  L_L121  L_L252  0.0109
K_K21051  L_L121  L_L253  0.0127
K_K21052  L_L121  L_L254  0.0152
K_K21053  L_L121  L_L255  0.0191
K_K21054  L_L121  L_L256  0.0256
K_K21055  L_L121  L_L257  0.0389
K_K21056  L_L121  L_L258  0.0812
K_K21057  L_L121  L_L259  0.1569
K_K21058  L_L121  L_L260  0.0812
K_K21059  L_L121  L_L261  0.0389
K_K21060  L_L121  L_L262  0.0256
K_K21061  L_L121  L_L263  0.0191
K_K21062  L_L121  L_L264  0.0152
K_K21063  L_L121  L_L265  0.0127
K_K21064  L_L121  L_L266  0.0109
K_K21065  L_L121  L_L267  0.0095
K_K21066  L_L121  L_L268  0.0084
K_K21067  L_L121  L_L269  0.0076
K_K21068  L_L121  L_L270  0.0069
K_K21069  L_L121  L_L271  0.0063
K_K21070  L_L121  L_L272  0.0058
K_K21071  L_L121  L_L273  0.0054
K_K21072  L_L121  L_L274  0.0051
K_K21073  L_L121  L_L275  0.0047
K_K21074  L_L121  L_L276  0.0045
* *  Branch  NTMP0000000121 - NTMP0000000122
R_R122  NTMP0000000121  nU_122  32.914993m  TC=0,0
V_Ui122  nU_122  nR_122  STIMULUS=U_IND_0000000122
R_V243  nR_122  nV_243  23.280268m  TC=0,0
L_V243  nR_122  nV_243  0.014646uH
R_V244  nV_243  nV_244  7.852787m  TC=0,0
L_V244  nV_243  nV_244  0.073723uH
L_L122  nV_244  NTMP0000000122  6.519695uH
K_K21075  L_L122  L_L123  0.1050
K_K21076  L_L122  L_L124  0.0397
K_K21077  L_L122  L_L125  0.0258
K_K21078  L_L122  L_L126  0.0192
K_K21079  L_L122  L_L127  0.0153
K_K21080  L_L122  L_L128  0.0127
K_K21081  L_L122  L_L129  0.0109
K_K21082  L_L122  L_L130  0.0095
K_K21083  L_L122  L_L131  0.0084
K_K21084  L_L122  L_L132  0.0076
K_K21085  L_L122  L_L133  0.0069
K_K21086  L_L122  L_L134  0.0063
K_K21087  L_L122  L_L135  0.0058
K_K21088  L_L122  L_L136  0.0054
K_K21089  L_L122  L_L137  0.0051
K_K21090  L_L122  L_L138  0.0047
K_K21091  L_L122  L_L185  0.0010
K_K21092  L_L122  L_L186  0.0010
K_K21093  L_L122  L_L187  0.0010
K_K21094  L_L122  L_L188  0.0011
K_K21095  L_L122  L_L189  0.0011
K_K21096  L_L122  L_L190  0.0011
K_K21097  L_L122  L_L191  0.0011
K_K21098  L_L122  L_L192  0.0011
K_K21099  L_L122  L_L193  0.0011
K_K21100  L_L122  L_L194  0.0011
K_K21101  L_L122  L_L195  0.0012
K_K21102  L_L122  L_L196  0.0012
K_K21103  L_L122  L_L197  0.0012
K_K21104  L_L122  L_L198  0.0012
K_K21105  L_L122  L_L199  0.0012
K_K21106  L_L122  L_L200  0.0013
K_K21107  L_L122  L_L201  0.0013
K_K21108  L_L122  L_L202  0.0013
K_K21109  L_L122  L_L203  0.0013
K_K21110  L_L122  L_L204  0.0014
K_K21111  L_L122  L_L205  0.0014
K_K21112  L_L122  L_L206  0.0014
K_K21113  L_L122  L_L207  0.0014
K_K21114  L_L122  L_L208  0.0015
K_K21115  L_L122  L_L209  0.0015
K_K21116  L_L122  L_L210  0.0015
K_K21117  L_L122  L_L211  0.0015
K_K21118  L_L122  L_L212  0.0016
K_K21119  L_L122  L_L213  0.0016
K_K21120  L_L122  L_L214  0.0016
K_K21121  L_L122  L_L215  0.0017
K_K21122  L_L122  L_L216  0.0017
K_K21123  L_L122  L_L217  0.0018
K_K21124  L_L122  L_L218  0.0018
K_K21125  L_L122  L_L219  0.0018
K_K21126  L_L122  L_L220  0.0019
K_K21127  L_L122  L_L221  0.0019
K_K21128  L_L122  L_L222  0.0020
K_K21129  L_L122  L_L223  0.0020
K_K21130  L_L122  L_L224  0.0021
K_K21131  L_L122  L_L225  0.0022
K_K21132  L_L122  L_L226  0.0022
K_K21133  L_L122  L_L227  0.0023
K_K21134  L_L122  L_L228  0.0024
K_K21135  L_L122  L_L229  0.0024
K_K21136  L_L122  L_L230  0.0025
K_K21137  L_L122  L_L231  0.0026
K_K21138  L_L122  L_L232  0.0027
K_K21139  L_L122  L_L233  0.0028
K_K21140  L_L122  L_L234  0.0029
K_K21141  L_L122  L_L235  0.0030
K_K21142  L_L122  L_L236  0.0032
K_K21143  L_L122  L_L237  0.0033
K_K21144  L_L122  L_L238  0.0034
K_K21145  L_L122  L_L239  0.0036
K_K21146  L_L122  L_L240  0.0038
K_K21147  L_L122  L_L241  0.0040
K_K21148  L_L122  L_L242  0.0042
K_K21149  L_L122  L_L243  0.0045
K_K21150  L_L122  L_L244  0.0047
K_K21151  L_L122  L_L245  0.0051
K_K21152  L_L122  L_L246  0.0054
K_K21153  L_L122  L_L247  0.0058
K_K21154  L_L122  L_L248  0.0063
K_K21155  L_L122  L_L249  0.0069
K_K21156  L_L122  L_L250  0.0076
K_K21157  L_L122  L_L251  0.0084
K_K21158  L_L122  L_L252  0.0095
K_K21159  L_L122  L_L253  0.0109
K_K21160  L_L122  L_L254  0.0127
K_K21161  L_L122  L_L255  0.0152
K_K21162  L_L122  L_L256  0.0191
K_K21163  L_L122  L_L257  0.0256
K_K21164  L_L122  L_L258  0.0389
K_K21165  L_L122  L_L259  0.0812
K_K21166  L_L122  L_L260  0.1569
K_K21167  L_L122  L_L261  0.0812
K_K21168  L_L122  L_L262  0.0389
K_K21169  L_L122  L_L263  0.0256
K_K21170  L_L122  L_L264  0.0191
K_K21171  L_L122  L_L265  0.0152
K_K21172  L_L122  L_L266  0.0127
K_K21173  L_L122  L_L267  0.0109
K_K21174  L_L122  L_L268  0.0095
K_K21175  L_L122  L_L269  0.0084
K_K21176  L_L122  L_L270  0.0076
K_K21177  L_L122  L_L271  0.0069
K_K21178  L_L122  L_L272  0.0063
K_K21179  L_L122  L_L273  0.0058
K_K21180  L_L122  L_L274  0.0054
K_K21181  L_L122  L_L275  0.0051
K_K21182  L_L122  L_L276  0.0047
* *  Branch  NTMP0000000122 - NTMP0000000123
R_R123  NTMP0000000122  nU_123  32.914993m  TC=0,0
V_Ui123  nU_123  nR_123  STIMULUS=U_IND_0000000123
R_V245  nR_123  nV_245  23.280268m  TC=0,0
L_V245  nR_123  nV_245  0.014646uH
R_V246  nV_245  nV_246  7.852787m  TC=0,0
L_V246  nV_245  nV_246  0.073723uH
L_L123  nV_246  NTMP0000000123  6.519695uH
K_K21183  L_L123  L_L124  0.1050
K_K21184  L_L123  L_L125  0.0397
K_K21185  L_L123  L_L126  0.0258
K_K21186  L_L123  L_L127  0.0192
K_K21187  L_L123  L_L128  0.0153
K_K21188  L_L123  L_L129  0.0127
K_K21189  L_L123  L_L130  0.0109
K_K21190  L_L123  L_L131  0.0095
K_K21191  L_L123  L_L132  0.0084
K_K21192  L_L123  L_L133  0.0076
K_K21193  L_L123  L_L134  0.0069
K_K21194  L_L123  L_L135  0.0063
K_K21195  L_L123  L_L136  0.0058
K_K21196  L_L123  L_L137  0.0054
K_K21197  L_L123  L_L138  0.0051
K_K21198  L_L123  L_L186  0.0010
K_K21199  L_L123  L_L187  0.0010
K_K21200  L_L123  L_L188  0.0010
K_K21201  L_L123  L_L189  0.0011
K_K21202  L_L123  L_L190  0.0011
K_K21203  L_L123  L_L191  0.0011
K_K21204  L_L123  L_L192  0.0011
K_K21205  L_L123  L_L193  0.0011
K_K21206  L_L123  L_L194  0.0011
K_K21207  L_L123  L_L195  0.0011
K_K21208  L_L123  L_L196  0.0012
K_K21209  L_L123  L_L197  0.0012
K_K21210  L_L123  L_L198  0.0012
K_K21211  L_L123  L_L199  0.0012
K_K21212  L_L123  L_L200  0.0012
K_K21213  L_L123  L_L201  0.0013
K_K21214  L_L123  L_L202  0.0013
K_K21215  L_L123  L_L203  0.0013
K_K21216  L_L123  L_L204  0.0013
K_K21217  L_L123  L_L205  0.0014
K_K21218  L_L123  L_L206  0.0014
K_K21219  L_L123  L_L207  0.0014
K_K21220  L_L123  L_L208  0.0014
K_K21221  L_L123  L_L209  0.0015
K_K21222  L_L123  L_L210  0.0015
K_K21223  L_L123  L_L211  0.0015
K_K21224  L_L123  L_L212  0.0015
K_K21225  L_L123  L_L213  0.0016
K_K21226  L_L123  L_L214  0.0016
K_K21227  L_L123  L_L215  0.0016
K_K21228  L_L123  L_L216  0.0017
K_K21229  L_L123  L_L217  0.0017
K_K21230  L_L123  L_L218  0.0018
K_K21231  L_L123  L_L219  0.0018
K_K21232  L_L123  L_L220  0.0018
K_K21233  L_L123  L_L221  0.0019
K_K21234  L_L123  L_L222  0.0019
K_K21235  L_L123  L_L223  0.0020
K_K21236  L_L123  L_L224  0.0020
K_K21237  L_L123  L_L225  0.0021
K_K21238  L_L123  L_L226  0.0022
K_K21239  L_L123  L_L227  0.0022
K_K21240  L_L123  L_L228  0.0023
K_K21241  L_L123  L_L229  0.0024
K_K21242  L_L123  L_L230  0.0024
K_K21243  L_L123  L_L231  0.0025
K_K21244  L_L123  L_L232  0.0026
K_K21245  L_L123  L_L233  0.0027
K_K21246  L_L123  L_L234  0.0028
K_K21247  L_L123  L_L235  0.0029
K_K21248  L_L123  L_L236  0.0030
K_K21249  L_L123  L_L237  0.0032
K_K21250  L_L123  L_L238  0.0033
K_K21251  L_L123  L_L239  0.0034
K_K21252  L_L123  L_L240  0.0036
K_K21253  L_L123  L_L241  0.0038
K_K21254  L_L123  L_L242  0.0040
K_K21255  L_L123  L_L243  0.0042
K_K21256  L_L123  L_L244  0.0045
K_K21257  L_L123  L_L245  0.0047
K_K21258  L_L123  L_L246  0.0051
K_K21259  L_L123  L_L247  0.0054
K_K21260  L_L123  L_L248  0.0058
K_K21261  L_L123  L_L249  0.0063
K_K21262  L_L123  L_L250  0.0069
K_K21263  L_L123  L_L251  0.0076
K_K21264  L_L123  L_L252  0.0084
K_K21265  L_L123  L_L253  0.0095
K_K21266  L_L123  L_L254  0.0109
K_K21267  L_L123  L_L255  0.0127
K_K21268  L_L123  L_L256  0.0152
K_K21269  L_L123  L_L257  0.0191
K_K21270  L_L123  L_L258  0.0256
K_K21271  L_L123  L_L259  0.0389
K_K21272  L_L123  L_L260  0.0812
K_K21273  L_L123  L_L261  0.1569
K_K21274  L_L123  L_L262  0.0812
K_K21275  L_L123  L_L263  0.0389
K_K21276  L_L123  L_L264  0.0256
K_K21277  L_L123  L_L265  0.0191
K_K21278  L_L123  L_L266  0.0152
K_K21279  L_L123  L_L267  0.0127
K_K21280  L_L123  L_L268  0.0109
K_K21281  L_L123  L_L269  0.0095
K_K21282  L_L123  L_L270  0.0084
K_K21283  L_L123  L_L271  0.0076
K_K21284  L_L123  L_L272  0.0069
K_K21285  L_L123  L_L273  0.0063
K_K21286  L_L123  L_L274  0.0058
K_K21287  L_L123  L_L275  0.0054
K_K21288  L_L123  L_L276  0.0051
* *  Branch  NTMP0000000123 - NTMP0000000124
R_R124  NTMP0000000123  nU_124  32.914993m  TC=0,0
V_Ui124  nU_124  nR_124  STIMULUS=U_IND_0000000124
R_V247  nR_124  nV_247  23.280268m  TC=0,0
L_V247  nR_124  nV_247  0.014646uH
R_V248  nV_247  nV_248  7.852787m  TC=0,0
L_V248  nV_247  nV_248  0.073723uH
L_L124  nV_248  NTMP0000000124  6.519695uH
K_K21289  L_L124  L_L125  0.1050
K_K21290  L_L124  L_L126  0.0397
K_K21291  L_L124  L_L127  0.0258
K_K21292  L_L124  L_L128  0.0192
K_K21293  L_L124  L_L129  0.0153
K_K21294  L_L124  L_L130  0.0127
K_K21295  L_L124  L_L131  0.0109
K_K21296  L_L124  L_L132  0.0095
K_K21297  L_L124  L_L133  0.0084
K_K21298  L_L124  L_L134  0.0076
K_K21299  L_L124  L_L135  0.0069
K_K21300  L_L124  L_L136  0.0063
K_K21301  L_L124  L_L137  0.0058
K_K21302  L_L124  L_L138  0.0054
K_K21303  L_L124  L_L187  0.0010
K_K21304  L_L124  L_L188  0.0010
K_K21305  L_L124  L_L189  0.0010
K_K21306  L_L124  L_L190  0.0011
K_K21307  L_L124  L_L191  0.0011
K_K21308  L_L124  L_L192  0.0011
K_K21309  L_L124  L_L193  0.0011
K_K21310  L_L124  L_L194  0.0011
K_K21311  L_L124  L_L195  0.0011
K_K21312  L_L124  L_L196  0.0011
K_K21313  L_L124  L_L197  0.0012
K_K21314  L_L124  L_L198  0.0012
K_K21315  L_L124  L_L199  0.0012
K_K21316  L_L124  L_L200  0.0012
K_K21317  L_L124  L_L201  0.0012
K_K21318  L_L124  L_L202  0.0013
K_K21319  L_L124  L_L203  0.0013
K_K21320  L_L124  L_L204  0.0013
K_K21321  L_L124  L_L205  0.0013
K_K21322  L_L124  L_L206  0.0014
K_K21323  L_L124  L_L207  0.0014
K_K21324  L_L124  L_L208  0.0014
K_K21325  L_L124  L_L209  0.0014
K_K21326  L_L124  L_L210  0.0015
K_K21327  L_L124  L_L211  0.0015
K_K21328  L_L124  L_L212  0.0015
K_K21329  L_L124  L_L213  0.0015
K_K21330  L_L124  L_L214  0.0016
K_K21331  L_L124  L_L215  0.0016
K_K21332  L_L124  L_L216  0.0016
K_K21333  L_L124  L_L217  0.0017
K_K21334  L_L124  L_L218  0.0017
K_K21335  L_L124  L_L219  0.0018
K_K21336  L_L124  L_L220  0.0018
K_K21337  L_L124  L_L221  0.0018
K_K21338  L_L124  L_L222  0.0019
K_K21339  L_L124  L_L223  0.0019
K_K21340  L_L124  L_L224  0.0020
K_K21341  L_L124  L_L225  0.0020
K_K21342  L_L124  L_L226  0.0021
K_K21343  L_L124  L_L227  0.0022
K_K21344  L_L124  L_L228  0.0022
K_K21345  L_L124  L_L229  0.0023
K_K21346  L_L124  L_L230  0.0024
K_K21347  L_L124  L_L231  0.0024
K_K21348  L_L124  L_L232  0.0025
K_K21349  L_L124  L_L233  0.0026
K_K21350  L_L124  L_L234  0.0027
K_K21351  L_L124  L_L235  0.0028
K_K21352  L_L124  L_L236  0.0029
K_K21353  L_L124  L_L237  0.0030
K_K21354  L_L124  L_L238  0.0032
K_K21355  L_L124  L_L239  0.0033
K_K21356  L_L124  L_L240  0.0034
K_K21357  L_L124  L_L241  0.0036
K_K21358  L_L124  L_L242  0.0038
K_K21359  L_L124  L_L243  0.0040
K_K21360  L_L124  L_L244  0.0042
K_K21361  L_L124  L_L245  0.0045
K_K21362  L_L124  L_L246  0.0047
K_K21363  L_L124  L_L247  0.0051
K_K21364  L_L124  L_L248  0.0054
K_K21365  L_L124  L_L249  0.0058
K_K21366  L_L124  L_L250  0.0063
K_K21367  L_L124  L_L251  0.0069
K_K21368  L_L124  L_L252  0.0076
K_K21369  L_L124  L_L253  0.0084
K_K21370  L_L124  L_L254  0.0095
K_K21371  L_L124  L_L255  0.0109
K_K21372  L_L124  L_L256  0.0127
K_K21373  L_L124  L_L257  0.0152
K_K21374  L_L124  L_L258  0.0191
K_K21375  L_L124  L_L259  0.0256
K_K21376  L_L124  L_L260  0.0389
K_K21377  L_L124  L_L261  0.0812
K_K21378  L_L124  L_L262  0.1569
K_K21379  L_L124  L_L263  0.0812
K_K21380  L_L124  L_L264  0.0389
K_K21381  L_L124  L_L265  0.0256
K_K21382  L_L124  L_L266  0.0191
K_K21383  L_L124  L_L267  0.0152
K_K21384  L_L124  L_L268  0.0127
K_K21385  L_L124  L_L269  0.0109
K_K21386  L_L124  L_L270  0.0095
K_K21387  L_L124  L_L271  0.0084
K_K21388  L_L124  L_L272  0.0076
K_K21389  L_L124  L_L273  0.0069
K_K21390  L_L124  L_L274  0.0063
K_K21391  L_L124  L_L275  0.0058
K_K21392  L_L124  L_L276  0.0054
* *  Branch  NTMP0000000124 - NTMP0000000125
R_R125  NTMP0000000124  nU_125  32.914993m  TC=0,0
V_Ui125  nU_125  nR_125  STIMULUS=U_IND_0000000125
R_V249  nR_125  nV_249  23.280268m  TC=0,0
L_V249  nR_125  nV_249  0.014646uH
R_V250  nV_249  nV_250  7.852787m  TC=0,0
L_V250  nV_249  nV_250  0.073723uH
L_L125  nV_250  NTMP0000000125  6.519695uH
K_K21393  L_L125  L_L126  0.1050
K_K21394  L_L125  L_L127  0.0397
K_K21395  L_L125  L_L128  0.0258
K_K21396  L_L125  L_L129  0.0192
K_K21397  L_L125  L_L130  0.0153
K_K21398  L_L125  L_L131  0.0127
K_K21399  L_L125  L_L132  0.0109
K_K21400  L_L125  L_L133  0.0095
K_K21401  L_L125  L_L134  0.0084
K_K21402  L_L125  L_L135  0.0076
K_K21403  L_L125  L_L136  0.0069
K_K21404  L_L125  L_L137  0.0063
K_K21405  L_L125  L_L138  0.0058
K_K21406  L_L125  L_L188  0.0010
K_K21407  L_L125  L_L189  0.0010
K_K21408  L_L125  L_L190  0.0010
K_K21409  L_L125  L_L191  0.0011
K_K21410  L_L125  L_L192  0.0011
K_K21411  L_L125  L_L193  0.0011
K_K21412  L_L125  L_L194  0.0011
K_K21413  L_L125  L_L195  0.0011
K_K21414  L_L125  L_L196  0.0011
K_K21415  L_L125  L_L197  0.0011
K_K21416  L_L125  L_L198  0.0012
K_K21417  L_L125  L_L199  0.0012
K_K21418  L_L125  L_L200  0.0012
K_K21419  L_L125  L_L201  0.0012
K_K21420  L_L125  L_L202  0.0012
K_K21421  L_L125  L_L203  0.0013
K_K21422  L_L125  L_L204  0.0013
K_K21423  L_L125  L_L205  0.0013
K_K21424  L_L125  L_L206  0.0013
K_K21425  L_L125  L_L207  0.0014
K_K21426  L_L125  L_L208  0.0014
K_K21427  L_L125  L_L209  0.0014
K_K21428  L_L125  L_L210  0.0014
K_K21429  L_L125  L_L211  0.0015
K_K21430  L_L125  L_L212  0.0015
K_K21431  L_L125  L_L213  0.0015
K_K21432  L_L125  L_L214  0.0015
K_K21433  L_L125  L_L215  0.0016
K_K21434  L_L125  L_L216  0.0016
K_K21435  L_L125  L_L217  0.0016
K_K21436  L_L125  L_L218  0.0017
K_K21437  L_L125  L_L219  0.0017
K_K21438  L_L125  L_L220  0.0018
K_K21439  L_L125  L_L221  0.0018
K_K21440  L_L125  L_L222  0.0018
K_K21441  L_L125  L_L223  0.0019
K_K21442  L_L125  L_L224  0.0019
K_K21443  L_L125  L_L225  0.0020
K_K21444  L_L125  L_L226  0.0020
K_K21445  L_L125  L_L227  0.0021
K_K21446  L_L125  L_L228  0.0022
K_K21447  L_L125  L_L229  0.0022
K_K21448  L_L125  L_L230  0.0023
K_K21449  L_L125  L_L231  0.0024
K_K21450  L_L125  L_L232  0.0024
K_K21451  L_L125  L_L233  0.0025
K_K21452  L_L125  L_L234  0.0026
K_K21453  L_L125  L_L235  0.0027
K_K21454  L_L125  L_L236  0.0028
K_K21455  L_L125  L_L237  0.0029
K_K21456  L_L125  L_L238  0.0030
K_K21457  L_L125  L_L239  0.0032
K_K21458  L_L125  L_L240  0.0033
K_K21459  L_L125  L_L241  0.0034
K_K21460  L_L125  L_L242  0.0036
K_K21461  L_L125  L_L243  0.0038
K_K21462  L_L125  L_L244  0.0040
K_K21463  L_L125  L_L245  0.0042
K_K21464  L_L125  L_L246  0.0045
K_K21465  L_L125  L_L247  0.0047
K_K21466  L_L125  L_L248  0.0051
K_K21467  L_L125  L_L249  0.0054
K_K21468  L_L125  L_L250  0.0058
K_K21469  L_L125  L_L251  0.0063
K_K21470  L_L125  L_L252  0.0069
K_K21471  L_L125  L_L253  0.0076
K_K21472  L_L125  L_L254  0.0084
K_K21473  L_L125  L_L255  0.0095
K_K21474  L_L125  L_L256  0.0109
K_K21475  L_L125  L_L257  0.0127
K_K21476  L_L125  L_L258  0.0152
K_K21477  L_L125  L_L259  0.0191
K_K21478  L_L125  L_L260  0.0256
K_K21479  L_L125  L_L261  0.0389
K_K21480  L_L125  L_L262  0.0812
K_K21481  L_L125  L_L263  0.1569
K_K21482  L_L125  L_L264  0.0812
K_K21483  L_L125  L_L265  0.0389
K_K21484  L_L125  L_L266  0.0256
K_K21485  L_L125  L_L267  0.0191
K_K21486  L_L125  L_L268  0.0152
K_K21487  L_L125  L_L269  0.0127
K_K21488  L_L125  L_L270  0.0109
K_K21489  L_L125  L_L271  0.0095
K_K21490  L_L125  L_L272  0.0084
K_K21491  L_L125  L_L273  0.0076
K_K21492  L_L125  L_L274  0.0069
K_K21493  L_L125  L_L275  0.0063
K_K21494  L_L125  L_L276  0.0058
* *  Branch  NTMP0000000125 - NTMP0000000126
R_R126  NTMP0000000125  nU_126  32.914993m  TC=0,0
V_Ui126  nU_126  nR_126  STIMULUS=U_IND_0000000126
R_V251  nR_126  nV_251  23.280268m  TC=0,0
L_V251  nR_126  nV_251  0.014646uH
R_V252  nV_251  nV_252  7.852787m  TC=0,0
L_V252  nV_251  nV_252  0.073723uH
L_L126  nV_252  NTMP0000000126  6.519695uH
K_K21495  L_L126  L_L127  0.1050
K_K21496  L_L126  L_L128  0.0397
K_K21497  L_L126  L_L129  0.0258
K_K21498  L_L126  L_L130  0.0192
K_K21499  L_L126  L_L131  0.0153
K_K21500  L_L126  L_L132  0.0127
K_K21501  L_L126  L_L133  0.0109
K_K21502  L_L126  L_L134  0.0095
K_K21503  L_L126  L_L135  0.0084
K_K21504  L_L126  L_L136  0.0076
K_K21505  L_L126  L_L137  0.0069
K_K21506  L_L126  L_L138  0.0063
K_K21507  L_L126  L_L189  0.0010
K_K21508  L_L126  L_L190  0.0010
K_K21509  L_L126  L_L191  0.0010
K_K21510  L_L126  L_L192  0.0011
K_K21511  L_L126  L_L193  0.0011
K_K21512  L_L126  L_L194  0.0011
K_K21513  L_L126  L_L195  0.0011
K_K21514  L_L126  L_L196  0.0011
K_K21515  L_L126  L_L197  0.0011
K_K21516  L_L126  L_L198  0.0011
K_K21517  L_L126  L_L199  0.0012
K_K21518  L_L126  L_L200  0.0012
K_K21519  L_L126  L_L201  0.0012
K_K21520  L_L126  L_L202  0.0012
K_K21521  L_L126  L_L203  0.0012
K_K21522  L_L126  L_L204  0.0013
K_K21523  L_L126  L_L205  0.0013
K_K21524  L_L126  L_L206  0.0013
K_K21525  L_L126  L_L207  0.0013
K_K21526  L_L126  L_L208  0.0014
K_K21527  L_L126  L_L209  0.0014
K_K21528  L_L126  L_L210  0.0014
K_K21529  L_L126  L_L211  0.0014
K_K21530  L_L126  L_L212  0.0015
K_K21531  L_L126  L_L213  0.0015
K_K21532  L_L126  L_L214  0.0015
K_K21533  L_L126  L_L215  0.0015
K_K21534  L_L126  L_L216  0.0016
K_K21535  L_L126  L_L217  0.0016
K_K21536  L_L126  L_L218  0.0016
K_K21537  L_L126  L_L219  0.0017
K_K21538  L_L126  L_L220  0.0017
K_K21539  L_L126  L_L221  0.0018
K_K21540  L_L126  L_L222  0.0018
K_K21541  L_L126  L_L223  0.0018
K_K21542  L_L126  L_L224  0.0019
K_K21543  L_L126  L_L225  0.0019
K_K21544  L_L126  L_L226  0.0020
K_K21545  L_L126  L_L227  0.0020
K_K21546  L_L126  L_L228  0.0021
K_K21547  L_L126  L_L229  0.0022
K_K21548  L_L126  L_L230  0.0022
K_K21549  L_L126  L_L231  0.0023
K_K21550  L_L126  L_L232  0.0024
K_K21551  L_L126  L_L233  0.0024
K_K21552  L_L126  L_L234  0.0025
K_K21553  L_L126  L_L235  0.0026
K_K21554  L_L126  L_L236  0.0027
K_K21555  L_L126  L_L237  0.0028
K_K21556  L_L126  L_L238  0.0029
K_K21557  L_L126  L_L239  0.0030
K_K21558  L_L126  L_L240  0.0032
K_K21559  L_L126  L_L241  0.0033
K_K21560  L_L126  L_L242  0.0034
K_K21561  L_L126  L_L243  0.0036
K_K21562  L_L126  L_L244  0.0038
K_K21563  L_L126  L_L245  0.0040
K_K21564  L_L126  L_L246  0.0042
K_K21565  L_L126  L_L247  0.0045
K_K21566  L_L126  L_L248  0.0047
K_K21567  L_L126  L_L249  0.0051
K_K21568  L_L126  L_L250  0.0054
K_K21569  L_L126  L_L251  0.0058
K_K21570  L_L126  L_L252  0.0063
K_K21571  L_L126  L_L253  0.0069
K_K21572  L_L126  L_L254  0.0076
K_K21573  L_L126  L_L255  0.0084
K_K21574  L_L126  L_L256  0.0095
K_K21575  L_L126  L_L257  0.0109
K_K21576  L_L126  L_L258  0.0127
K_K21577  L_L126  L_L259  0.0152
K_K21578  L_L126  L_L260  0.0191
K_K21579  L_L126  L_L261  0.0256
K_K21580  L_L126  L_L262  0.0389
K_K21581  L_L126  L_L263  0.0812
K_K21582  L_L126  L_L264  0.1569
K_K21583  L_L126  L_L265  0.0812
K_K21584  L_L126  L_L266  0.0389
K_K21585  L_L126  L_L267  0.0256
K_K21586  L_L126  L_L268  0.0191
K_K21587  L_L126  L_L269  0.0152
K_K21588  L_L126  L_L270  0.0127
K_K21589  L_L126  L_L271  0.0109
K_K21590  L_L126  L_L272  0.0095
K_K21591  L_L126  L_L273  0.0084
K_K21592  L_L126  L_L274  0.0076
K_K21593  L_L126  L_L275  0.0069
K_K21594  L_L126  L_L276  0.0063
* *  Branch  NTMP0000000126 - NTMP0000000127
R_R127  NTMP0000000126  nU_127  32.914993m  TC=0,0
V_Ui127  nU_127  nR_127  STIMULUS=U_IND_0000000127
R_V253  nR_127  nV_253  23.280268m  TC=0,0
L_V253  nR_127  nV_253  0.014646uH
R_V254  nV_253  nV_254  7.852787m  TC=0,0
L_V254  nV_253  nV_254  0.073723uH
L_L127  nV_254  NTMP0000000127  6.519695uH
K_K21595  L_L127  L_L128  0.1050
K_K21596  L_L127  L_L129  0.0397
K_K21597  L_L127  L_L130  0.0258
K_K21598  L_L127  L_L131  0.0192
K_K21599  L_L127  L_L132  0.0153
K_K21600  L_L127  L_L133  0.0127
K_K21601  L_L127  L_L134  0.0109
K_K21602  L_L127  L_L135  0.0095
K_K21603  L_L127  L_L136  0.0084
K_K21604  L_L127  L_L137  0.0076
K_K21605  L_L127  L_L138  0.0069
K_K21606  L_L127  L_L190  0.0010
K_K21607  L_L127  L_L191  0.0010
K_K21608  L_L127  L_L192  0.0010
K_K21609  L_L127  L_L193  0.0011
K_K21610  L_L127  L_L194  0.0011
K_K21611  L_L127  L_L195  0.0011
K_K21612  L_L127  L_L196  0.0011
K_K21613  L_L127  L_L197  0.0011
K_K21614  L_L127  L_L198  0.0011
K_K21615  L_L127  L_L199  0.0011
K_K21616  L_L127  L_L200  0.0012
K_K21617  L_L127  L_L201  0.0012
K_K21618  L_L127  L_L202  0.0012
K_K21619  L_L127  L_L203  0.0012
K_K21620  L_L127  L_L204  0.0012
K_K21621  L_L127  L_L205  0.0013
K_K21622  L_L127  L_L206  0.0013
K_K21623  L_L127  L_L207  0.0013
K_K21624  L_L127  L_L208  0.0013
K_K21625  L_L127  L_L209  0.0014
K_K21626  L_L127  L_L210  0.0014
K_K21627  L_L127  L_L211  0.0014
K_K21628  L_L127  L_L212  0.0014
K_K21629  L_L127  L_L213  0.0015
K_K21630  L_L127  L_L214  0.0015
K_K21631  L_L127  L_L215  0.0015
K_K21632  L_L127  L_L216  0.0015
K_K21633  L_L127  L_L217  0.0016
K_K21634  L_L127  L_L218  0.0016
K_K21635  L_L127  L_L219  0.0016
K_K21636  L_L127  L_L220  0.0017
K_K21637  L_L127  L_L221  0.0017
K_K21638  L_L127  L_L222  0.0018
K_K21639  L_L127  L_L223  0.0018
K_K21640  L_L127  L_L224  0.0018
K_K21641  L_L127  L_L225  0.0019
K_K21642  L_L127  L_L226  0.0019
K_K21643  L_L127  L_L227  0.0020
K_K21644  L_L127  L_L228  0.0020
K_K21645  L_L127  L_L229  0.0021
K_K21646  L_L127  L_L230  0.0022
K_K21647  L_L127  L_L231  0.0022
K_K21648  L_L127  L_L232  0.0023
K_K21649  L_L127  L_L233  0.0024
K_K21650  L_L127  L_L234  0.0024
K_K21651  L_L127  L_L235  0.0025
K_K21652  L_L127  L_L236  0.0026
K_K21653  L_L127  L_L237  0.0027
K_K21654  L_L127  L_L238  0.0028
K_K21655  L_L127  L_L239  0.0029
K_K21656  L_L127  L_L240  0.0030
K_K21657  L_L127  L_L241  0.0032
K_K21658  L_L127  L_L242  0.0033
K_K21659  L_L127  L_L243  0.0034
K_K21660  L_L127  L_L244  0.0036
K_K21661  L_L127  L_L245  0.0038
K_K21662  L_L127  L_L246  0.0040
K_K21663  L_L127  L_L247  0.0042
K_K21664  L_L127  L_L248  0.0045
K_K21665  L_L127  L_L249  0.0047
K_K21666  L_L127  L_L250  0.0051
K_K21667  L_L127  L_L251  0.0054
K_K21668  L_L127  L_L252  0.0058
K_K21669  L_L127  L_L253  0.0063
K_K21670  L_L127  L_L254  0.0069
K_K21671  L_L127  L_L255  0.0076
K_K21672  L_L127  L_L256  0.0084
K_K21673  L_L127  L_L257  0.0095
K_K21674  L_L127  L_L258  0.0109
K_K21675  L_L127  L_L259  0.0127
K_K21676  L_L127  L_L260  0.0152
K_K21677  L_L127  L_L261  0.0191
K_K21678  L_L127  L_L262  0.0256
K_K21679  L_L127  L_L263  0.0389
K_K21680  L_L127  L_L264  0.0812
K_K21681  L_L127  L_L265  0.1569
K_K21682  L_L127  L_L266  0.0812
K_K21683  L_L127  L_L267  0.0389
K_K21684  L_L127  L_L268  0.0256
K_K21685  L_L127  L_L269  0.0191
K_K21686  L_L127  L_L270  0.0152
K_K21687  L_L127  L_L271  0.0127
K_K21688  L_L127  L_L272  0.0109
K_K21689  L_L127  L_L273  0.0095
K_K21690  L_L127  L_L274  0.0084
K_K21691  L_L127  L_L275  0.0076
K_K21692  L_L127  L_L276  0.0069
* *  Branch  NTMP0000000127 - NTMP0000000128
R_R128  NTMP0000000127  nU_128  32.914993m  TC=0,0
V_Ui128  nU_128  nR_128  STIMULUS=U_IND_0000000128
R_V255  nR_128  nV_255  23.280268m  TC=0,0
L_V255  nR_128  nV_255  0.014646uH
R_V256  nV_255  nV_256  7.852787m  TC=0,0
L_V256  nV_255  nV_256  0.073723uH
L_L128  nV_256  NTMP0000000128  6.519695uH
K_K21693  L_L128  L_L129  0.1050
K_K21694  L_L128  L_L130  0.0397
K_K21695  L_L128  L_L131  0.0258
K_K21696  L_L128  L_L132  0.0192
K_K21697  L_L128  L_L133  0.0153
K_K21698  L_L128  L_L134  0.0127
K_K21699  L_L128  L_L135  0.0109
K_K21700  L_L128  L_L136  0.0095
K_K21701  L_L128  L_L137  0.0084
K_K21702  L_L128  L_L138  0.0076
K_K21703  L_L128  L_L191  0.0010
K_K21704  L_L128  L_L192  0.0010
K_K21705  L_L128  L_L193  0.0010
K_K21706  L_L128  L_L194  0.0011
K_K21707  L_L128  L_L195  0.0011
K_K21708  L_L128  L_L196  0.0011
K_K21709  L_L128  L_L197  0.0011
K_K21710  L_L128  L_L198  0.0011
K_K21711  L_L128  L_L199  0.0011
K_K21712  L_L128  L_L200  0.0011
K_K21713  L_L128  L_L201  0.0012
K_K21714  L_L128  L_L202  0.0012
K_K21715  L_L128  L_L203  0.0012
K_K21716  L_L128  L_L204  0.0012
K_K21717  L_L128  L_L205  0.0012
K_K21718  L_L128  L_L206  0.0013
K_K21719  L_L128  L_L207  0.0013
K_K21720  L_L128  L_L208  0.0013
K_K21721  L_L128  L_L209  0.0013
K_K21722  L_L128  L_L210  0.0014
K_K21723  L_L128  L_L211  0.0014
K_K21724  L_L128  L_L212  0.0014
K_K21725  L_L128  L_L213  0.0014
K_K21726  L_L128  L_L214  0.0015
K_K21727  L_L128  L_L215  0.0015
K_K21728  L_L128  L_L216  0.0015
K_K21729  L_L128  L_L217  0.0015
K_K21730  L_L128  L_L218  0.0016
K_K21731  L_L128  L_L219  0.0016
K_K21732  L_L128  L_L220  0.0016
K_K21733  L_L128  L_L221  0.0017
K_K21734  L_L128  L_L222  0.0017
K_K21735  L_L128  L_L223  0.0018
K_K21736  L_L128  L_L224  0.0018
K_K21737  L_L128  L_L225  0.0018
K_K21738  L_L128  L_L226  0.0019
K_K21739  L_L128  L_L227  0.0019
K_K21740  L_L128  L_L228  0.0020
K_K21741  L_L128  L_L229  0.0020
K_K21742  L_L128  L_L230  0.0021
K_K21743  L_L128  L_L231  0.0022
K_K21744  L_L128  L_L232  0.0022
K_K21745  L_L128  L_L233  0.0023
K_K21746  L_L128  L_L234  0.0024
K_K21747  L_L128  L_L235  0.0024
K_K21748  L_L128  L_L236  0.0025
K_K21749  L_L128  L_L237  0.0026
K_K21750  L_L128  L_L238  0.0027
K_K21751  L_L128  L_L239  0.0028
K_K21752  L_L128  L_L240  0.0029
K_K21753  L_L128  L_L241  0.0030
K_K21754  L_L128  L_L242  0.0032
K_K21755  L_L128  L_L243  0.0033
K_K21756  L_L128  L_L244  0.0034
K_K21757  L_L128  L_L245  0.0036
K_K21758  L_L128  L_L246  0.0038
K_K21759  L_L128  L_L247  0.0040
K_K21760  L_L128  L_L248  0.0042
K_K21761  L_L128  L_L249  0.0045
K_K21762  L_L128  L_L250  0.0047
K_K21763  L_L128  L_L251  0.0051
K_K21764  L_L128  L_L252  0.0054
K_K21765  L_L128  L_L253  0.0058
K_K21766  L_L128  L_L254  0.0063
K_K21767  L_L128  L_L255  0.0069
K_K21768  L_L128  L_L256  0.0076
K_K21769  L_L128  L_L257  0.0084
K_K21770  L_L128  L_L258  0.0095
K_K21771  L_L128  L_L259  0.0109
K_K21772  L_L128  L_L260  0.0127
K_K21773  L_L128  L_L261  0.0152
K_K21774  L_L128  L_L262  0.0191
K_K21775  L_L128  L_L263  0.0256
K_K21776  L_L128  L_L264  0.0389
K_K21777  L_L128  L_L265  0.0812
K_K21778  L_L128  L_L266  0.1569
K_K21779  L_L128  L_L267  0.0812
K_K21780  L_L128  L_L268  0.0389
K_K21781  L_L128  L_L269  0.0256
K_K21782  L_L128  L_L270  0.0191
K_K21783  L_L128  L_L271  0.0152
K_K21784  L_L128  L_L272  0.0127
K_K21785  L_L128  L_L273  0.0109
K_K21786  L_L128  L_L274  0.0095
K_K21787  L_L128  L_L275  0.0084
K_K21788  L_L128  L_L276  0.0076
* *  Branch  NTMP0000000128 - NTMP0000000129
R_R129  NTMP0000000128  nU_129  32.914993m  TC=0,0
V_Ui129  nU_129  nR_129  STIMULUS=U_IND_0000000129
R_V257  nR_129  nV_257  23.280268m  TC=0,0
L_V257  nR_129  nV_257  0.014646uH
R_V258  nV_257  nV_258  7.852787m  TC=0,0
L_V258  nV_257  nV_258  0.073723uH
L_L129  nV_258  NTMP0000000129  6.519695uH
K_K21789  L_L129  L_L130  0.1050
K_K21790  L_L129  L_L131  0.0397
K_K21791  L_L129  L_L132  0.0258
K_K21792  L_L129  L_L133  0.0192
K_K21793  L_L129  L_L134  0.0153
K_K21794  L_L129  L_L135  0.0127
K_K21795  L_L129  L_L136  0.0109
K_K21796  L_L129  L_L137  0.0095
K_K21797  L_L129  L_L138  0.0084
K_K21798  L_L129  L_L192  0.0010
K_K21799  L_L129  L_L193  0.0010
K_K21800  L_L129  L_L194  0.0010
K_K21801  L_L129  L_L195  0.0011
K_K21802  L_L129  L_L196  0.0011
K_K21803  L_L129  L_L197  0.0011
K_K21804  L_L129  L_L198  0.0011
K_K21805  L_L129  L_L199  0.0011
K_K21806  L_L129  L_L200  0.0011
K_K21807  L_L129  L_L201  0.0011
K_K21808  L_L129  L_L202  0.0012
K_K21809  L_L129  L_L203  0.0012
K_K21810  L_L129  L_L204  0.0012
K_K21811  L_L129  L_L205  0.0012
K_K21812  L_L129  L_L206  0.0012
K_K21813  L_L129  L_L207  0.0013
K_K21814  L_L129  L_L208  0.0013
K_K21815  L_L129  L_L209  0.0013
K_K21816  L_L129  L_L210  0.0013
K_K21817  L_L129  L_L211  0.0014
K_K21818  L_L129  L_L212  0.0014
K_K21819  L_L129  L_L213  0.0014
K_K21820  L_L129  L_L214  0.0014
K_K21821  L_L129  L_L215  0.0015
K_K21822  L_L129  L_L216  0.0015
K_K21823  L_L129  L_L217  0.0015
K_K21824  L_L129  L_L218  0.0015
K_K21825  L_L129  L_L219  0.0016
K_K21826  L_L129  L_L220  0.0016
K_K21827  L_L129  L_L221  0.0016
K_K21828  L_L129  L_L222  0.0017
K_K21829  L_L129  L_L223  0.0017
K_K21830  L_L129  L_L224  0.0018
K_K21831  L_L129  L_L225  0.0018
K_K21832  L_L129  L_L226  0.0018
K_K21833  L_L129  L_L227  0.0019
K_K21834  L_L129  L_L228  0.0019
K_K21835  L_L129  L_L229  0.0020
K_K21836  L_L129  L_L230  0.0020
K_K21837  L_L129  L_L231  0.0021
K_K21838  L_L129  L_L232  0.0022
K_K21839  L_L129  L_L233  0.0022
K_K21840  L_L129  L_L234  0.0023
K_K21841  L_L129  L_L235  0.0024
K_K21842  L_L129  L_L236  0.0024
K_K21843  L_L129  L_L237  0.0025
K_K21844  L_L129  L_L238  0.0026
K_K21845  L_L129  L_L239  0.0027
K_K21846  L_L129  L_L240  0.0028
K_K21847  L_L129  L_L241  0.0029
K_K21848  L_L129  L_L242  0.0030
K_K21849  L_L129  L_L243  0.0032
K_K21850  L_L129  L_L244  0.0033
K_K21851  L_L129  L_L245  0.0034
K_K21852  L_L129  L_L246  0.0036
K_K21853  L_L129  L_L247  0.0038
K_K21854  L_L129  L_L248  0.0040
K_K21855  L_L129  L_L249  0.0042
K_K21856  L_L129  L_L250  0.0045
K_K21857  L_L129  L_L251  0.0047
K_K21858  L_L129  L_L252  0.0051
K_K21859  L_L129  L_L253  0.0054
K_K21860  L_L129  L_L254  0.0058
K_K21861  L_L129  L_L255  0.0063
K_K21862  L_L129  L_L256  0.0069
K_K21863  L_L129  L_L257  0.0076
K_K21864  L_L129  L_L258  0.0084
K_K21865  L_L129  L_L259  0.0095
K_K21866  L_L129  L_L260  0.0109
K_K21867  L_L129  L_L261  0.0127
K_K21868  L_L129  L_L262  0.0152
K_K21869  L_L129  L_L263  0.0191
K_K21870  L_L129  L_L264  0.0256
K_K21871  L_L129  L_L265  0.0389
K_K21872  L_L129  L_L266  0.0812
K_K21873  L_L129  L_L267  0.1569
K_K21874  L_L129  L_L268  0.0812
K_K21875  L_L129  L_L269  0.0389
K_K21876  L_L129  L_L270  0.0256
K_K21877  L_L129  L_L271  0.0191
K_K21878  L_L129  L_L272  0.0152
K_K21879  L_L129  L_L273  0.0127
K_K21880  L_L129  L_L274  0.0109
K_K21881  L_L129  L_L275  0.0095
K_K21882  L_L129  L_L276  0.0084
* *  Branch  NTMP0000000129 - NTMP0000000130
R_R130  NTMP0000000129  nU_130  32.914993m  TC=0,0
V_Ui130  nU_130  nR_130  STIMULUS=U_IND_0000000130
R_V259  nR_130  nV_259  23.280268m  TC=0,0
L_V259  nR_130  nV_259  0.014646uH
R_V260  nV_259  nV_260  7.852787m  TC=0,0
L_V260  nV_259  nV_260  0.073723uH
L_L130  nV_260  NTMP0000000130  6.519695uH
K_K21883  L_L130  L_L131  0.1050
K_K21884  L_L130  L_L132  0.0397
K_K21885  L_L130  L_L133  0.0258
K_K21886  L_L130  L_L134  0.0192
K_K21887  L_L130  L_L135  0.0153
K_K21888  L_L130  L_L136  0.0127
K_K21889  L_L130  L_L137  0.0109
K_K21890  L_L130  L_L138  0.0095
K_K21891  L_L130  L_L193  0.0010
K_K21892  L_L130  L_L194  0.0010
K_K21893  L_L130  L_L195  0.0010
K_K21894  L_L130  L_L196  0.0011
K_K21895  L_L130  L_L197  0.0011
K_K21896  L_L130  L_L198  0.0011
K_K21897  L_L130  L_L199  0.0011
K_K21898  L_L130  L_L200  0.0011
K_K21899  L_L130  L_L201  0.0011
K_K21900  L_L130  L_L202  0.0011
K_K21901  L_L130  L_L203  0.0012
K_K21902  L_L130  L_L204  0.0012
K_K21903  L_L130  L_L205  0.0012
K_K21904  L_L130  L_L206  0.0012
K_K21905  L_L130  L_L207  0.0012
K_K21906  L_L130  L_L208  0.0013
K_K21907  L_L130  L_L209  0.0013
K_K21908  L_L130  L_L210  0.0013
K_K21909  L_L130  L_L211  0.0013
K_K21910  L_L130  L_L212  0.0014
K_K21911  L_L130  L_L213  0.0014
K_K21912  L_L130  L_L214  0.0014
K_K21913  L_L130  L_L215  0.0014
K_K21914  L_L130  L_L216  0.0015
K_K21915  L_L130  L_L217  0.0015
K_K21916  L_L130  L_L218  0.0015
K_K21917  L_L130  L_L219  0.0015
K_K21918  L_L130  L_L220  0.0016
K_K21919  L_L130  L_L221  0.0016
K_K21920  L_L130  L_L222  0.0016
K_K21921  L_L130  L_L223  0.0017
K_K21922  L_L130  L_L224  0.0017
K_K21923  L_L130  L_L225  0.0018
K_K21924  L_L130  L_L226  0.0018
K_K21925  L_L130  L_L227  0.0018
K_K21926  L_L130  L_L228  0.0019
K_K21927  L_L130  L_L229  0.0019
K_K21928  L_L130  L_L230  0.0020
K_K21929  L_L130  L_L231  0.0020
K_K21930  L_L130  L_L232  0.0021
K_K21931  L_L130  L_L233  0.0022
K_K21932  L_L130  L_L234  0.0022
K_K21933  L_L130  L_L235  0.0023
K_K21934  L_L130  L_L236  0.0024
K_K21935  L_L130  L_L237  0.0024
K_K21936  L_L130  L_L238  0.0025
K_K21937  L_L130  L_L239  0.0026
K_K21938  L_L130  L_L240  0.0027
K_K21939  L_L130  L_L241  0.0028
K_K21940  L_L130  L_L242  0.0029
K_K21941  L_L130  L_L243  0.0030
K_K21942  L_L130  L_L244  0.0032
K_K21943  L_L130  L_L245  0.0033
K_K21944  L_L130  L_L246  0.0034
K_K21945  L_L130  L_L247  0.0036
K_K21946  L_L130  L_L248  0.0038
K_K21947  L_L130  L_L249  0.0040
K_K21948  L_L130  L_L250  0.0042
K_K21949  L_L130  L_L251  0.0045
K_K21950  L_L130  L_L252  0.0047
K_K21951  L_L130  L_L253  0.0051
K_K21952  L_L130  L_L254  0.0054
K_K21953  L_L130  L_L255  0.0058
K_K21954  L_L130  L_L256  0.0063
K_K21955  L_L130  L_L257  0.0069
K_K21956  L_L130  L_L258  0.0076
K_K21957  L_L130  L_L259  0.0084
K_K21958  L_L130  L_L260  0.0095
K_K21959  L_L130  L_L261  0.0109
K_K21960  L_L130  L_L262  0.0127
K_K21961  L_L130  L_L263  0.0152
K_K21962  L_L130  L_L264  0.0191
K_K21963  L_L130  L_L265  0.0256
K_K21964  L_L130  L_L266  0.0389
K_K21965  L_L130  L_L267  0.0812
K_K21966  L_L130  L_L268  0.1569
K_K21967  L_L130  L_L269  0.0812
K_K21968  L_L130  L_L270  0.0389
K_K21969  L_L130  L_L271  0.0256
K_K21970  L_L130  L_L272  0.0191
K_K21971  L_L130  L_L273  0.0152
K_K21972  L_L130  L_L274  0.0127
K_K21973  L_L130  L_L275  0.0109
K_K21974  L_L130  L_L276  0.0095
* *  Branch  NTMP0000000130 - NTMP0000000131
R_R131  NTMP0000000130  nU_131  32.914993m  TC=0,0
V_Ui131  nU_131  nR_131  STIMULUS=U_IND_0000000131
R_V261  nR_131  nV_261  23.280268m  TC=0,0
L_V261  nR_131  nV_261  0.014646uH
R_V262  nV_261  nV_262  7.852787m  TC=0,0
L_V262  nV_261  nV_262  0.073723uH
L_L131  nV_262  NTMP0000000131  6.519695uH
K_K21975  L_L131  L_L132  0.1050
K_K21976  L_L131  L_L133  0.0397
K_K21977  L_L131  L_L134  0.0258
K_K21978  L_L131  L_L135  0.0192
K_K21979  L_L131  L_L136  0.0153
K_K21980  L_L131  L_L137  0.0127
K_K21981  L_L131  L_L138  0.0109
K_K21982  L_L131  L_L194  0.0010
K_K21983  L_L131  L_L195  0.0010
K_K21984  L_L131  L_L196  0.0010
K_K21985  L_L131  L_L197  0.0011
K_K21986  L_L131  L_L198  0.0011
K_K21987  L_L131  L_L199  0.0011
K_K21988  L_L131  L_L200  0.0011
K_K21989  L_L131  L_L201  0.0011
K_K21990  L_L131  L_L202  0.0011
K_K21991  L_L131  L_L203  0.0011
K_K21992  L_L131  L_L204  0.0012
K_K21993  L_L131  L_L205  0.0012
K_K21994  L_L131  L_L206  0.0012
K_K21995  L_L131  L_L207  0.0012
K_K21996  L_L131  L_L208  0.0012
K_K21997  L_L131  L_L209  0.0013
K_K21998  L_L131  L_L210  0.0013
K_K21999  L_L131  L_L211  0.0013
K_K22000  L_L131  L_L212  0.0013
K_K22001  L_L131  L_L213  0.0014
K_K22002  L_L131  L_L214  0.0014
K_K22003  L_L131  L_L215  0.0014
K_K22004  L_L131  L_L216  0.0014
K_K22005  L_L131  L_L217  0.0015
K_K22006  L_L131  L_L218  0.0015
K_K22007  L_L131  L_L219  0.0015
K_K22008  L_L131  L_L220  0.0015
K_K22009  L_L131  L_L221  0.0016
K_K22010  L_L131  L_L222  0.0016
K_K22011  L_L131  L_L223  0.0016
K_K22012  L_L131  L_L224  0.0017
K_K22013  L_L131  L_L225  0.0017
K_K22014  L_L131  L_L226  0.0018
K_K22015  L_L131  L_L227  0.0018
K_K22016  L_L131  L_L228  0.0018
K_K22017  L_L131  L_L229  0.0019
K_K22018  L_L131  L_L230  0.0019
K_K22019  L_L131  L_L231  0.0020
K_K22020  L_L131  L_L232  0.0020
K_K22021  L_L131  L_L233  0.0021
K_K22022  L_L131  L_L234  0.0022
K_K22023  L_L131  L_L235  0.0022
K_K22024  L_L131  L_L236  0.0023
K_K22025  L_L131  L_L237  0.0024
K_K22026  L_L131  L_L238  0.0024
K_K22027  L_L131  L_L239  0.0025
K_K22028  L_L131  L_L240  0.0026
K_K22029  L_L131  L_L241  0.0027
K_K22030  L_L131  L_L242  0.0028
K_K22031  L_L131  L_L243  0.0029
K_K22032  L_L131  L_L244  0.0030
K_K22033  L_L131  L_L245  0.0032
K_K22034  L_L131  L_L246  0.0033
K_K22035  L_L131  L_L247  0.0034
K_K22036  L_L131  L_L248  0.0036
K_K22037  L_L131  L_L249  0.0038
K_K22038  L_L131  L_L250  0.0040
K_K22039  L_L131  L_L251  0.0042
K_K22040  L_L131  L_L252  0.0045
K_K22041  L_L131  L_L253  0.0047
K_K22042  L_L131  L_L254  0.0051
K_K22043  L_L131  L_L255  0.0054
K_K22044  L_L131  L_L256  0.0058
K_K22045  L_L131  L_L257  0.0063
K_K22046  L_L131  L_L258  0.0069
K_K22047  L_L131  L_L259  0.0076
K_K22048  L_L131  L_L260  0.0084
K_K22049  L_L131  L_L261  0.0095
K_K22050  L_L131  L_L262  0.0109
K_K22051  L_L131  L_L263  0.0127
K_K22052  L_L131  L_L264  0.0152
K_K22053  L_L131  L_L265  0.0191
K_K22054  L_L131  L_L266  0.0256
K_K22055  L_L131  L_L267  0.0389
K_K22056  L_L131  L_L268  0.0812
K_K22057  L_L131  L_L269  0.1569
K_K22058  L_L131  L_L270  0.0812
K_K22059  L_L131  L_L271  0.0389
K_K22060  L_L131  L_L272  0.0256
K_K22061  L_L131  L_L273  0.0191
K_K22062  L_L131  L_L274  0.0152
K_K22063  L_L131  L_L275  0.0127
K_K22064  L_L131  L_L276  0.0109
* *  Branch  NTMP0000000131 - NTMP0000000132
R_R132  NTMP0000000131  nU_132  32.914993m  TC=0,0
V_Ui132  nU_132  nR_132  STIMULUS=U_IND_0000000132
R_V263  nR_132  nV_263  23.280268m  TC=0,0
L_V263  nR_132  nV_263  0.014646uH
R_V264  nV_263  nV_264  7.852787m  TC=0,0
L_V264  nV_263  nV_264  0.073723uH
L_L132  nV_264  NTMP0000000132  6.519695uH
K_K22065  L_L132  L_L133  0.1050
K_K22066  L_L132  L_L134  0.0397
K_K22067  L_L132  L_L135  0.0258
K_K22068  L_L132  L_L136  0.0192
K_K22069  L_L132  L_L137  0.0153
K_K22070  L_L132  L_L138  0.0127
K_K22071  L_L132  L_L195  0.0010
K_K22072  L_L132  L_L196  0.0010
K_K22073  L_L132  L_L197  0.0010
K_K22074  L_L132  L_L198  0.0011
K_K22075  L_L132  L_L199  0.0011
K_K22076  L_L132  L_L200  0.0011
K_K22077  L_L132  L_L201  0.0011
K_K22078  L_L132  L_L202  0.0011
K_K22079  L_L132  L_L203  0.0011
K_K22080  L_L132  L_L204  0.0011
K_K22081  L_L132  L_L205  0.0012
K_K22082  L_L132  L_L206  0.0012
K_K22083  L_L132  L_L207  0.0012
K_K22084  L_L132  L_L208  0.0012
K_K22085  L_L132  L_L209  0.0012
K_K22086  L_L132  L_L210  0.0013
K_K22087  L_L132  L_L211  0.0013
K_K22088  L_L132  L_L212  0.0013
K_K22089  L_L132  L_L213  0.0013
K_K22090  L_L132  L_L214  0.0014
K_K22091  L_L132  L_L215  0.0014
K_K22092  L_L132  L_L216  0.0014
K_K22093  L_L132  L_L217  0.0014
K_K22094  L_L132  L_L218  0.0015
K_K22095  L_L132  L_L219  0.0015
K_K22096  L_L132  L_L220  0.0015
K_K22097  L_L132  L_L221  0.0015
K_K22098  L_L132  L_L222  0.0016
K_K22099  L_L132  L_L223  0.0016
K_K22100  L_L132  L_L224  0.0016
K_K22101  L_L132  L_L225  0.0017
K_K22102  L_L132  L_L226  0.0017
K_K22103  L_L132  L_L227  0.0018
K_K22104  L_L132  L_L228  0.0018
K_K22105  L_L132  L_L229  0.0018
K_K22106  L_L132  L_L230  0.0019
K_K22107  L_L132  L_L231  0.0019
K_K22108  L_L132  L_L232  0.0020
K_K22109  L_L132  L_L233  0.0020
K_K22110  L_L132  L_L234  0.0021
K_K22111  L_L132  L_L235  0.0022
K_K22112  L_L132  L_L236  0.0022
K_K22113  L_L132  L_L237  0.0023
K_K22114  L_L132  L_L238  0.0024
K_K22115  L_L132  L_L239  0.0024
K_K22116  L_L132  L_L240  0.0025
K_K22117  L_L132  L_L241  0.0026
K_K22118  L_L132  L_L242  0.0027
K_K22119  L_L132  L_L243  0.0028
K_K22120  L_L132  L_L244  0.0029
K_K22121  L_L132  L_L245  0.0030
K_K22122  L_L132  L_L246  0.0032
K_K22123  L_L132  L_L247  0.0033
K_K22124  L_L132  L_L248  0.0034
K_K22125  L_L132  L_L249  0.0036
K_K22126  L_L132  L_L250  0.0038
K_K22127  L_L132  L_L251  0.0040
K_K22128  L_L132  L_L252  0.0042
K_K22129  L_L132  L_L253  0.0045
K_K22130  L_L132  L_L254  0.0047
K_K22131  L_L132  L_L255  0.0051
K_K22132  L_L132  L_L256  0.0054
K_K22133  L_L132  L_L257  0.0058
K_K22134  L_L132  L_L258  0.0063
K_K22135  L_L132  L_L259  0.0069
K_K22136  L_L132  L_L260  0.0076
K_K22137  L_L132  L_L261  0.0084
K_K22138  L_L132  L_L262  0.0095
K_K22139  L_L132  L_L263  0.0109
K_K22140  L_L132  L_L264  0.0127
K_K22141  L_L132  L_L265  0.0152
K_K22142  L_L132  L_L266  0.0191
K_K22143  L_L132  L_L267  0.0256
K_K22144  L_L132  L_L268  0.0389
K_K22145  L_L132  L_L269  0.0812
K_K22146  L_L132  L_L270  0.1569
K_K22147  L_L132  L_L271  0.0812
K_K22148  L_L132  L_L272  0.0389
K_K22149  L_L132  L_L273  0.0256
K_K22150  L_L132  L_L274  0.0191
K_K22151  L_L132  L_L275  0.0152
K_K22152  L_L132  L_L276  0.0127
* *  Branch  NTMP0000000132 - NTMP0000000133
R_R133  NTMP0000000132  nU_133  32.914993m  TC=0,0
V_Ui133  nU_133  nR_133  STIMULUS=U_IND_0000000133
R_V265  nR_133  nV_265  23.280268m  TC=0,0
L_V265  nR_133  nV_265  0.014646uH
R_V266  nV_265  nV_266  7.852787m  TC=0,0
L_V266  nV_265  nV_266  0.073723uH
L_L133  nV_266  NTMP0000000133  6.519695uH
K_K22153  L_L133  L_L134  0.1050
K_K22154  L_L133  L_L135  0.0397
K_K22155  L_L133  L_L136  0.0258
K_K22156  L_L133  L_L137  0.0192
K_K22157  L_L133  L_L138  0.0153
K_K22158  L_L133  L_L196  0.0010
K_K22159  L_L133  L_L197  0.0010
K_K22160  L_L133  L_L198  0.0010
K_K22161  L_L133  L_L199  0.0011
K_K22162  L_L133  L_L200  0.0011
K_K22163  L_L133  L_L201  0.0011
K_K22164  L_L133  L_L202  0.0011
K_K22165  L_L133  L_L203  0.0011
K_K22166  L_L133  L_L204  0.0011
K_K22167  L_L133  L_L205  0.0011
K_K22168  L_L133  L_L206  0.0012
K_K22169  L_L133  L_L207  0.0012
K_K22170  L_L133  L_L208  0.0012
K_K22171  L_L133  L_L209  0.0012
K_K22172  L_L133  L_L210  0.0012
K_K22173  L_L133  L_L211  0.0013
K_K22174  L_L133  L_L212  0.0013
K_K22175  L_L133  L_L213  0.0013
K_K22176  L_L133  L_L214  0.0013
K_K22177  L_L133  L_L215  0.0014
K_K22178  L_L133  L_L216  0.0014
K_K22179  L_L133  L_L217  0.0014
K_K22180  L_L133  L_L218  0.0014
K_K22181  L_L133  L_L219  0.0015
K_K22182  L_L133  L_L220  0.0015
K_K22183  L_L133  L_L221  0.0015
K_K22184  L_L133  L_L222  0.0015
K_K22185  L_L133  L_L223  0.0016
K_K22186  L_L133  L_L224  0.0016
K_K22187  L_L133  L_L225  0.0016
K_K22188  L_L133  L_L226  0.0017
K_K22189  L_L133  L_L227  0.0017
K_K22190  L_L133  L_L228  0.0018
K_K22191  L_L133  L_L229  0.0018
K_K22192  L_L133  L_L230  0.0018
K_K22193  L_L133  L_L231  0.0019
K_K22194  L_L133  L_L232  0.0019
K_K22195  L_L133  L_L233  0.0020
K_K22196  L_L133  L_L234  0.0020
K_K22197  L_L133  L_L235  0.0021
K_K22198  L_L133  L_L236  0.0022
K_K22199  L_L133  L_L237  0.0022
K_K22200  L_L133  L_L238  0.0023
K_K22201  L_L133  L_L239  0.0024
K_K22202  L_L133  L_L240  0.0024
K_K22203  L_L133  L_L241  0.0025
K_K22204  L_L133  L_L242  0.0026
K_K22205  L_L133  L_L243  0.0027
K_K22206  L_L133  L_L244  0.0028
K_K22207  L_L133  L_L245  0.0029
K_K22208  L_L133  L_L246  0.0030
K_K22209  L_L133  L_L247  0.0032
K_K22210  L_L133  L_L248  0.0033
K_K22211  L_L133  L_L249  0.0034
K_K22212  L_L133  L_L250  0.0036
K_K22213  L_L133  L_L251  0.0038
K_K22214  L_L133  L_L252  0.0040
K_K22215  L_L133  L_L253  0.0042
K_K22216  L_L133  L_L254  0.0045
K_K22217  L_L133  L_L255  0.0047
K_K22218  L_L133  L_L256  0.0051
K_K22219  L_L133  L_L257  0.0054
K_K22220  L_L133  L_L258  0.0058
K_K22221  L_L133  L_L259  0.0063
K_K22222  L_L133  L_L260  0.0069
K_K22223  L_L133  L_L261  0.0076
K_K22224  L_L133  L_L262  0.0084
K_K22225  L_L133  L_L263  0.0095
K_K22226  L_L133  L_L264  0.0109
K_K22227  L_L133  L_L265  0.0127
K_K22228  L_L133  L_L266  0.0152
K_K22229  L_L133  L_L267  0.0191
K_K22230  L_L133  L_L268  0.0256
K_K22231  L_L133  L_L269  0.0389
K_K22232  L_L133  L_L270  0.0812
K_K22233  L_L133  L_L271  0.1569
K_K22234  L_L133  L_L272  0.0812
K_K22235  L_L133  L_L273  0.0389
K_K22236  L_L133  L_L274  0.0256
K_K22237  L_L133  L_L275  0.0191
K_K22238  L_L133  L_L276  0.0152
* *  Branch  NTMP0000000133 - NTMP0000000134
R_R134  NTMP0000000133  nU_134  32.914993m  TC=0,0
V_Ui134  nU_134  nR_134  STIMULUS=U_IND_0000000134
R_V267  nR_134  nV_267  23.280268m  TC=0,0
L_V267  nR_134  nV_267  0.014646uH
R_V268  nV_267  nV_268  7.852787m  TC=0,0
L_V268  nV_267  nV_268  0.073723uH
L_L134  nV_268  NTMP0000000134  6.519695uH
K_K22239  L_L134  L_L135  0.1050
K_K22240  L_L134  L_L136  0.0397
K_K22241  L_L134  L_L137  0.0258
K_K22242  L_L134  L_L138  0.0192
K_K22243  L_L134  L_L197  0.0010
K_K22244  L_L134  L_L198  0.0010
K_K22245  L_L134  L_L199  0.0010
K_K22246  L_L134  L_L200  0.0011
K_K22247  L_L134  L_L201  0.0011
K_K22248  L_L134  L_L202  0.0011
K_K22249  L_L134  L_L203  0.0011
K_K22250  L_L134  L_L204  0.0011
K_K22251  L_L134  L_L205  0.0011
K_K22252  L_L134  L_L206  0.0011
K_K22253  L_L134  L_L207  0.0012
K_K22254  L_L134  L_L208  0.0012
K_K22255  L_L134  L_L209  0.0012
K_K22256  L_L134  L_L210  0.0012
K_K22257  L_L134  L_L211  0.0012
K_K22258  L_L134  L_L212  0.0013
K_K22259  L_L134  L_L213  0.0013
K_K22260  L_L134  L_L214  0.0013
K_K22261  L_L134  L_L215  0.0013
K_K22262  L_L134  L_L216  0.0014
K_K22263  L_L134  L_L217  0.0014
K_K22264  L_L134  L_L218  0.0014
K_K22265  L_L134  L_L219  0.0014
K_K22266  L_L134  L_L220  0.0015
K_K22267  L_L134  L_L221  0.0015
K_K22268  L_L134  L_L222  0.0015
K_K22269  L_L134  L_L223  0.0015
K_K22270  L_L134  L_L224  0.0016
K_K22271  L_L134  L_L225  0.0016
K_K22272  L_L134  L_L226  0.0016
K_K22273  L_L134  L_L227  0.0017
K_K22274  L_L134  L_L228  0.0017
K_K22275  L_L134  L_L229  0.0018
K_K22276  L_L134  L_L230  0.0018
K_K22277  L_L134  L_L231  0.0018
K_K22278  L_L134  L_L232  0.0019
K_K22279  L_L134  L_L233  0.0019
K_K22280  L_L134  L_L234  0.0020
K_K22281  L_L134  L_L235  0.0020
K_K22282  L_L134  L_L236  0.0021
K_K22283  L_L134  L_L237  0.0022
K_K22284  L_L134  L_L238  0.0022
K_K22285  L_L134  L_L239  0.0023
K_K22286  L_L134  L_L240  0.0024
K_K22287  L_L134  L_L241  0.0024
K_K22288  L_L134  L_L242  0.0025
K_K22289  L_L134  L_L243  0.0026
K_K22290  L_L134  L_L244  0.0027
K_K22291  L_L134  L_L245  0.0028
K_K22292  L_L134  L_L246  0.0029
K_K22293  L_L134  L_L247  0.0030
K_K22294  L_L134  L_L248  0.0032
K_K22295  L_L134  L_L249  0.0033
K_K22296  L_L134  L_L250  0.0034
K_K22297  L_L134  L_L251  0.0036
K_K22298  L_L134  L_L252  0.0038
K_K22299  L_L134  L_L253  0.0040
K_K22300  L_L134  L_L254  0.0042
K_K22301  L_L134  L_L255  0.0045
K_K22302  L_L134  L_L256  0.0047
K_K22303  L_L134  L_L257  0.0051
K_K22304  L_L134  L_L258  0.0054
K_K22305  L_L134  L_L259  0.0058
K_K22306  L_L134  L_L260  0.0063
K_K22307  L_L134  L_L261  0.0069
K_K22308  L_L134  L_L262  0.0076
K_K22309  L_L134  L_L263  0.0084
K_K22310  L_L134  L_L264  0.0095
K_K22311  L_L134  L_L265  0.0109
K_K22312  L_L134  L_L266  0.0127
K_K22313  L_L134  L_L267  0.0152
K_K22314  L_L134  L_L268  0.0191
K_K22315  L_L134  L_L269  0.0256
K_K22316  L_L134  L_L270  0.0389
K_K22317  L_L134  L_L271  0.0812
K_K22318  L_L134  L_L272  0.1569
K_K22319  L_L134  L_L273  0.0812
K_K22320  L_L134  L_L274  0.0389
K_K22321  L_L134  L_L275  0.0256
K_K22322  L_L134  L_L276  0.0191
* *  Branch  NTMP0000000134 - NTMP0000000135
R_R135  NTMP0000000134  nU_135  32.914993m  TC=0,0
V_Ui135  nU_135  nR_135  STIMULUS=U_IND_0000000135
R_V269  nR_135  nV_269  23.280268m  TC=0,0
L_V269  nR_135  nV_269  0.014646uH
R_V270  nV_269  nV_270  7.852787m  TC=0,0
L_V270  nV_269  nV_270  0.073723uH
L_L135  nV_270  NTMP0000000135  6.519695uH
K_K22323  L_L135  L_L136  0.1050
K_K22324  L_L135  L_L137  0.0397
K_K22325  L_L135  L_L138  0.0258
K_K22326  L_L135  L_L198  0.0010
K_K22327  L_L135  L_L199  0.0010
K_K22328  L_L135  L_L200  0.0010
K_K22329  L_L135  L_L201  0.0011
K_K22330  L_L135  L_L202  0.0011
K_K22331  L_L135  L_L203  0.0011
K_K22332  L_L135  L_L204  0.0011
K_K22333  L_L135  L_L205  0.0011
K_K22334  L_L135  L_L206  0.0011
K_K22335  L_L135  L_L207  0.0011
K_K22336  L_L135  L_L208  0.0012
K_K22337  L_L135  L_L209  0.0012
K_K22338  L_L135  L_L210  0.0012
K_K22339  L_L135  L_L211  0.0012
K_K22340  L_L135  L_L212  0.0012
K_K22341  L_L135  L_L213  0.0013
K_K22342  L_L135  L_L214  0.0013
K_K22343  L_L135  L_L215  0.0013
K_K22344  L_L135  L_L216  0.0013
K_K22345  L_L135  L_L217  0.0014
K_K22346  L_L135  L_L218  0.0014
K_K22347  L_L135  L_L219  0.0014
K_K22348  L_L135  L_L220  0.0014
K_K22349  L_L135  L_L221  0.0015
K_K22350  L_L135  L_L222  0.0015
K_K22351  L_L135  L_L223  0.0015
K_K22352  L_L135  L_L224  0.0015
K_K22353  L_L135  L_L225  0.0016
K_K22354  L_L135  L_L226  0.0016
K_K22355  L_L135  L_L227  0.0016
K_K22356  L_L135  L_L228  0.0017
K_K22357  L_L135  L_L229  0.0017
K_K22358  L_L135  L_L230  0.0018
K_K22359  L_L135  L_L231  0.0018
K_K22360  L_L135  L_L232  0.0018
K_K22361  L_L135  L_L233  0.0019
K_K22362  L_L135  L_L234  0.0019
K_K22363  L_L135  L_L235  0.0020
K_K22364  L_L135  L_L236  0.0020
K_K22365  L_L135  L_L237  0.0021
K_K22366  L_L135  L_L238  0.0022
K_K22367  L_L135  L_L239  0.0022
K_K22368  L_L135  L_L240  0.0023
K_K22369  L_L135  L_L241  0.0024
K_K22370  L_L135  L_L242  0.0024
K_K22371  L_L135  L_L243  0.0025
K_K22372  L_L135  L_L244  0.0026
K_K22373  L_L135  L_L245  0.0027
K_K22374  L_L135  L_L246  0.0028
K_K22375  L_L135  L_L247  0.0029
K_K22376  L_L135  L_L248  0.0030
K_K22377  L_L135  L_L249  0.0032
K_K22378  L_L135  L_L250  0.0033
K_K22379  L_L135  L_L251  0.0034
K_K22380  L_L135  L_L252  0.0036
K_K22381  L_L135  L_L253  0.0038
K_K22382  L_L135  L_L254  0.0040
K_K22383  L_L135  L_L255  0.0042
K_K22384  L_L135  L_L256  0.0045
K_K22385  L_L135  L_L257  0.0047
K_K22386  L_L135  L_L258  0.0051
K_K22387  L_L135  L_L259  0.0054
K_K22388  L_L135  L_L260  0.0058
K_K22389  L_L135  L_L261  0.0063
K_K22390  L_L135  L_L262  0.0069
K_K22391  L_L135  L_L263  0.0076
K_K22392  L_L135  L_L264  0.0084
K_K22393  L_L135  L_L265  0.0095
K_K22394  L_L135  L_L266  0.0109
K_K22395  L_L135  L_L267  0.0127
K_K22396  L_L135  L_L268  0.0152
K_K22397  L_L135  L_L269  0.0191
K_K22398  L_L135  L_L270  0.0256
K_K22399  L_L135  L_L271  0.0389
K_K22400  L_L135  L_L272  0.0812
K_K22401  L_L135  L_L273  0.1569
K_K22402  L_L135  L_L274  0.0812
K_K22403  L_L135  L_L275  0.0389
K_K22404  L_L135  L_L276  0.0256
* *  Branch  NTMP0000000135 - NTMP0000000136
R_R136  NTMP0000000135  nU_136  32.914993m  TC=0,0
V_Ui136  nU_136  nR_136  STIMULUS=U_IND_0000000136
R_V271  nR_136  nV_271  23.280268m  TC=0,0
L_V271  nR_136  nV_271  0.014646uH
R_V272  nV_271  nV_272  7.852787m  TC=0,0
L_V272  nV_271  nV_272  0.073723uH
L_L136  nV_272  NTMP0000000136  6.519695uH
K_K22405  L_L136  L_L137  0.1050
K_K22406  L_L136  L_L138  0.0397
K_K22407  L_L136  L_L199  0.0010
K_K22408  L_L136  L_L200  0.0010
K_K22409  L_L136  L_L201  0.0010
K_K22410  L_L136  L_L202  0.0011
K_K22411  L_L136  L_L203  0.0011
K_K22412  L_L136  L_L204  0.0011
K_K22413  L_L136  L_L205  0.0011
K_K22414  L_L136  L_L206  0.0011
K_K22415  L_L136  L_L207  0.0011
K_K22416  L_L136  L_L208  0.0011
K_K22417  L_L136  L_L209  0.0012
K_K22418  L_L136  L_L210  0.0012
K_K22419  L_L136  L_L211  0.0012
K_K22420  L_L136  L_L212  0.0012
K_K22421  L_L136  L_L213  0.0012
K_K22422  L_L136  L_L214  0.0013
K_K22423  L_L136  L_L215  0.0013
K_K22424  L_L136  L_L216  0.0013
K_K22425  L_L136  L_L217  0.0013
K_K22426  L_L136  L_L218  0.0014
K_K22427  L_L136  L_L219  0.0014
K_K22428  L_L136  L_L220  0.0014
K_K22429  L_L136  L_L221  0.0014
K_K22430  L_L136  L_L222  0.0015
K_K22431  L_L136  L_L223  0.0015
K_K22432  L_L136  L_L224  0.0015
K_K22433  L_L136  L_L225  0.0015
K_K22434  L_L136  L_L226  0.0016
K_K22435  L_L136  L_L227  0.0016
K_K22436  L_L136  L_L228  0.0016
K_K22437  L_L136  L_L229  0.0017
K_K22438  L_L136  L_L230  0.0017
K_K22439  L_L136  L_L231  0.0018
K_K22440  L_L136  L_L232  0.0018
K_K22441  L_L136  L_L233  0.0018
K_K22442  L_L136  L_L234  0.0019
K_K22443  L_L136  L_L235  0.0019
K_K22444  L_L136  L_L236  0.0020
K_K22445  L_L136  L_L237  0.0020
K_K22446  L_L136  L_L238  0.0021
K_K22447  L_L136  L_L239  0.0022
K_K22448  L_L136  L_L240  0.0022
K_K22449  L_L136  L_L241  0.0023
K_K22450  L_L136  L_L242  0.0024
K_K22451  L_L136  L_L243  0.0024
K_K22452  L_L136  L_L244  0.0025
K_K22453  L_L136  L_L245  0.0026
K_K22454  L_L136  L_L246  0.0027
K_K22455  L_L136  L_L247  0.0028
K_K22456  L_L136  L_L248  0.0029
K_K22457  L_L136  L_L249  0.0030
K_K22458  L_L136  L_L250  0.0032
K_K22459  L_L136  L_L251  0.0033
K_K22460  L_L136  L_L252  0.0034
K_K22461  L_L136  L_L253  0.0036
K_K22462  L_L136  L_L254  0.0038
K_K22463  L_L136  L_L255  0.0040
K_K22464  L_L136  L_L256  0.0042
K_K22465  L_L136  L_L257  0.0045
K_K22466  L_L136  L_L258  0.0047
K_K22467  L_L136  L_L259  0.0051
K_K22468  L_L136  L_L260  0.0054
K_K22469  L_L136  L_L261  0.0058
K_K22470  L_L136  L_L262  0.0063
K_K22471  L_L136  L_L263  0.0069
K_K22472  L_L136  L_L264  0.0076
K_K22473  L_L136  L_L265  0.0084
K_K22474  L_L136  L_L266  0.0095
K_K22475  L_L136  L_L267  0.0109
K_K22476  L_L136  L_L268  0.0127
K_K22477  L_L136  L_L269  0.0152
K_K22478  L_L136  L_L270  0.0191
K_K22479  L_L136  L_L271  0.0256
K_K22480  L_L136  L_L272  0.0389
K_K22481  L_L136  L_L273  0.0812
K_K22482  L_L136  L_L274  0.1569
K_K22483  L_L136  L_L275  0.0812
K_K22484  L_L136  L_L276  0.0389
* *  Branch  NTMP0000000136 - NTMP0000000137
R_R137  NTMP0000000136  nU_137  32.914993m  TC=0,0
V_Ui137  nU_137  nR_137  STIMULUS=U_IND_0000000137
R_V273  nR_137  nV_273  23.280268m  TC=0,0
L_V273  nR_137  nV_273  0.014646uH
R_V274  nV_273  nV_274  7.852787m  TC=0,0
L_V274  nV_273  nV_274  0.073723uH
L_L137  nV_274  NTMP0000000137  6.519695uH
K_K22485  L_L137  L_L138  0.1050
K_K22486  L_L137  L_L200  0.0010
K_K22487  L_L137  L_L201  0.0010
K_K22488  L_L137  L_L202  0.0010
K_K22489  L_L137  L_L203  0.0011
K_K22490  L_L137  L_L204  0.0011
K_K22491  L_L137  L_L205  0.0011
K_K22492  L_L137  L_L206  0.0011
K_K22493  L_L137  L_L207  0.0011
K_K22494  L_L137  L_L208  0.0011
K_K22495  L_L137  L_L209  0.0011
K_K22496  L_L137  L_L210  0.0012
K_K22497  L_L137  L_L211  0.0012
K_K22498  L_L137  L_L212  0.0012
K_K22499  L_L137  L_L213  0.0012
K_K22500  L_L137  L_L214  0.0012
K_K22501  L_L137  L_L215  0.0013
K_K22502  L_L137  L_L216  0.0013
K_K22503  L_L137  L_L217  0.0013
K_K22504  L_L137  L_L218  0.0013
K_K22505  L_L137  L_L219  0.0014
K_K22506  L_L137  L_L220  0.0014
K_K22507  L_L137  L_L221  0.0014
K_K22508  L_L137  L_L222  0.0014
K_K22509  L_L137  L_L223  0.0015
K_K22510  L_L137  L_L224  0.0015
K_K22511  L_L137  L_L225  0.0015
K_K22512  L_L137  L_L226  0.0015
K_K22513  L_L137  L_L227  0.0016
K_K22514  L_L137  L_L228  0.0016
K_K22515  L_L137  L_L229  0.0016
K_K22516  L_L137  L_L230  0.0017
K_K22517  L_L137  L_L231  0.0017
K_K22518  L_L137  L_L232  0.0018
K_K22519  L_L137  L_L233  0.0018
K_K22520  L_L137  L_L234  0.0018
K_K22521  L_L137  L_L235  0.0019
K_K22522  L_L137  L_L236  0.0019
K_K22523  L_L137  L_L237  0.0020
K_K22524  L_L137  L_L238  0.0020
K_K22525  L_L137  L_L239  0.0021
K_K22526  L_L137  L_L240  0.0022
K_K22527  L_L137  L_L241  0.0022
K_K22528  L_L137  L_L242  0.0023
K_K22529  L_L137  L_L243  0.0024
K_K22530  L_L137  L_L244  0.0024
K_K22531  L_L137  L_L245  0.0025
K_K22532  L_L137  L_L246  0.0026
K_K22533  L_L137  L_L247  0.0027
K_K22534  L_L137  L_L248  0.0028
K_K22535  L_L137  L_L249  0.0029
K_K22536  L_L137  L_L250  0.0030
K_K22537  L_L137  L_L251  0.0032
K_K22538  L_L137  L_L252  0.0033
K_K22539  L_L137  L_L253  0.0034
K_K22540  L_L137  L_L254  0.0036
K_K22541  L_L137  L_L255  0.0038
K_K22542  L_L137  L_L256  0.0040
K_K22543  L_L137  L_L257  0.0042
K_K22544  L_L137  L_L258  0.0045
K_K22545  L_L137  L_L259  0.0047
K_K22546  L_L137  L_L260  0.0051
K_K22547  L_L137  L_L261  0.0054
K_K22548  L_L137  L_L262  0.0058
K_K22549  L_L137  L_L263  0.0063
K_K22550  L_L137  L_L264  0.0069
K_K22551  L_L137  L_L265  0.0076
K_K22552  L_L137  L_L266  0.0084
K_K22553  L_L137  L_L267  0.0095
K_K22554  L_L137  L_L268  0.0109
K_K22555  L_L137  L_L269  0.0127
K_K22556  L_L137  L_L270  0.0152
K_K22557  L_L137  L_L271  0.0191
K_K22558  L_L137  L_L272  0.0256
K_K22559  L_L137  L_L273  0.0389
K_K22560  L_L137  L_L274  0.0812
K_K22561  L_L137  L_L275  0.1569
K_K22562  L_L137  L_L276  0.0812
* *  Branch  NTMP0000000137 - NP15
R_R138  NTMP0000000137  nU_138  32.914993m  TC=0,0
V_Ui138  nU_138  nR_138  STIMULUS=U_IND_0000000138
R_V275  nR_138  nV_275  23.280268m  TC=0,0
L_V275  nR_138  nV_275  0.014646uH
R_V276  nV_275  nV_276  7.852787m  TC=0,0
L_V276  nV_275  nV_276  0.073723uH
L_L138  nV_276  NP15  6.519695uH
K_K22563  L_L138  L_L201  0.0010
K_K22564  L_L138  L_L202  0.0010
K_K22565  L_L138  L_L203  0.0010
K_K22566  L_L138  L_L204  0.0011
K_K22567  L_L138  L_L205  0.0011
K_K22568  L_L138  L_L206  0.0011
K_K22569  L_L138  L_L207  0.0011
K_K22570  L_L138  L_L208  0.0011
K_K22571  L_L138  L_L209  0.0011
K_K22572  L_L138  L_L210  0.0011
K_K22573  L_L138  L_L211  0.0012
K_K22574  L_L138  L_L212  0.0012
K_K22575  L_L138  L_L213  0.0012
K_K22576  L_L138  L_L214  0.0012
K_K22577  L_L138  L_L215  0.0012
K_K22578  L_L138  L_L216  0.0013
K_K22579  L_L138  L_L217  0.0013
K_K22580  L_L138  L_L218  0.0013
K_K22581  L_L138  L_L219  0.0013
K_K22582  L_L138  L_L220  0.0014
K_K22583  L_L138  L_L221  0.0014
K_K22584  L_L138  L_L222  0.0014
K_K22585  L_L138  L_L223  0.0014
K_K22586  L_L138  L_L224  0.0015
K_K22587  L_L138  L_L225  0.0015
K_K22588  L_L138  L_L226  0.0015
K_K22589  L_L138  L_L227  0.0015
K_K22590  L_L138  L_L228  0.0016
K_K22591  L_L138  L_L229  0.0016
K_K22592  L_L138  L_L230  0.0016
K_K22593  L_L138  L_L231  0.0017
K_K22594  L_L138  L_L232  0.0017
K_K22595  L_L138  L_L233  0.0018
K_K22596  L_L138  L_L234  0.0018
K_K22597  L_L138  L_L235  0.0018
K_K22598  L_L138  L_L236  0.0019
K_K22599  L_L138  L_L237  0.0019
K_K22600  L_L138  L_L238  0.0020
K_K22601  L_L138  L_L239  0.0020
K_K22602  L_L138  L_L240  0.0021
K_K22603  L_L138  L_L241  0.0022
K_K22604  L_L138  L_L242  0.0022
K_K22605  L_L138  L_L243  0.0023
K_K22606  L_L138  L_L244  0.0024
K_K22607  L_L138  L_L245  0.0024
K_K22608  L_L138  L_L246  0.0025
K_K22609  L_L138  L_L247  0.0026
K_K22610  L_L138  L_L248  0.0027
K_K22611  L_L138  L_L249  0.0028
K_K22612  L_L138  L_L250  0.0029
K_K22613  L_L138  L_L251  0.0030
K_K22614  L_L138  L_L252  0.0032
K_K22615  L_L138  L_L253  0.0033
K_K22616  L_L138  L_L254  0.0034
K_K22617  L_L138  L_L255  0.0036
K_K22618  L_L138  L_L256  0.0038
K_K22619  L_L138  L_L257  0.0040
K_K22620  L_L138  L_L258  0.0042
K_K22621  L_L138  L_L259  0.0045
K_K22622  L_L138  L_L260  0.0047
K_K22623  L_L138  L_L261  0.0051
K_K22624  L_L138  L_L262  0.0054
K_K22625  L_L138  L_L263  0.0058
K_K22626  L_L138  L_L264  0.0063
K_K22627  L_L138  L_L265  0.0069
K_K22628  L_L138  L_L266  0.0076
K_K22629  L_L138  L_L267  0.0084
K_K22630  L_L138  L_L268  0.0095
K_K22631  L_L138  L_L269  0.0109
K_K22632  L_L138  L_L270  0.0127
K_K22633  L_L138  L_L271  0.0152
K_K22634  L_L138  L_L272  0.0191
K_K22635  L_L138  L_L273  0.0256
K_K22636  L_L138  L_L274  0.0389
K_K22637  L_L138  L_L275  0.0812
K_K22638  L_L138  L_L276  0.1569
* *  Branch  NN01 - NTMP0000000139
R_R139  NN01  nU_139  32.914993m  TC=0,0
V_Ui139  nU_139  nR_139  STIMULUS=U_IND_0000000139
R_V277  nR_139  nV_277  23.280268m  TC=0,0
L_V277  nR_139  nV_277  0.014646uH
R_V278  nV_277  nV_278  7.852787m  TC=0,0
L_V278  nV_277  nV_278  0.073723uH
L_L139  nV_278  NTMP0000000139  6.519695uH
K_K22639  L_L139  L_L140  0.1050
K_K22640  L_L139  L_L141  0.0397
K_K22641  L_L139  L_L142  0.0258
K_K22642  L_L139  L_L143  0.0192
K_K22643  L_L139  L_L144  0.0153
K_K22644  L_L139  L_L145  0.0127
K_K22645  L_L139  L_L146  0.0109
K_K22646  L_L139  L_L147  0.0095
K_K22647  L_L139  L_L148  0.0084
K_K22648  L_L139  L_L149  0.0076
K_K22649  L_L139  L_L150  0.0069
K_K22650  L_L139  L_L151  0.0063
K_K22651  L_L139  L_L152  0.0058
K_K22652  L_L139  L_L153  0.0054
K_K22653  L_L139  L_L154  0.0051
K_K22654  L_L139  L_L155  0.0047
K_K22655  L_L139  L_L156  0.0045
K_K22656  L_L139  L_L157  0.0042
K_K22657  L_L139  L_L158  0.0040
K_K22658  L_L139  L_L159  0.0038
K_K22659  L_L139  L_L160  0.0036
K_K22660  L_L139  L_L161  0.0034
K_K22661  L_L139  L_L162  0.0033
K_K22662  L_L139  L_L163  0.0032
K_K22663  L_L139  L_L164  0.0030
K_K22664  L_L139  L_L165  0.0029
K_K22665  L_L139  L_L166  0.0028
K_K22666  L_L139  L_L167  0.0027
K_K22667  L_L139  L_L168  0.0026
K_K22668  L_L139  L_L169  0.0025
K_K22669  L_L139  L_L170  0.0024
K_K22670  L_L139  L_L171  0.0024
K_K22671  L_L139  L_L172  0.0023
K_K22672  L_L139  L_L173  0.0022
K_K22673  L_L139  L_L174  0.0022
K_K22674  L_L139  L_L175  0.0021
K_K22675  L_L139  L_L176  0.0020
K_K22676  L_L139  L_L177  0.0020
K_K22677  L_L139  L_L178  0.0019
K_K22678  L_L139  L_L179  0.0019
K_K22679  L_L139  L_L180  0.0018
K_K22680  L_L139  L_L181  0.0018
K_K22681  L_L139  L_L182  0.0018
K_K22682  L_L139  L_L183  0.0017
K_K22683  L_L139  L_L184  0.0017
K_K22684  L_L139  L_L185  0.0017
K_K22685  L_L139  L_L186  0.0016
K_K22686  L_L139  L_L187  0.0016
K_K22687  L_L139  L_L188  0.0015
K_K22688  L_L139  L_L189  0.0015
K_K22689  L_L139  L_L190  0.0015
K_K22690  L_L139  L_L191  0.0015
K_K22691  L_L139  L_L192  0.0014
K_K22692  L_L139  L_L193  0.0014
K_K22693  L_L139  L_L194  0.0014
K_K22694  L_L139  L_L195  0.0014
K_K22695  L_L139  L_L196  0.0013
K_K22696  L_L139  L_L197  0.0013
K_K22697  L_L139  L_L198  0.0013
K_K22698  L_L139  L_L199  0.0013
K_K22699  L_L139  L_L200  0.0013
K_K22700  L_L139  L_L201  0.0012
K_K22701  L_L139  L_L202  0.0012
K_K22702  L_L139  L_L203  0.0012
K_K22703  L_L139  L_L204  0.0012
K_K22704  L_L139  L_L205  0.0011
K_K22705  L_L139  L_L206  0.0011
K_K22706  L_L139  L_L207  0.0011
K_K22707  L_L139  L_L208  0.0011
K_K22708  L_L139  L_L209  0.0011
K_K22709  L_L139  L_L210  0.0011
K_K22710  L_L139  L_L211  0.0011
K_K22711  L_L139  L_L212  0.0010
K_K22712  L_L139  L_L213  0.0010
K_K22713  L_L139  L_L214  0.0010
* *  Branch  NTMP0000000139 - NTMP0000000140
R_R140  NTMP0000000139  nU_140  32.914993m  TC=0,0
V_Ui140  nU_140  nR_140  STIMULUS=U_IND_0000000140
R_V279  nR_140  nV_279  23.280268m  TC=0,0
L_V279  nR_140  nV_279  0.014646uH
R_V280  nV_279  nV_280  7.852787m  TC=0,0
L_V280  nV_279  nV_280  0.073723uH
L_L140  nV_280  NTMP0000000140  6.519695uH
K_K22714  L_L140  L_L141  0.1050
K_K22715  L_L140  L_L142  0.0397
K_K22716  L_L140  L_L143  0.0258
K_K22717  L_L140  L_L144  0.0192
K_K22718  L_L140  L_L145  0.0153
K_K22719  L_L140  L_L146  0.0127
K_K22720  L_L140  L_L147  0.0109
K_K22721  L_L140  L_L148  0.0095
K_K22722  L_L140  L_L149  0.0084
K_K22723  L_L140  L_L150  0.0076
K_K22724  L_L140  L_L151  0.0069
K_K22725  L_L140  L_L152  0.0063
K_K22726  L_L140  L_L153  0.0058
K_K22727  L_L140  L_L154  0.0054
K_K22728  L_L140  L_L155  0.0051
K_K22729  L_L140  L_L156  0.0047
K_K22730  L_L140  L_L157  0.0045
K_K22731  L_L140  L_L158  0.0042
K_K22732  L_L140  L_L159  0.0040
K_K22733  L_L140  L_L160  0.0038
K_K22734  L_L140  L_L161  0.0036
K_K22735  L_L140  L_L162  0.0034
K_K22736  L_L140  L_L163  0.0033
K_K22737  L_L140  L_L164  0.0032
K_K22738  L_L140  L_L165  0.0030
K_K22739  L_L140  L_L166  0.0029
K_K22740  L_L140  L_L167  0.0028
K_K22741  L_L140  L_L168  0.0027
K_K22742  L_L140  L_L169  0.0026
K_K22743  L_L140  L_L170  0.0025
K_K22744  L_L140  L_L171  0.0024
K_K22745  L_L140  L_L172  0.0024
K_K22746  L_L140  L_L173  0.0023
K_K22747  L_L140  L_L174  0.0022
K_K22748  L_L140  L_L175  0.0022
K_K22749  L_L140  L_L176  0.0021
K_K22750  L_L140  L_L177  0.0020
K_K22751  L_L140  L_L178  0.0020
K_K22752  L_L140  L_L179  0.0019
K_K22753  L_L140  L_L180  0.0019
K_K22754  L_L140  L_L181  0.0018
K_K22755  L_L140  L_L182  0.0018
K_K22756  L_L140  L_L183  0.0018
K_K22757  L_L140  L_L184  0.0017
K_K22758  L_L140  L_L185  0.0017
K_K22759  L_L140  L_L186  0.0017
K_K22760  L_L140  L_L187  0.0016
K_K22761  L_L140  L_L188  0.0016
K_K22762  L_L140  L_L189  0.0015
K_K22763  L_L140  L_L190  0.0015
K_K22764  L_L140  L_L191  0.0015
K_K22765  L_L140  L_L192  0.0015
K_K22766  L_L140  L_L193  0.0014
K_K22767  L_L140  L_L194  0.0014
K_K22768  L_L140  L_L195  0.0014
K_K22769  L_L140  L_L196  0.0014
K_K22770  L_L140  L_L197  0.0013
K_K22771  L_L140  L_L198  0.0013
K_K22772  L_L140  L_L199  0.0013
K_K22773  L_L140  L_L200  0.0013
K_K22774  L_L140  L_L201  0.0013
K_K22775  L_L140  L_L202  0.0012
K_K22776  L_L140  L_L203  0.0012
K_K22777  L_L140  L_L204  0.0012
K_K22778  L_L140  L_L205  0.0012
K_K22779  L_L140  L_L206  0.0011
K_K22780  L_L140  L_L207  0.0011
K_K22781  L_L140  L_L208  0.0011
K_K22782  L_L140  L_L209  0.0011
K_K22783  L_L140  L_L210  0.0011
K_K22784  L_L140  L_L211  0.0011
K_K22785  L_L140  L_L212  0.0011
K_K22786  L_L140  L_L213  0.0010
K_K22787  L_L140  L_L214  0.0010
K_K22788  L_L140  L_L215  0.0010
* *  Branch  NTMP0000000140 - NTMP0000000141
R_R141  NTMP0000000140  nU_141  32.914993m  TC=0,0
V_Ui141  nU_141  nR_141  STIMULUS=U_IND_0000000141
R_V281  nR_141  nV_281  23.280268m  TC=0,0
L_V281  nR_141  nV_281  0.014646uH
R_V282  nV_281  nV_282  7.852787m  TC=0,0
L_V282  nV_281  nV_282  0.073723uH
L_L141  nV_282  NTMP0000000141  6.519695uH
K_K22789  L_L141  L_L142  0.1050
K_K22790  L_L141  L_L143  0.0397
K_K22791  L_L141  L_L144  0.0258
K_K22792  L_L141  L_L145  0.0192
K_K22793  L_L141  L_L146  0.0153
K_K22794  L_L141  L_L147  0.0127
K_K22795  L_L141  L_L148  0.0109
K_K22796  L_L141  L_L149  0.0095
K_K22797  L_L141  L_L150  0.0084
K_K22798  L_L141  L_L151  0.0076
K_K22799  L_L141  L_L152  0.0069
K_K22800  L_L141  L_L153  0.0063
K_K22801  L_L141  L_L154  0.0058
K_K22802  L_L141  L_L155  0.0054
K_K22803  L_L141  L_L156  0.0051
K_K22804  L_L141  L_L157  0.0047
K_K22805  L_L141  L_L158  0.0045
K_K22806  L_L141  L_L159  0.0042
K_K22807  L_L141  L_L160  0.0040
K_K22808  L_L141  L_L161  0.0038
K_K22809  L_L141  L_L162  0.0036
K_K22810  L_L141  L_L163  0.0034
K_K22811  L_L141  L_L164  0.0033
K_K22812  L_L141  L_L165  0.0032
K_K22813  L_L141  L_L166  0.0030
K_K22814  L_L141  L_L167  0.0029
K_K22815  L_L141  L_L168  0.0028
K_K22816  L_L141  L_L169  0.0027
K_K22817  L_L141  L_L170  0.0026
K_K22818  L_L141  L_L171  0.0025
K_K22819  L_L141  L_L172  0.0024
K_K22820  L_L141  L_L173  0.0024
K_K22821  L_L141  L_L174  0.0023
K_K22822  L_L141  L_L175  0.0022
K_K22823  L_L141  L_L176  0.0022
K_K22824  L_L141  L_L177  0.0021
K_K22825  L_L141  L_L178  0.0020
K_K22826  L_L141  L_L179  0.0020
K_K22827  L_L141  L_L180  0.0019
K_K22828  L_L141  L_L181  0.0019
K_K22829  L_L141  L_L182  0.0018
K_K22830  L_L141  L_L183  0.0018
K_K22831  L_L141  L_L184  0.0018
K_K22832  L_L141  L_L185  0.0017
K_K22833  L_L141  L_L186  0.0017
K_K22834  L_L141  L_L187  0.0017
K_K22835  L_L141  L_L188  0.0016
K_K22836  L_L141  L_L189  0.0016
K_K22837  L_L141  L_L190  0.0015
K_K22838  L_L141  L_L191  0.0015
K_K22839  L_L141  L_L192  0.0015
K_K22840  L_L141  L_L193  0.0015
K_K22841  L_L141  L_L194  0.0014
K_K22842  L_L141  L_L195  0.0014
K_K22843  L_L141  L_L196  0.0014
K_K22844  L_L141  L_L197  0.0014
K_K22845  L_L141  L_L198  0.0013
K_K22846  L_L141  L_L199  0.0013
K_K22847  L_L141  L_L200  0.0013
K_K22848  L_L141  L_L201  0.0013
K_K22849  L_L141  L_L202  0.0013
K_K22850  L_L141  L_L203  0.0012
K_K22851  L_L141  L_L204  0.0012
K_K22852  L_L141  L_L205  0.0012
K_K22853  L_L141  L_L206  0.0012
K_K22854  L_L141  L_L207  0.0011
K_K22855  L_L141  L_L208  0.0011
K_K22856  L_L141  L_L209  0.0011
K_K22857  L_L141  L_L210  0.0011
K_K22858  L_L141  L_L211  0.0011
K_K22859  L_L141  L_L212  0.0011
K_K22860  L_L141  L_L213  0.0011
K_K22861  L_L141  L_L214  0.0010
K_K22862  L_L141  L_L215  0.0010
K_K22863  L_L141  L_L216  0.0010
* *  Branch  NTMP0000000141 - NTMP0000000142
R_R142  NTMP0000000141  nU_142  32.914993m  TC=0,0
V_Ui142  nU_142  nR_142  STIMULUS=U_IND_0000000142
R_V283  nR_142  nV_283  23.280268m  TC=0,0
L_V283  nR_142  nV_283  0.014646uH
R_V284  nV_283  nV_284  7.852787m  TC=0,0
L_V284  nV_283  nV_284  0.073723uH
L_L142  nV_284  NTMP0000000142  6.519695uH
K_K22864  L_L142  L_L143  0.1050
K_K22865  L_L142  L_L144  0.0397
K_K22866  L_L142  L_L145  0.0258
K_K22867  L_L142  L_L146  0.0192
K_K22868  L_L142  L_L147  0.0153
K_K22869  L_L142  L_L148  0.0127
K_K22870  L_L142  L_L149  0.0109
K_K22871  L_L142  L_L150  0.0095
K_K22872  L_L142  L_L151  0.0084
K_K22873  L_L142  L_L152  0.0076
K_K22874  L_L142  L_L153  0.0069
K_K22875  L_L142  L_L154  0.0063
K_K22876  L_L142  L_L155  0.0058
K_K22877  L_L142  L_L156  0.0054
K_K22878  L_L142  L_L157  0.0051
K_K22879  L_L142  L_L158  0.0047
K_K22880  L_L142  L_L159  0.0045
K_K22881  L_L142  L_L160  0.0042
K_K22882  L_L142  L_L161  0.0040
K_K22883  L_L142  L_L162  0.0038
K_K22884  L_L142  L_L163  0.0036
K_K22885  L_L142  L_L164  0.0034
K_K22886  L_L142  L_L165  0.0033
K_K22887  L_L142  L_L166  0.0032
K_K22888  L_L142  L_L167  0.0030
K_K22889  L_L142  L_L168  0.0029
K_K22890  L_L142  L_L169  0.0028
K_K22891  L_L142  L_L170  0.0027
K_K22892  L_L142  L_L171  0.0026
K_K22893  L_L142  L_L172  0.0025
K_K22894  L_L142  L_L173  0.0024
K_K22895  L_L142  L_L174  0.0024
K_K22896  L_L142  L_L175  0.0023
K_K22897  L_L142  L_L176  0.0022
K_K22898  L_L142  L_L177  0.0022
K_K22899  L_L142  L_L178  0.0021
K_K22900  L_L142  L_L179  0.0020
K_K22901  L_L142  L_L180  0.0020
K_K22902  L_L142  L_L181  0.0019
K_K22903  L_L142  L_L182  0.0019
K_K22904  L_L142  L_L183  0.0019
K_K22905  L_L142  L_L184  0.0018
K_K22906  L_L142  L_L185  0.0018
K_K22907  L_L142  L_L186  0.0017
K_K22908  L_L142  L_L187  0.0017
K_K22909  L_L142  L_L188  0.0017
K_K22910  L_L142  L_L189  0.0016
K_K22911  L_L142  L_L190  0.0016
K_K22912  L_L142  L_L191  0.0015
K_K22913  L_L142  L_L192  0.0015
K_K22914  L_L142  L_L193  0.0015
K_K22915  L_L142  L_L194  0.0015
K_K22916  L_L142  L_L195  0.0014
K_K22917  L_L142  L_L196  0.0014
K_K22918  L_L142  L_L197  0.0014
K_K22919  L_L142  L_L198  0.0014
K_K22920  L_L142  L_L199  0.0013
K_K22921  L_L142  L_L200  0.0013
K_K22922  L_L142  L_L201  0.0013
K_K22923  L_L142  L_L202  0.0013
K_K22924  L_L142  L_L203  0.0013
K_K22925  L_L142  L_L204  0.0012
K_K22926  L_L142  L_L205  0.0012
K_K22927  L_L142  L_L206  0.0012
K_K22928  L_L142  L_L207  0.0012
K_K22929  L_L142  L_L208  0.0011
K_K22930  L_L142  L_L209  0.0011
K_K22931  L_L142  L_L210  0.0011
K_K22932  L_L142  L_L211  0.0011
K_K22933  L_L142  L_L212  0.0011
K_K22934  L_L142  L_L213  0.0011
K_K22935  L_L142  L_L214  0.0011
K_K22936  L_L142  L_L215  0.0010
K_K22937  L_L142  L_L216  0.0010
K_K22938  L_L142  L_L217  0.0010
* *  Branch  NTMP0000000142 - NTMP0000000143
R_R143  NTMP0000000142  nU_143  32.914993m  TC=0,0
V_Ui143  nU_143  nR_143  STIMULUS=U_IND_0000000143
R_V285  nR_143  nV_285  23.280268m  TC=0,0
L_V285  nR_143  nV_285  0.014646uH
R_V286  nV_285  nV_286  7.852787m  TC=0,0
L_V286  nV_285  nV_286  0.073723uH
L_L143  nV_286  NTMP0000000143  6.519695uH
K_K22939  L_L143  L_L144  0.1050
K_K22940  L_L143  L_L145  0.0397
K_K22941  L_L143  L_L146  0.0258
K_K22942  L_L143  L_L147  0.0192
K_K22943  L_L143  L_L148  0.0153
K_K22944  L_L143  L_L149  0.0127
K_K22945  L_L143  L_L150  0.0109
K_K22946  L_L143  L_L151  0.0095
K_K22947  L_L143  L_L152  0.0084
K_K22948  L_L143  L_L153  0.0076
K_K22949  L_L143  L_L154  0.0069
K_K22950  L_L143  L_L155  0.0063
K_K22951  L_L143  L_L156  0.0058
K_K22952  L_L143  L_L157  0.0054
K_K22953  L_L143  L_L158  0.0051
K_K22954  L_L143  L_L159  0.0047
K_K22955  L_L143  L_L160  0.0045
K_K22956  L_L143  L_L161  0.0042
K_K22957  L_L143  L_L162  0.0040
K_K22958  L_L143  L_L163  0.0038
K_K22959  L_L143  L_L164  0.0036
K_K22960  L_L143  L_L165  0.0034
K_K22961  L_L143  L_L166  0.0033
K_K22962  L_L143  L_L167  0.0032
K_K22963  L_L143  L_L168  0.0030
K_K22964  L_L143  L_L169  0.0029
K_K22965  L_L143  L_L170  0.0028
K_K22966  L_L143  L_L171  0.0027
K_K22967  L_L143  L_L172  0.0026
K_K22968  L_L143  L_L173  0.0025
K_K22969  L_L143  L_L174  0.0024
K_K22970  L_L143  L_L175  0.0024
K_K22971  L_L143  L_L176  0.0023
K_K22972  L_L143  L_L177  0.0022
K_K22973  L_L143  L_L178  0.0022
K_K22974  L_L143  L_L179  0.0021
K_K22975  L_L143  L_L180  0.0020
K_K22976  L_L143  L_L181  0.0020
K_K22977  L_L143  L_L182  0.0019
K_K22978  L_L143  L_L183  0.0019
K_K22979  L_L143  L_L184  0.0018
K_K22980  L_L143  L_L185  0.0018
K_K22981  L_L143  L_L186  0.0018
K_K22982  L_L143  L_L187  0.0017
K_K22983  L_L143  L_L188  0.0017
K_K22984  L_L143  L_L189  0.0016
K_K22985  L_L143  L_L190  0.0016
K_K22986  L_L143  L_L191  0.0016
K_K22987  L_L143  L_L192  0.0015
K_K22988  L_L143  L_L193  0.0015
K_K22989  L_L143  L_L194  0.0015
K_K22990  L_L143  L_L195  0.0015
K_K22991  L_L143  L_L196  0.0014
K_K22992  L_L143  L_L197  0.0014
K_K22993  L_L143  L_L198  0.0014
K_K22994  L_L143  L_L199  0.0014
K_K22995  L_L143  L_L200  0.0013
K_K22996  L_L143  L_L201  0.0013
K_K22997  L_L143  L_L202  0.0013
K_K22998  L_L143  L_L203  0.0013
K_K22999  L_L143  L_L204  0.0013
K_K23000  L_L143  L_L205  0.0012
K_K23001  L_L143  L_L206  0.0012
K_K23002  L_L143  L_L207  0.0012
K_K23003  L_L143  L_L208  0.0012
K_K23004  L_L143  L_L209  0.0011
K_K23005  L_L143  L_L210  0.0011
K_K23006  L_L143  L_L211  0.0011
K_K23007  L_L143  L_L212  0.0011
K_K23008  L_L143  L_L213  0.0011
K_K23009  L_L143  L_L214  0.0011
K_K23010  L_L143  L_L215  0.0011
K_K23011  L_L143  L_L216  0.0010
K_K23012  L_L143  L_L217  0.0010
K_K23013  L_L143  L_L218  0.0010
* *  Branch  NTMP0000000143 - NTMP0000000144
R_R144  NTMP0000000143  nU_144  32.914993m  TC=0,0
V_Ui144  nU_144  nR_144  STIMULUS=U_IND_0000000144
R_V287  nR_144  nV_287  23.280268m  TC=0,0
L_V287  nR_144  nV_287  0.014646uH
R_V288  nV_287  nV_288  7.852787m  TC=0,0
L_V288  nV_287  nV_288  0.073723uH
L_L144  nV_288  NTMP0000000144  6.519695uH
K_K23014  L_L144  L_L145  0.1050
K_K23015  L_L144  L_L146  0.0397
K_K23016  L_L144  L_L147  0.0258
K_K23017  L_L144  L_L148  0.0192
K_K23018  L_L144  L_L149  0.0153
K_K23019  L_L144  L_L150  0.0127
K_K23020  L_L144  L_L151  0.0109
K_K23021  L_L144  L_L152  0.0095
K_K23022  L_L144  L_L153  0.0084
K_K23023  L_L144  L_L154  0.0076
K_K23024  L_L144  L_L155  0.0069
K_K23025  L_L144  L_L156  0.0063
K_K23026  L_L144  L_L157  0.0058
K_K23027  L_L144  L_L158  0.0054
K_K23028  L_L144  L_L159  0.0051
K_K23029  L_L144  L_L160  0.0047
K_K23030  L_L144  L_L161  0.0045
K_K23031  L_L144  L_L162  0.0042
K_K23032  L_L144  L_L163  0.0040
K_K23033  L_L144  L_L164  0.0038
K_K23034  L_L144  L_L165  0.0036
K_K23035  L_L144  L_L166  0.0034
K_K23036  L_L144  L_L167  0.0033
K_K23037  L_L144  L_L168  0.0032
K_K23038  L_L144  L_L169  0.0030
K_K23039  L_L144  L_L170  0.0029
K_K23040  L_L144  L_L171  0.0028
K_K23041  L_L144  L_L172  0.0027
K_K23042  L_L144  L_L173  0.0026
K_K23043  L_L144  L_L174  0.0025
K_K23044  L_L144  L_L175  0.0024
K_K23045  L_L144  L_L176  0.0024
K_K23046  L_L144  L_L177  0.0023
K_K23047  L_L144  L_L178  0.0022
K_K23048  L_L144  L_L179  0.0022
K_K23049  L_L144  L_L180  0.0021
K_K23050  L_L144  L_L181  0.0020
K_K23051  L_L144  L_L182  0.0020
K_K23052  L_L144  L_L183  0.0019
K_K23053  L_L144  L_L184  0.0019
K_K23054  L_L144  L_L185  0.0018
K_K23055  L_L144  L_L186  0.0018
K_K23056  L_L144  L_L187  0.0018
K_K23057  L_L144  L_L188  0.0017
K_K23058  L_L144  L_L189  0.0017
K_K23059  L_L144  L_L190  0.0016
K_K23060  L_L144  L_L191  0.0016
K_K23061  L_L144  L_L192  0.0016
K_K23062  L_L144  L_L193  0.0016
K_K23063  L_L144  L_L194  0.0015
K_K23064  L_L144  L_L195  0.0015
K_K23065  L_L144  L_L196  0.0015
K_K23066  L_L144  L_L197  0.0014
K_K23067  L_L144  L_L198  0.0014
K_K23068  L_L144  L_L199  0.0014
K_K23069  L_L144  L_L200  0.0014
K_K23070  L_L144  L_L201  0.0013
K_K23071  L_L144  L_L202  0.0013
K_K23072  L_L144  L_L203  0.0013
K_K23073  L_L144  L_L204  0.0013
K_K23074  L_L144  L_L205  0.0013
K_K23075  L_L144  L_L206  0.0012
K_K23076  L_L144  L_L207  0.0012
K_K23077  L_L144  L_L208  0.0012
K_K23078  L_L144  L_L209  0.0012
K_K23079  L_L144  L_L210  0.0011
K_K23080  L_L144  L_L211  0.0011
K_K23081  L_L144  L_L212  0.0011
K_K23082  L_L144  L_L213  0.0011
K_K23083  L_L144  L_L214  0.0011
K_K23084  L_L144  L_L215  0.0011
K_K23085  L_L144  L_L216  0.0011
K_K23086  L_L144  L_L217  0.0010
K_K23087  L_L144  L_L218  0.0010
K_K23088  L_L144  L_L219  0.0010
* *  Branch  NTMP0000000144 - NTMP0000000145
R_R145  NTMP0000000144  nU_145  32.914993m  TC=0,0
V_Ui145  nU_145  nR_145  STIMULUS=U_IND_0000000145
R_V289  nR_145  nV_289  23.280268m  TC=0,0
L_V289  nR_145  nV_289  0.014646uH
R_V290  nV_289  nV_290  7.852787m  TC=0,0
L_V290  nV_289  nV_290  0.073723uH
L_L145  nV_290  NTMP0000000145  6.519695uH
K_K23089  L_L145  L_L146  0.1050
K_K23090  L_L145  L_L147  0.0397
K_K23091  L_L145  L_L148  0.0258
K_K23092  L_L145  L_L149  0.0192
K_K23093  L_L145  L_L150  0.0153
K_K23094  L_L145  L_L151  0.0127
K_K23095  L_L145  L_L152  0.0109
K_K23096  L_L145  L_L153  0.0095
K_K23097  L_L145  L_L154  0.0084
K_K23098  L_L145  L_L155  0.0076
K_K23099  L_L145  L_L156  0.0069
K_K23100  L_L145  L_L157  0.0063
K_K23101  L_L145  L_L158  0.0058
K_K23102  L_L145  L_L159  0.0054
K_K23103  L_L145  L_L160  0.0051
K_K23104  L_L145  L_L161  0.0047
K_K23105  L_L145  L_L162  0.0045
K_K23106  L_L145  L_L163  0.0042
K_K23107  L_L145  L_L164  0.0040
K_K23108  L_L145  L_L165  0.0038
K_K23109  L_L145  L_L166  0.0036
K_K23110  L_L145  L_L167  0.0034
K_K23111  L_L145  L_L168  0.0033
K_K23112  L_L145  L_L169  0.0032
K_K23113  L_L145  L_L170  0.0030
K_K23114  L_L145  L_L171  0.0029
K_K23115  L_L145  L_L172  0.0028
K_K23116  L_L145  L_L173  0.0027
K_K23117  L_L145  L_L174  0.0026
K_K23118  L_L145  L_L175  0.0025
K_K23119  L_L145  L_L176  0.0024
K_K23120  L_L145  L_L177  0.0024
K_K23121  L_L145  L_L178  0.0023
K_K23122  L_L145  L_L179  0.0022
K_K23123  L_L145  L_L180  0.0022
K_K23124  L_L145  L_L181  0.0021
K_K23125  L_L145  L_L182  0.0020
K_K23126  L_L145  L_L183  0.0020
K_K23127  L_L145  L_L184  0.0019
K_K23128  L_L145  L_L185  0.0019
K_K23129  L_L145  L_L186  0.0018
K_K23130  L_L145  L_L187  0.0018
K_K23131  L_L145  L_L188  0.0018
K_K23132  L_L145  L_L189  0.0017
K_K23133  L_L145  L_L190  0.0017
K_K23134  L_L145  L_L191  0.0016
K_K23135  L_L145  L_L192  0.0016
K_K23136  L_L145  L_L193  0.0016
K_K23137  L_L145  L_L194  0.0015
K_K23138  L_L145  L_L195  0.0015
K_K23139  L_L145  L_L196  0.0015
K_K23140  L_L145  L_L197  0.0015
K_K23141  L_L145  L_L198  0.0014
K_K23142  L_L145  L_L199  0.0014
K_K23143  L_L145  L_L200  0.0014
K_K23144  L_L145  L_L201  0.0014
K_K23145  L_L145  L_L202  0.0013
K_K23146  L_L145  L_L203  0.0013
K_K23147  L_L145  L_L204  0.0013
K_K23148  L_L145  L_L205  0.0013
K_K23149  L_L145  L_L206  0.0013
K_K23150  L_L145  L_L207  0.0012
K_K23151  L_L145  L_L208  0.0012
K_K23152  L_L145  L_L209  0.0012
K_K23153  L_L145  L_L210  0.0012
K_K23154  L_L145  L_L211  0.0011
K_K23155  L_L145  L_L212  0.0011
K_K23156  L_L145  L_L213  0.0011
K_K23157  L_L145  L_L214  0.0011
K_K23158  L_L145  L_L215  0.0011
K_K23159  L_L145  L_L216  0.0011
K_K23160  L_L145  L_L217  0.0011
K_K23161  L_L145  L_L218  0.0010
K_K23162  L_L145  L_L219  0.0010
K_K23163  L_L145  L_L220  0.0010
* *  Branch  NTMP0000000145 - NTMP0000000146
R_R146  NTMP0000000145  nU_146  32.914993m  TC=0,0
V_Ui146  nU_146  nR_146  STIMULUS=U_IND_0000000146
R_V291  nR_146  nV_291  23.280268m  TC=0,0
L_V291  nR_146  nV_291  0.014646uH
R_V292  nV_291  nV_292  7.852787m  TC=0,0
L_V292  nV_291  nV_292  0.073723uH
L_L146  nV_292  NTMP0000000146  6.519695uH
K_K23164  L_L146  L_L147  0.1050
K_K23165  L_L146  L_L148  0.0397
K_K23166  L_L146  L_L149  0.0258
K_K23167  L_L146  L_L150  0.0192
K_K23168  L_L146  L_L151  0.0153
K_K23169  L_L146  L_L152  0.0127
K_K23170  L_L146  L_L153  0.0109
K_K23171  L_L146  L_L154  0.0095
K_K23172  L_L146  L_L155  0.0084
K_K23173  L_L146  L_L156  0.0076
K_K23174  L_L146  L_L157  0.0069
K_K23175  L_L146  L_L158  0.0063
K_K23176  L_L146  L_L159  0.0058
K_K23177  L_L146  L_L160  0.0054
K_K23178  L_L146  L_L161  0.0051
K_K23179  L_L146  L_L162  0.0047
K_K23180  L_L146  L_L163  0.0045
K_K23181  L_L146  L_L164  0.0042
K_K23182  L_L146  L_L165  0.0040
K_K23183  L_L146  L_L166  0.0038
K_K23184  L_L146  L_L167  0.0036
K_K23185  L_L146  L_L168  0.0034
K_K23186  L_L146  L_L169  0.0033
K_K23187  L_L146  L_L170  0.0032
K_K23188  L_L146  L_L171  0.0030
K_K23189  L_L146  L_L172  0.0029
K_K23190  L_L146  L_L173  0.0028
K_K23191  L_L146  L_L174  0.0027
K_K23192  L_L146  L_L175  0.0026
K_K23193  L_L146  L_L176  0.0025
K_K23194  L_L146  L_L177  0.0024
K_K23195  L_L146  L_L178  0.0024
K_K23196  L_L146  L_L179  0.0023
K_K23197  L_L146  L_L180  0.0022
K_K23198  L_L146  L_L181  0.0022
K_K23199  L_L146  L_L182  0.0021
K_K23200  L_L146  L_L183  0.0020
K_K23201  L_L146  L_L184  0.0020
K_K23202  L_L146  L_L185  0.0019
K_K23203  L_L146  L_L186  0.0019
K_K23204  L_L146  L_L187  0.0018
K_K23205  L_L146  L_L188  0.0018
K_K23206  L_L146  L_L189  0.0018
K_K23207  L_L146  L_L190  0.0017
K_K23208  L_L146  L_L191  0.0017
K_K23209  L_L146  L_L192  0.0016
K_K23210  L_L146  L_L193  0.0016
K_K23211  L_L146  L_L194  0.0016
K_K23212  L_L146  L_L195  0.0015
K_K23213  L_L146  L_L196  0.0015
K_K23214  L_L146  L_L197  0.0015
K_K23215  L_L146  L_L198  0.0015
K_K23216  L_L146  L_L199  0.0014
K_K23217  L_L146  L_L200  0.0014
K_K23218  L_L146  L_L201  0.0014
K_K23219  L_L146  L_L202  0.0014
K_K23220  L_L146  L_L203  0.0013
K_K23221  L_L146  L_L204  0.0013
K_K23222  L_L146  L_L205  0.0013
K_K23223  L_L146  L_L206  0.0013
K_K23224  L_L146  L_L207  0.0013
K_K23225  L_L146  L_L208  0.0012
K_K23226  L_L146  L_L209  0.0012
K_K23227  L_L146  L_L210  0.0012
K_K23228  L_L146  L_L211  0.0012
K_K23229  L_L146  L_L212  0.0011
K_K23230  L_L146  L_L213  0.0011
K_K23231  L_L146  L_L214  0.0011
K_K23232  L_L146  L_L215  0.0011
K_K23233  L_L146  L_L216  0.0011
K_K23234  L_L146  L_L217  0.0011
K_K23235  L_L146  L_L218  0.0011
K_K23236  L_L146  L_L219  0.0010
K_K23237  L_L146  L_L220  0.0010
K_K23238  L_L146  L_L221  0.0010
* *  Branch  NTMP0000000146 - NTMP0000000147
R_R147  NTMP0000000146  nU_147  32.914993m  TC=0,0
V_Ui147  nU_147  nR_147  STIMULUS=U_IND_0000000147
R_V293  nR_147  nV_293  23.280268m  TC=0,0
L_V293  nR_147  nV_293  0.014646uH
R_V294  nV_293  nV_294  7.852787m  TC=0,0
L_V294  nV_293  nV_294  0.073723uH
L_L147  nV_294  NTMP0000000147  6.519695uH
K_K23239  L_L147  L_L148  0.1050
K_K23240  L_L147  L_L149  0.0397
K_K23241  L_L147  L_L150  0.0258
K_K23242  L_L147  L_L151  0.0192
K_K23243  L_L147  L_L152  0.0153
K_K23244  L_L147  L_L153  0.0127
K_K23245  L_L147  L_L154  0.0109
K_K23246  L_L147  L_L155  0.0095
K_K23247  L_L147  L_L156  0.0084
K_K23248  L_L147  L_L157  0.0076
K_K23249  L_L147  L_L158  0.0069
K_K23250  L_L147  L_L159  0.0063
K_K23251  L_L147  L_L160  0.0058
K_K23252  L_L147  L_L161  0.0054
K_K23253  L_L147  L_L162  0.0051
K_K23254  L_L147  L_L163  0.0047
K_K23255  L_L147  L_L164  0.0045
K_K23256  L_L147  L_L165  0.0042
K_K23257  L_L147  L_L166  0.0040
K_K23258  L_L147  L_L167  0.0038
K_K23259  L_L147  L_L168  0.0036
K_K23260  L_L147  L_L169  0.0034
K_K23261  L_L147  L_L170  0.0033
K_K23262  L_L147  L_L171  0.0032
K_K23263  L_L147  L_L172  0.0030
K_K23264  L_L147  L_L173  0.0029
K_K23265  L_L147  L_L174  0.0028
K_K23266  L_L147  L_L175  0.0027
K_K23267  L_L147  L_L176  0.0026
K_K23268  L_L147  L_L177  0.0025
K_K23269  L_L147  L_L178  0.0024
K_K23270  L_L147  L_L179  0.0024
K_K23271  L_L147  L_L180  0.0023
K_K23272  L_L147  L_L181  0.0022
K_K23273  L_L147  L_L182  0.0022
K_K23274  L_L147  L_L183  0.0021
K_K23275  L_L147  L_L184  0.0020
K_K23276  L_L147  L_L185  0.0020
K_K23277  L_L147  L_L186  0.0019
K_K23278  L_L147  L_L187  0.0019
K_K23279  L_L147  L_L188  0.0018
K_K23280  L_L147  L_L189  0.0018
K_K23281  L_L147  L_L190  0.0018
K_K23282  L_L147  L_L191  0.0017
K_K23283  L_L147  L_L192  0.0017
K_K23284  L_L147  L_L193  0.0016
K_K23285  L_L147  L_L194  0.0016
K_K23286  L_L147  L_L195  0.0016
K_K23287  L_L147  L_L196  0.0015
K_K23288  L_L147  L_L197  0.0015
K_K23289  L_L147  L_L198  0.0015
K_K23290  L_L147  L_L199  0.0015
K_K23291  L_L147  L_L200  0.0014
K_K23292  L_L147  L_L201  0.0014
K_K23293  L_L147  L_L202  0.0014
K_K23294  L_L147  L_L203  0.0014
K_K23295  L_L147  L_L204  0.0013
K_K23296  L_L147  L_L205  0.0013
K_K23297  L_L147  L_L206  0.0013
K_K23298  L_L147  L_L207  0.0013
K_K23299  L_L147  L_L208  0.0013
K_K23300  L_L147  L_L209  0.0012
K_K23301  L_L147  L_L210  0.0012
K_K23302  L_L147  L_L211  0.0012
K_K23303  L_L147  L_L212  0.0012
K_K23304  L_L147  L_L213  0.0011
K_K23305  L_L147  L_L214  0.0011
K_K23306  L_L147  L_L215  0.0011
K_K23307  L_L147  L_L216  0.0011
K_K23308  L_L147  L_L217  0.0011
K_K23309  L_L147  L_L218  0.0011
K_K23310  L_L147  L_L219  0.0011
K_K23311  L_L147  L_L220  0.0010
K_K23312  L_L147  L_L221  0.0010
K_K23313  L_L147  L_L222  0.0010
* *  Branch  NTMP0000000147 - NTMP0000000148
R_R148  NTMP0000000147  nU_148  32.914993m  TC=0,0
V_Ui148  nU_148  nR_148  STIMULUS=U_IND_0000000148
R_V295  nR_148  nV_295  23.280268m  TC=0,0
L_V295  nR_148  nV_295  0.014646uH
R_V296  nV_295  nV_296  7.852787m  TC=0,0
L_V296  nV_295  nV_296  0.073723uH
L_L148  nV_296  NTMP0000000148  6.519695uH
K_K23314  L_L148  L_L149  0.1050
K_K23315  L_L148  L_L150  0.0397
K_K23316  L_L148  L_L151  0.0258
K_K23317  L_L148  L_L152  0.0192
K_K23318  L_L148  L_L153  0.0153
K_K23319  L_L148  L_L154  0.0127
K_K23320  L_L148  L_L155  0.0109
K_K23321  L_L148  L_L156  0.0095
K_K23322  L_L148  L_L157  0.0084
K_K23323  L_L148  L_L158  0.0076
K_K23324  L_L148  L_L159  0.0069
K_K23325  L_L148  L_L160  0.0063
K_K23326  L_L148  L_L161  0.0058
K_K23327  L_L148  L_L162  0.0054
K_K23328  L_L148  L_L163  0.0051
K_K23329  L_L148  L_L164  0.0047
K_K23330  L_L148  L_L165  0.0045
K_K23331  L_L148  L_L166  0.0042
K_K23332  L_L148  L_L167  0.0040
K_K23333  L_L148  L_L168  0.0038
K_K23334  L_L148  L_L169  0.0036
K_K23335  L_L148  L_L170  0.0034
K_K23336  L_L148  L_L171  0.0033
K_K23337  L_L148  L_L172  0.0032
K_K23338  L_L148  L_L173  0.0030
K_K23339  L_L148  L_L174  0.0029
K_K23340  L_L148  L_L175  0.0028
K_K23341  L_L148  L_L176  0.0027
K_K23342  L_L148  L_L177  0.0026
K_K23343  L_L148  L_L178  0.0025
K_K23344  L_L148  L_L179  0.0024
K_K23345  L_L148  L_L180  0.0024
K_K23346  L_L148  L_L181  0.0023
K_K23347  L_L148  L_L182  0.0022
K_K23348  L_L148  L_L183  0.0022
K_K23349  L_L148  L_L184  0.0021
K_K23350  L_L148  L_L185  0.0020
K_K23351  L_L148  L_L186  0.0020
K_K23352  L_L148  L_L187  0.0019
K_K23353  L_L148  L_L188  0.0019
K_K23354  L_L148  L_L189  0.0018
K_K23355  L_L148  L_L190  0.0018
K_K23356  L_L148  L_L191  0.0018
K_K23357  L_L148  L_L192  0.0017
K_K23358  L_L148  L_L193  0.0017
K_K23359  L_L148  L_L194  0.0016
K_K23360  L_L148  L_L195  0.0016
K_K23361  L_L148  L_L196  0.0016
K_K23362  L_L148  L_L197  0.0015
K_K23363  L_L148  L_L198  0.0015
K_K23364  L_L148  L_L199  0.0015
K_K23365  L_L148  L_L200  0.0015
K_K23366  L_L148  L_L201  0.0014
K_K23367  L_L148  L_L202  0.0014
K_K23368  L_L148  L_L203  0.0014
K_K23369  L_L148  L_L204  0.0014
K_K23370  L_L148  L_L205  0.0013
K_K23371  L_L148  L_L206  0.0013
K_K23372  L_L148  L_L207  0.0013
K_K23373  L_L148  L_L208  0.0013
K_K23374  L_L148  L_L209  0.0013
K_K23375  L_L148  L_L210  0.0012
K_K23376  L_L148  L_L211  0.0012
K_K23377  L_L148  L_L212  0.0012
K_K23378  L_L148  L_L213  0.0012
K_K23379  L_L148  L_L214  0.0011
K_K23380  L_L148  L_L215  0.0011
K_K23381  L_L148  L_L216  0.0011
K_K23382  L_L148  L_L217  0.0011
K_K23383  L_L148  L_L218  0.0011
K_K23384  L_L148  L_L219  0.0011
K_K23385  L_L148  L_L220  0.0011
K_K23386  L_L148  L_L221  0.0010
K_K23387  L_L148  L_L222  0.0010
K_K23388  L_L148  L_L223  0.0010
* *  Branch  NTMP0000000148 - NTMP0000000149
R_R149  NTMP0000000148  nU_149  32.914993m  TC=0,0
V_Ui149  nU_149  nR_149  STIMULUS=U_IND_0000000149
R_V297  nR_149  nV_297  23.280268m  TC=0,0
L_V297  nR_149  nV_297  0.014646uH
R_V298  nV_297  nV_298  7.852787m  TC=0,0
L_V298  nV_297  nV_298  0.073723uH
L_L149  nV_298  NTMP0000000149  6.519695uH
K_K23389  L_L149  L_L150  0.1050
K_K23390  L_L149  L_L151  0.0397
K_K23391  L_L149  L_L152  0.0258
K_K23392  L_L149  L_L153  0.0192
K_K23393  L_L149  L_L154  0.0153
K_K23394  L_L149  L_L155  0.0127
K_K23395  L_L149  L_L156  0.0109
K_K23396  L_L149  L_L157  0.0095
K_K23397  L_L149  L_L158  0.0084
K_K23398  L_L149  L_L159  0.0076
K_K23399  L_L149  L_L160  0.0069
K_K23400  L_L149  L_L161  0.0063
K_K23401  L_L149  L_L162  0.0058
K_K23402  L_L149  L_L163  0.0054
K_K23403  L_L149  L_L164  0.0051
K_K23404  L_L149  L_L165  0.0047
K_K23405  L_L149  L_L166  0.0045
K_K23406  L_L149  L_L167  0.0042
K_K23407  L_L149  L_L168  0.0040
K_K23408  L_L149  L_L169  0.0038
K_K23409  L_L149  L_L170  0.0036
K_K23410  L_L149  L_L171  0.0034
K_K23411  L_L149  L_L172  0.0033
K_K23412  L_L149  L_L173  0.0032
K_K23413  L_L149  L_L174  0.0030
K_K23414  L_L149  L_L175  0.0029
K_K23415  L_L149  L_L176  0.0028
K_K23416  L_L149  L_L177  0.0027
K_K23417  L_L149  L_L178  0.0026
K_K23418  L_L149  L_L179  0.0025
K_K23419  L_L149  L_L180  0.0024
K_K23420  L_L149  L_L181  0.0024
K_K23421  L_L149  L_L182  0.0023
K_K23422  L_L149  L_L183  0.0022
K_K23423  L_L149  L_L184  0.0022
K_K23424  L_L149  L_L185  0.0021
K_K23425  L_L149  L_L186  0.0020
K_K23426  L_L149  L_L187  0.0020
K_K23427  L_L149  L_L188  0.0019
K_K23428  L_L149  L_L189  0.0019
K_K23429  L_L149  L_L190  0.0018
K_K23430  L_L149  L_L191  0.0018
K_K23431  L_L149  L_L192  0.0018
K_K23432  L_L149  L_L193  0.0017
K_K23433  L_L149  L_L194  0.0017
K_K23434  L_L149  L_L195  0.0016
K_K23435  L_L149  L_L196  0.0016
K_K23436  L_L149  L_L197  0.0016
K_K23437  L_L149  L_L198  0.0015
K_K23438  L_L149  L_L199  0.0015
K_K23439  L_L149  L_L200  0.0015
K_K23440  L_L149  L_L201  0.0015
K_K23441  L_L149  L_L202  0.0014
K_K23442  L_L149  L_L203  0.0014
K_K23443  L_L149  L_L204  0.0014
K_K23444  L_L149  L_L205  0.0014
K_K23445  L_L149  L_L206  0.0013
K_K23446  L_L149  L_L207  0.0013
K_K23447  L_L149  L_L208  0.0013
K_K23448  L_L149  L_L209  0.0013
K_K23449  L_L149  L_L210  0.0013
K_K23450  L_L149  L_L211  0.0012
K_K23451  L_L149  L_L212  0.0012
K_K23452  L_L149  L_L213  0.0012
K_K23453  L_L149  L_L214  0.0012
K_K23454  L_L149  L_L215  0.0011
K_K23455  L_L149  L_L216  0.0011
K_K23456  L_L149  L_L217  0.0011
K_K23457  L_L149  L_L218  0.0011
K_K23458  L_L149  L_L219  0.0011
K_K23459  L_L149  L_L220  0.0011
K_K23460  L_L149  L_L221  0.0011
K_K23461  L_L149  L_L222  0.0010
K_K23462  L_L149  L_L223  0.0010
K_K23463  L_L149  L_L224  0.0010
* *  Branch  NTMP0000000149 - NTMP0000000150
R_R150  NTMP0000000149  nU_150  32.914993m  TC=0,0
V_Ui150  nU_150  nR_150  STIMULUS=U_IND_0000000150
R_V299  nR_150  nV_299  23.280268m  TC=0,0
L_V299  nR_150  nV_299  0.014646uH
R_V300  nV_299  nV_300  7.852787m  TC=0,0
L_V300  nV_299  nV_300  0.073723uH
L_L150  nV_300  NTMP0000000150  6.519695uH
K_K23464  L_L150  L_L151  0.1050
K_K23465  L_L150  L_L152  0.0397
K_K23466  L_L150  L_L153  0.0258
K_K23467  L_L150  L_L154  0.0192
K_K23468  L_L150  L_L155  0.0153
K_K23469  L_L150  L_L156  0.0127
K_K23470  L_L150  L_L157  0.0109
K_K23471  L_L150  L_L158  0.0095
K_K23472  L_L150  L_L159  0.0084
K_K23473  L_L150  L_L160  0.0076
K_K23474  L_L150  L_L161  0.0069
K_K23475  L_L150  L_L162  0.0063
K_K23476  L_L150  L_L163  0.0058
K_K23477  L_L150  L_L164  0.0054
K_K23478  L_L150  L_L165  0.0051
K_K23479  L_L150  L_L166  0.0047
K_K23480  L_L150  L_L167  0.0045
K_K23481  L_L150  L_L168  0.0042
K_K23482  L_L150  L_L169  0.0040
K_K23483  L_L150  L_L170  0.0038
K_K23484  L_L150  L_L171  0.0036
K_K23485  L_L150  L_L172  0.0034
K_K23486  L_L150  L_L173  0.0033
K_K23487  L_L150  L_L174  0.0032
K_K23488  L_L150  L_L175  0.0030
K_K23489  L_L150  L_L176  0.0029
K_K23490  L_L150  L_L177  0.0028
K_K23491  L_L150  L_L178  0.0027
K_K23492  L_L150  L_L179  0.0026
K_K23493  L_L150  L_L180  0.0025
K_K23494  L_L150  L_L181  0.0024
K_K23495  L_L150  L_L182  0.0024
K_K23496  L_L150  L_L183  0.0023
K_K23497  L_L150  L_L184  0.0022
K_K23498  L_L150  L_L185  0.0022
K_K23499  L_L150  L_L186  0.0021
K_K23500  L_L150  L_L187  0.0020
K_K23501  L_L150  L_L188  0.0020
K_K23502  L_L150  L_L189  0.0019
K_K23503  L_L150  L_L190  0.0019
K_K23504  L_L150  L_L191  0.0019
K_K23505  L_L150  L_L192  0.0018
K_K23506  L_L150  L_L193  0.0018
K_K23507  L_L150  L_L194  0.0017
K_K23508  L_L150  L_L195  0.0017
K_K23509  L_L150  L_L196  0.0017
K_K23510  L_L150  L_L197  0.0016
K_K23511  L_L150  L_L198  0.0016
K_K23512  L_L150  L_L199  0.0015
K_K23513  L_L150  L_L200  0.0015
K_K23514  L_L150  L_L201  0.0015
K_K23515  L_L150  L_L202  0.0015
K_K23516  L_L150  L_L203  0.0014
K_K23517  L_L150  L_L204  0.0014
K_K23518  L_L150  L_L205  0.0014
K_K23519  L_L150  L_L206  0.0014
K_K23520  L_L150  L_L207  0.0013
K_K23521  L_L150  L_L208  0.0013
K_K23522  L_L150  L_L209  0.0013
K_K23523  L_L150  L_L210  0.0013
K_K23524  L_L150  L_L211  0.0013
K_K23525  L_L150  L_L212  0.0012
K_K23526  L_L150  L_L213  0.0012
K_K23527  L_L150  L_L214  0.0012
K_K23528  L_L150  L_L215  0.0012
K_K23529  L_L150  L_L216  0.0011
K_K23530  L_L150  L_L217  0.0011
K_K23531  L_L150  L_L218  0.0011
K_K23532  L_L150  L_L219  0.0011
K_K23533  L_L150  L_L220  0.0011
K_K23534  L_L150  L_L221  0.0011
K_K23535  L_L150  L_L222  0.0011
K_K23536  L_L150  L_L223  0.0010
K_K23537  L_L150  L_L224  0.0010
K_K23538  L_L150  L_L225  0.0010
* *  Branch  NTMP0000000150 - NTMP0000000151
R_R151  NTMP0000000150  nU_151  32.914993m  TC=0,0
V_Ui151  nU_151  nR_151  STIMULUS=U_IND_0000000151
R_V301  nR_151  nV_301  23.280268m  TC=0,0
L_V301  nR_151  nV_301  0.014646uH
R_V302  nV_301  nV_302  7.852787m  TC=0,0
L_V302  nV_301  nV_302  0.073723uH
L_L151  nV_302  NTMP0000000151  6.519695uH
K_K23539  L_L151  L_L152  0.1050
K_K23540  L_L151  L_L153  0.0397
K_K23541  L_L151  L_L154  0.0258
K_K23542  L_L151  L_L155  0.0192
K_K23543  L_L151  L_L156  0.0153
K_K23544  L_L151  L_L157  0.0127
K_K23545  L_L151  L_L158  0.0109
K_K23546  L_L151  L_L159  0.0095
K_K23547  L_L151  L_L160  0.0084
K_K23548  L_L151  L_L161  0.0076
K_K23549  L_L151  L_L162  0.0069
K_K23550  L_L151  L_L163  0.0063
K_K23551  L_L151  L_L164  0.0058
K_K23552  L_L151  L_L165  0.0054
K_K23553  L_L151  L_L166  0.0051
K_K23554  L_L151  L_L167  0.0047
K_K23555  L_L151  L_L168  0.0045
K_K23556  L_L151  L_L169  0.0042
K_K23557  L_L151  L_L170  0.0040
K_K23558  L_L151  L_L171  0.0038
K_K23559  L_L151  L_L172  0.0036
K_K23560  L_L151  L_L173  0.0034
K_K23561  L_L151  L_L174  0.0033
K_K23562  L_L151  L_L175  0.0032
K_K23563  L_L151  L_L176  0.0030
K_K23564  L_L151  L_L177  0.0029
K_K23565  L_L151  L_L178  0.0028
K_K23566  L_L151  L_L179  0.0027
K_K23567  L_L151  L_L180  0.0026
K_K23568  L_L151  L_L181  0.0025
K_K23569  L_L151  L_L182  0.0024
K_K23570  L_L151  L_L183  0.0024
K_K23571  L_L151  L_L184  0.0023
K_K23572  L_L151  L_L185  0.0022
K_K23573  L_L151  L_L186  0.0022
K_K23574  L_L151  L_L187  0.0021
K_K23575  L_L151  L_L188  0.0020
K_K23576  L_L151  L_L189  0.0020
K_K23577  L_L151  L_L190  0.0019
K_K23578  L_L151  L_L191  0.0019
K_K23579  L_L151  L_L192  0.0019
K_K23580  L_L151  L_L193  0.0018
K_K23581  L_L151  L_L194  0.0018
K_K23582  L_L151  L_L195  0.0017
K_K23583  L_L151  L_L196  0.0017
K_K23584  L_L151  L_L197  0.0017
K_K23585  L_L151  L_L198  0.0016
K_K23586  L_L151  L_L199  0.0016
K_K23587  L_L151  L_L200  0.0015
K_K23588  L_L151  L_L201  0.0015
K_K23589  L_L151  L_L202  0.0015
K_K23590  L_L151  L_L203  0.0015
K_K23591  L_L151  L_L204  0.0014
K_K23592  L_L151  L_L205  0.0014
K_K23593  L_L151  L_L206  0.0014
K_K23594  L_L151  L_L207  0.0014
K_K23595  L_L151  L_L208  0.0013
K_K23596  L_L151  L_L209  0.0013
K_K23597  L_L151  L_L210  0.0013
K_K23598  L_L151  L_L211  0.0013
K_K23599  L_L151  L_L212  0.0013
K_K23600  L_L151  L_L213  0.0012
K_K23601  L_L151  L_L214  0.0012
K_K23602  L_L151  L_L215  0.0012
K_K23603  L_L151  L_L216  0.0012
K_K23604  L_L151  L_L217  0.0011
K_K23605  L_L151  L_L218  0.0011
K_K23606  L_L151  L_L219  0.0011
K_K23607  L_L151  L_L220  0.0011
K_K23608  L_L151  L_L221  0.0011
K_K23609  L_L151  L_L222  0.0011
K_K23610  L_L151  L_L223  0.0011
K_K23611  L_L151  L_L224  0.0010
K_K23612  L_L151  L_L225  0.0010
K_K23613  L_L151  L_L226  0.0010
* *  Branch  NTMP0000000151 - NTMP0000000152
R_R152  NTMP0000000151  nU_152  32.914993m  TC=0,0
V_Ui152  nU_152  nR_152  STIMULUS=U_IND_0000000152
R_V303  nR_152  nV_303  23.280268m  TC=0,0
L_V303  nR_152  nV_303  0.014646uH
R_V304  nV_303  nV_304  7.852787m  TC=0,0
L_V304  nV_303  nV_304  0.073723uH
L_L152  nV_304  NTMP0000000152  6.519695uH
K_K23614  L_L152  L_L153  0.1050
K_K23615  L_L152  L_L154  0.0397
K_K23616  L_L152  L_L155  0.0258
K_K23617  L_L152  L_L156  0.0192
K_K23618  L_L152  L_L157  0.0153
K_K23619  L_L152  L_L158  0.0127
K_K23620  L_L152  L_L159  0.0109
K_K23621  L_L152  L_L160  0.0095
K_K23622  L_L152  L_L161  0.0084
K_K23623  L_L152  L_L162  0.0076
K_K23624  L_L152  L_L163  0.0069
K_K23625  L_L152  L_L164  0.0063
K_K23626  L_L152  L_L165  0.0058
K_K23627  L_L152  L_L166  0.0054
K_K23628  L_L152  L_L167  0.0051
K_K23629  L_L152  L_L168  0.0047
K_K23630  L_L152  L_L169  0.0045
K_K23631  L_L152  L_L170  0.0042
K_K23632  L_L152  L_L171  0.0040
K_K23633  L_L152  L_L172  0.0038
K_K23634  L_L152  L_L173  0.0036
K_K23635  L_L152  L_L174  0.0034
K_K23636  L_L152  L_L175  0.0033
K_K23637  L_L152  L_L176  0.0032
K_K23638  L_L152  L_L177  0.0030
K_K23639  L_L152  L_L178  0.0029
K_K23640  L_L152  L_L179  0.0028
K_K23641  L_L152  L_L180  0.0027
K_K23642  L_L152  L_L181  0.0026
K_K23643  L_L152  L_L182  0.0025
K_K23644  L_L152  L_L183  0.0024
K_K23645  L_L152  L_L184  0.0024
K_K23646  L_L152  L_L185  0.0023
K_K23647  L_L152  L_L186  0.0022
K_K23648  L_L152  L_L187  0.0022
K_K23649  L_L152  L_L188  0.0021
K_K23650  L_L152  L_L189  0.0020
K_K23651  L_L152  L_L190  0.0020
K_K23652  L_L152  L_L191  0.0019
K_K23653  L_L152  L_L192  0.0019
K_K23654  L_L152  L_L193  0.0019
K_K23655  L_L152  L_L194  0.0018
K_K23656  L_L152  L_L195  0.0018
K_K23657  L_L152  L_L196  0.0017
K_K23658  L_L152  L_L197  0.0017
K_K23659  L_L152  L_L198  0.0017
K_K23660  L_L152  L_L199  0.0016
K_K23661  L_L152  L_L200  0.0016
K_K23662  L_L152  L_L201  0.0015
K_K23663  L_L152  L_L202  0.0015
K_K23664  L_L152  L_L203  0.0015
K_K23665  L_L152  L_L204  0.0015
K_K23666  L_L152  L_L205  0.0014
K_K23667  L_L152  L_L206  0.0014
K_K23668  L_L152  L_L207  0.0014
K_K23669  L_L152  L_L208  0.0014
K_K23670  L_L152  L_L209  0.0013
K_K23671  L_L152  L_L210  0.0013
K_K23672  L_L152  L_L211  0.0013
K_K23673  L_L152  L_L212  0.0013
K_K23674  L_L152  L_L213  0.0013
K_K23675  L_L152  L_L214  0.0012
K_K23676  L_L152  L_L215  0.0012
K_K23677  L_L152  L_L216  0.0012
K_K23678  L_L152  L_L217  0.0012
K_K23679  L_L152  L_L218  0.0011
K_K23680  L_L152  L_L219  0.0011
K_K23681  L_L152  L_L220  0.0011
K_K23682  L_L152  L_L221  0.0011
K_K23683  L_L152  L_L222  0.0011
K_K23684  L_L152  L_L223  0.0011
K_K23685  L_L152  L_L224  0.0011
K_K23686  L_L152  L_L225  0.0010
K_K23687  L_L152  L_L226  0.0010
K_K23688  L_L152  L_L227  0.0010
* *  Branch  NTMP0000000152 - NTMP0000000153
R_R153  NTMP0000000152  nU_153  32.914993m  TC=0,0
V_Ui153  nU_153  nR_153  STIMULUS=U_IND_0000000153
R_V305  nR_153  nV_305  23.280268m  TC=0,0
L_V305  nR_153  nV_305  0.014646uH
R_V306  nV_305  nV_306  7.852787m  TC=0,0
L_V306  nV_305  nV_306  0.073723uH
L_L153  nV_306  NTMP0000000153  6.519695uH
K_K23689  L_L153  L_L154  0.1050
K_K23690  L_L153  L_L155  0.0397
K_K23691  L_L153  L_L156  0.0258
K_K23692  L_L153  L_L157  0.0192
K_K23693  L_L153  L_L158  0.0153
K_K23694  L_L153  L_L159  0.0127
K_K23695  L_L153  L_L160  0.0109
K_K23696  L_L153  L_L161  0.0095
K_K23697  L_L153  L_L162  0.0084
K_K23698  L_L153  L_L163  0.0076
K_K23699  L_L153  L_L164  0.0069
K_K23700  L_L153  L_L165  0.0063
K_K23701  L_L153  L_L166  0.0058
K_K23702  L_L153  L_L167  0.0054
K_K23703  L_L153  L_L168  0.0051
K_K23704  L_L153  L_L169  0.0047
K_K23705  L_L153  L_L170  0.0045
K_K23706  L_L153  L_L171  0.0042
K_K23707  L_L153  L_L172  0.0040
K_K23708  L_L153  L_L173  0.0038
K_K23709  L_L153  L_L174  0.0036
K_K23710  L_L153  L_L175  0.0034
K_K23711  L_L153  L_L176  0.0033
K_K23712  L_L153  L_L177  0.0032
K_K23713  L_L153  L_L178  0.0030
K_K23714  L_L153  L_L179  0.0029
K_K23715  L_L153  L_L180  0.0028
K_K23716  L_L153  L_L181  0.0027
K_K23717  L_L153  L_L182  0.0026
K_K23718  L_L153  L_L183  0.0025
K_K23719  L_L153  L_L184  0.0024
K_K23720  L_L153  L_L185  0.0024
K_K23721  L_L153  L_L186  0.0023
K_K23722  L_L153  L_L187  0.0022
K_K23723  L_L153  L_L188  0.0022
K_K23724  L_L153  L_L189  0.0021
K_K23725  L_L153  L_L190  0.0020
K_K23726  L_L153  L_L191  0.0020
K_K23727  L_L153  L_L192  0.0019
K_K23728  L_L153  L_L193  0.0019
K_K23729  L_L153  L_L194  0.0019
K_K23730  L_L153  L_L195  0.0018
K_K23731  L_L153  L_L196  0.0018
K_K23732  L_L153  L_L197  0.0017
K_K23733  L_L153  L_L198  0.0017
K_K23734  L_L153  L_L199  0.0017
K_K23735  L_L153  L_L200  0.0016
K_K23736  L_L153  L_L201  0.0016
K_K23737  L_L153  L_L202  0.0015
K_K23738  L_L153  L_L203  0.0015
K_K23739  L_L153  L_L204  0.0015
K_K23740  L_L153  L_L205  0.0015
K_K23741  L_L153  L_L206  0.0014
K_K23742  L_L153  L_L207  0.0014
K_K23743  L_L153  L_L208  0.0014
K_K23744  L_L153  L_L209  0.0014
K_K23745  L_L153  L_L210  0.0013
K_K23746  L_L153  L_L211  0.0013
K_K23747  L_L153  L_L212  0.0013
K_K23748  L_L153  L_L213  0.0013
K_K23749  L_L153  L_L214  0.0013
K_K23750  L_L153  L_L215  0.0012
K_K23751  L_L153  L_L216  0.0012
K_K23752  L_L153  L_L217  0.0012
K_K23753  L_L153  L_L218  0.0012
K_K23754  L_L153  L_L219  0.0011
K_K23755  L_L153  L_L220  0.0011
K_K23756  L_L153  L_L221  0.0011
K_K23757  L_L153  L_L222  0.0011
K_K23758  L_L153  L_L223  0.0011
K_K23759  L_L153  L_L224  0.0011
K_K23760  L_L153  L_L225  0.0011
K_K23761  L_L153  L_L226  0.0010
K_K23762  L_L153  L_L227  0.0010
K_K23763  L_L153  L_L228  0.0010
* *  Branch  NTMP0000000153 - NTMP0000000154
R_R154  NTMP0000000153  nU_154  32.914993m  TC=0,0
V_Ui154  nU_154  nR_154  STIMULUS=U_IND_0000000154
R_V307  nR_154  nV_307  23.280268m  TC=0,0
L_V307  nR_154  nV_307  0.014646uH
R_V308  nV_307  nV_308  7.852787m  TC=0,0
L_V308  nV_307  nV_308  0.073723uH
L_L154  nV_308  NTMP0000000154  6.519695uH
K_K23764  L_L154  L_L155  0.1050
K_K23765  L_L154  L_L156  0.0397
K_K23766  L_L154  L_L157  0.0258
K_K23767  L_L154  L_L158  0.0192
K_K23768  L_L154  L_L159  0.0153
K_K23769  L_L154  L_L160  0.0127
K_K23770  L_L154  L_L161  0.0109
K_K23771  L_L154  L_L162  0.0095
K_K23772  L_L154  L_L163  0.0084
K_K23773  L_L154  L_L164  0.0076
K_K23774  L_L154  L_L165  0.0069
K_K23775  L_L154  L_L166  0.0063
K_K23776  L_L154  L_L167  0.0058
K_K23777  L_L154  L_L168  0.0054
K_K23778  L_L154  L_L169  0.0051
K_K23779  L_L154  L_L170  0.0047
K_K23780  L_L154  L_L171  0.0045
K_K23781  L_L154  L_L172  0.0042
K_K23782  L_L154  L_L173  0.0040
K_K23783  L_L154  L_L174  0.0038
K_K23784  L_L154  L_L175  0.0036
K_K23785  L_L154  L_L176  0.0034
K_K23786  L_L154  L_L177  0.0033
K_K23787  L_L154  L_L178  0.0032
K_K23788  L_L154  L_L179  0.0030
K_K23789  L_L154  L_L180  0.0029
K_K23790  L_L154  L_L181  0.0028
K_K23791  L_L154  L_L182  0.0027
K_K23792  L_L154  L_L183  0.0026
K_K23793  L_L154  L_L184  0.0025
K_K23794  L_L154  L_L185  0.0024
K_K23795  L_L154  L_L186  0.0024
K_K23796  L_L154  L_L187  0.0023
K_K23797  L_L154  L_L188  0.0022
K_K23798  L_L154  L_L189  0.0022
K_K23799  L_L154  L_L190  0.0021
K_K23800  L_L154  L_L191  0.0020
K_K23801  L_L154  L_L192  0.0020
K_K23802  L_L154  L_L193  0.0019
K_K23803  L_L154  L_L194  0.0019
K_K23804  L_L154  L_L195  0.0019
K_K23805  L_L154  L_L196  0.0018
K_K23806  L_L154  L_L197  0.0018
K_K23807  L_L154  L_L198  0.0017
K_K23808  L_L154  L_L199  0.0017
K_K23809  L_L154  L_L200  0.0017
K_K23810  L_L154  L_L201  0.0016
K_K23811  L_L154  L_L202  0.0016
K_K23812  L_L154  L_L203  0.0015
K_K23813  L_L154  L_L204  0.0015
K_K23814  L_L154  L_L205  0.0015
K_K23815  L_L154  L_L206  0.0015
K_K23816  L_L154  L_L207  0.0014
K_K23817  L_L154  L_L208  0.0014
K_K23818  L_L154  L_L209  0.0014
K_K23819  L_L154  L_L210  0.0014
K_K23820  L_L154  L_L211  0.0013
K_K23821  L_L154  L_L212  0.0013
K_K23822  L_L154  L_L213  0.0013
K_K23823  L_L154  L_L214  0.0013
K_K23824  L_L154  L_L215  0.0013
K_K23825  L_L154  L_L216  0.0012
K_K23826  L_L154  L_L217  0.0012
K_K23827  L_L154  L_L218  0.0012
K_K23828  L_L154  L_L219  0.0012
K_K23829  L_L154  L_L220  0.0011
K_K23830  L_L154  L_L221  0.0011
K_K23831  L_L154  L_L222  0.0011
K_K23832  L_L154  L_L223  0.0011
K_K23833  L_L154  L_L224  0.0011
K_K23834  L_L154  L_L225  0.0011
K_K23835  L_L154  L_L226  0.0011
K_K23836  L_L154  L_L227  0.0010
K_K23837  L_L154  L_L228  0.0010
K_K23838  L_L154  L_L229  0.0010
* *  Branch  NTMP0000000154 - NTMP0000000155
R_R155  NTMP0000000154  nU_155  32.914993m  TC=0,0
V_Ui155  nU_155  nR_155  STIMULUS=U_IND_0000000155
R_V309  nR_155  nV_309  23.280268m  TC=0,0
L_V309  nR_155  nV_309  0.014646uH
R_V310  nV_309  nV_310  7.852787m  TC=0,0
L_V310  nV_309  nV_310  0.073723uH
L_L155  nV_310  NTMP0000000155  6.519695uH
K_K23839  L_L155  L_L156  0.1050
K_K23840  L_L155  L_L157  0.0397
K_K23841  L_L155  L_L158  0.0258
K_K23842  L_L155  L_L159  0.0192
K_K23843  L_L155  L_L160  0.0153
K_K23844  L_L155  L_L161  0.0127
K_K23845  L_L155  L_L162  0.0109
K_K23846  L_L155  L_L163  0.0095
K_K23847  L_L155  L_L164  0.0084
K_K23848  L_L155  L_L165  0.0076
K_K23849  L_L155  L_L166  0.0069
K_K23850  L_L155  L_L167  0.0063
K_K23851  L_L155  L_L168  0.0058
K_K23852  L_L155  L_L169  0.0054
K_K23853  L_L155  L_L170  0.0051
K_K23854  L_L155  L_L171  0.0047
K_K23855  L_L155  L_L172  0.0045
K_K23856  L_L155  L_L173  0.0042
K_K23857  L_L155  L_L174  0.0040
K_K23858  L_L155  L_L175  0.0038
K_K23859  L_L155  L_L176  0.0036
K_K23860  L_L155  L_L177  0.0034
K_K23861  L_L155  L_L178  0.0033
K_K23862  L_L155  L_L179  0.0032
K_K23863  L_L155  L_L180  0.0030
K_K23864  L_L155  L_L181  0.0029
K_K23865  L_L155  L_L182  0.0028
K_K23866  L_L155  L_L183  0.0027
K_K23867  L_L155  L_L184  0.0026
K_K23868  L_L155  L_L185  0.0025
K_K23869  L_L155  L_L186  0.0024
K_K23870  L_L155  L_L187  0.0024
K_K23871  L_L155  L_L188  0.0023
K_K23872  L_L155  L_L189  0.0022
K_K23873  L_L155  L_L190  0.0022
K_K23874  L_L155  L_L191  0.0021
K_K23875  L_L155  L_L192  0.0020
K_K23876  L_L155  L_L193  0.0020
K_K23877  L_L155  L_L194  0.0019
K_K23878  L_L155  L_L195  0.0019
K_K23879  L_L155  L_L196  0.0019
K_K23880  L_L155  L_L197  0.0018
K_K23881  L_L155  L_L198  0.0018
K_K23882  L_L155  L_L199  0.0017
K_K23883  L_L155  L_L200  0.0017
K_K23884  L_L155  L_L201  0.0017
K_K23885  L_L155  L_L202  0.0016
K_K23886  L_L155  L_L203  0.0016
K_K23887  L_L155  L_L204  0.0015
K_K23888  L_L155  L_L205  0.0015
K_K23889  L_L155  L_L206  0.0015
K_K23890  L_L155  L_L207  0.0015
K_K23891  L_L155  L_L208  0.0014
K_K23892  L_L155  L_L209  0.0014
K_K23893  L_L155  L_L210  0.0014
K_K23894  L_L155  L_L211  0.0014
K_K23895  L_L155  L_L212  0.0013
K_K23896  L_L155  L_L213  0.0013
K_K23897  L_L155  L_L214  0.0013
K_K23898  L_L155  L_L215  0.0013
K_K23899  L_L155  L_L216  0.0013
K_K23900  L_L155  L_L217  0.0012
K_K23901  L_L155  L_L218  0.0012
K_K23902  L_L155  L_L219  0.0012
K_K23903  L_L155  L_L220  0.0012
K_K23904  L_L155  L_L221  0.0011
K_K23905  L_L155  L_L222  0.0011
K_K23906  L_L155  L_L223  0.0011
K_K23907  L_L155  L_L224  0.0011
K_K23908  L_L155  L_L225  0.0011
K_K23909  L_L155  L_L226  0.0011
K_K23910  L_L155  L_L227  0.0011
K_K23911  L_L155  L_L228  0.0010
K_K23912  L_L155  L_L229  0.0010
K_K23913  L_L155  L_L230  0.0010
* *  Branch  NTMP0000000155 - NTMP0000000156
R_R156  NTMP0000000155  nU_156  32.914993m  TC=0,0
V_Ui156  nU_156  nR_156  STIMULUS=U_IND_0000000156
R_V311  nR_156  nV_311  23.280268m  TC=0,0
L_V311  nR_156  nV_311  0.014646uH
R_V312  nV_311  nV_312  7.852787m  TC=0,0
L_V312  nV_311  nV_312  0.073723uH
L_L156  nV_312  NTMP0000000156  6.519695uH
K_K23914  L_L156  L_L157  0.1050
K_K23915  L_L156  L_L158  0.0397
K_K23916  L_L156  L_L159  0.0258
K_K23917  L_L156  L_L160  0.0192
K_K23918  L_L156  L_L161  0.0153
K_K23919  L_L156  L_L162  0.0127
K_K23920  L_L156  L_L163  0.0109
K_K23921  L_L156  L_L164  0.0095
K_K23922  L_L156  L_L165  0.0084
K_K23923  L_L156  L_L166  0.0076
K_K23924  L_L156  L_L167  0.0069
K_K23925  L_L156  L_L168  0.0063
K_K23926  L_L156  L_L169  0.0058
K_K23927  L_L156  L_L170  0.0054
K_K23928  L_L156  L_L171  0.0051
K_K23929  L_L156  L_L172  0.0047
K_K23930  L_L156  L_L173  0.0045
K_K23931  L_L156  L_L174  0.0042
K_K23932  L_L156  L_L175  0.0040
K_K23933  L_L156  L_L176  0.0038
K_K23934  L_L156  L_L177  0.0036
K_K23935  L_L156  L_L178  0.0034
K_K23936  L_L156  L_L179  0.0033
K_K23937  L_L156  L_L180  0.0032
K_K23938  L_L156  L_L181  0.0030
K_K23939  L_L156  L_L182  0.0029
K_K23940  L_L156  L_L183  0.0028
K_K23941  L_L156  L_L184  0.0027
K_K23942  L_L156  L_L185  0.0026
K_K23943  L_L156  L_L186  0.0025
K_K23944  L_L156  L_L187  0.0024
K_K23945  L_L156  L_L188  0.0024
K_K23946  L_L156  L_L189  0.0023
K_K23947  L_L156  L_L190  0.0022
K_K23948  L_L156  L_L191  0.0022
K_K23949  L_L156  L_L192  0.0021
K_K23950  L_L156  L_L193  0.0020
K_K23951  L_L156  L_L194  0.0020
K_K23952  L_L156  L_L195  0.0019
K_K23953  L_L156  L_L196  0.0019
K_K23954  L_L156  L_L197  0.0019
K_K23955  L_L156  L_L198  0.0018
K_K23956  L_L156  L_L199  0.0018
K_K23957  L_L156  L_L200  0.0017
K_K23958  L_L156  L_L201  0.0017
K_K23959  L_L156  L_L202  0.0017
K_K23960  L_L156  L_L203  0.0016
K_K23961  L_L156  L_L204  0.0016
K_K23962  L_L156  L_L205  0.0015
K_K23963  L_L156  L_L206  0.0015
K_K23964  L_L156  L_L207  0.0015
K_K23965  L_L156  L_L208  0.0015
K_K23966  L_L156  L_L209  0.0014
K_K23967  L_L156  L_L210  0.0014
K_K23968  L_L156  L_L211  0.0014
K_K23969  L_L156  L_L212  0.0014
K_K23970  L_L156  L_L213  0.0013
K_K23971  L_L156  L_L214  0.0013
K_K23972  L_L156  L_L215  0.0013
K_K23973  L_L156  L_L216  0.0013
K_K23974  L_L156  L_L217  0.0013
K_K23975  L_L156  L_L218  0.0012
K_K23976  L_L156  L_L219  0.0012
K_K23977  L_L156  L_L220  0.0012
K_K23978  L_L156  L_L221  0.0012
K_K23979  L_L156  L_L222  0.0011
K_K23980  L_L156  L_L223  0.0011
K_K23981  L_L156  L_L224  0.0011
K_K23982  L_L156  L_L225  0.0011
K_K23983  L_L156  L_L226  0.0011
K_K23984  L_L156  L_L227  0.0011
K_K23985  L_L156  L_L228  0.0011
K_K23986  L_L156  L_L229  0.0010
K_K23987  L_L156  L_L230  0.0010
K_K23988  L_L156  L_L231  0.0010
* *  Branch  NTMP0000000156 - NTMP0000000157
R_R157  NTMP0000000156  nU_157  32.914993m  TC=0,0
V_Ui157  nU_157  nR_157  STIMULUS=U_IND_0000000157
R_V313  nR_157  nV_313  23.280268m  TC=0,0
L_V313  nR_157  nV_313  0.014646uH
R_V314  nV_313  nV_314  7.852787m  TC=0,0
L_V314  nV_313  nV_314  0.073723uH
L_L157  nV_314  NTMP0000000157  6.519695uH
K_K23989  L_L157  L_L158  0.1050
K_K23990  L_L157  L_L159  0.0397
K_K23991  L_L157  L_L160  0.0258
K_K23992  L_L157  L_L161  0.0192
K_K23993  L_L157  L_L162  0.0153
K_K23994  L_L157  L_L163  0.0127
K_K23995  L_L157  L_L164  0.0109
K_K23996  L_L157  L_L165  0.0095
K_K23997  L_L157  L_L166  0.0084
K_K23998  L_L157  L_L167  0.0076
K_K23999  L_L157  L_L168  0.0069
K_K24000  L_L157  L_L169  0.0063
K_K24001  L_L157  L_L170  0.0058
K_K24002  L_L157  L_L171  0.0054
K_K24003  L_L157  L_L172  0.0051
K_K24004  L_L157  L_L173  0.0047
K_K24005  L_L157  L_L174  0.0045
K_K24006  L_L157  L_L175  0.0042
K_K24007  L_L157  L_L176  0.0040
K_K24008  L_L157  L_L177  0.0038
K_K24009  L_L157  L_L178  0.0036
K_K24010  L_L157  L_L179  0.0034
K_K24011  L_L157  L_L180  0.0033
K_K24012  L_L157  L_L181  0.0032
K_K24013  L_L157  L_L182  0.0030
K_K24014  L_L157  L_L183  0.0029
K_K24015  L_L157  L_L184  0.0028
K_K24016  L_L157  L_L185  0.0027
K_K24017  L_L157  L_L186  0.0026
K_K24018  L_L157  L_L187  0.0025
K_K24019  L_L157  L_L188  0.0024
K_K24020  L_L157  L_L189  0.0024
K_K24021  L_L157  L_L190  0.0023
K_K24022  L_L157  L_L191  0.0022
K_K24023  L_L157  L_L192  0.0022
K_K24024  L_L157  L_L193  0.0021
K_K24025  L_L157  L_L194  0.0020
K_K24026  L_L157  L_L195  0.0020
K_K24027  L_L157  L_L196  0.0019
K_K24028  L_L157  L_L197  0.0019
K_K24029  L_L157  L_L198  0.0019
K_K24030  L_L157  L_L199  0.0018
K_K24031  L_L157  L_L200  0.0018
K_K24032  L_L157  L_L201  0.0017
K_K24033  L_L157  L_L202  0.0017
K_K24034  L_L157  L_L203  0.0017
K_K24035  L_L157  L_L204  0.0016
K_K24036  L_L157  L_L205  0.0016
K_K24037  L_L157  L_L206  0.0015
K_K24038  L_L157  L_L207  0.0015
K_K24039  L_L157  L_L208  0.0015
K_K24040  L_L157  L_L209  0.0015
K_K24041  L_L157  L_L210  0.0014
K_K24042  L_L157  L_L211  0.0014
K_K24043  L_L157  L_L212  0.0014
K_K24044  L_L157  L_L213  0.0014
K_K24045  L_L157  L_L214  0.0013
K_K24046  L_L157  L_L215  0.0013
K_K24047  L_L157  L_L216  0.0013
K_K24048  L_L157  L_L217  0.0013
K_K24049  L_L157  L_L218  0.0013
K_K24050  L_L157  L_L219  0.0012
K_K24051  L_L157  L_L220  0.0012
K_K24052  L_L157  L_L221  0.0012
K_K24053  L_L157  L_L222  0.0012
K_K24054  L_L157  L_L223  0.0011
K_K24055  L_L157  L_L224  0.0011
K_K24056  L_L157  L_L225  0.0011
K_K24057  L_L157  L_L226  0.0011
K_K24058  L_L157  L_L227  0.0011
K_K24059  L_L157  L_L228  0.0011
K_K24060  L_L157  L_L229  0.0011
K_K24061  L_L157  L_L230  0.0010
K_K24062  L_L157  L_L231  0.0010
K_K24063  L_L157  L_L232  0.0010
* *  Branch  NTMP0000000157 - NTMP0000000158
R_R158  NTMP0000000157  nU_158  32.914993m  TC=0,0
V_Ui158  nU_158  nR_158  STIMULUS=U_IND_0000000158
R_V315  nR_158  nV_315  23.280268m  TC=0,0
L_V315  nR_158  nV_315  0.014646uH
R_V316  nV_315  nV_316  7.852787m  TC=0,0
L_V316  nV_315  nV_316  0.073723uH
L_L158  nV_316  NTMP0000000158  6.519695uH
K_K24064  L_L158  L_L159  0.1050
K_K24065  L_L158  L_L160  0.0397
K_K24066  L_L158  L_L161  0.0258
K_K24067  L_L158  L_L162  0.0192
K_K24068  L_L158  L_L163  0.0153
K_K24069  L_L158  L_L164  0.0127
K_K24070  L_L158  L_L165  0.0109
K_K24071  L_L158  L_L166  0.0095
K_K24072  L_L158  L_L167  0.0084
K_K24073  L_L158  L_L168  0.0076
K_K24074  L_L158  L_L169  0.0069
K_K24075  L_L158  L_L170  0.0063
K_K24076  L_L158  L_L171  0.0058
K_K24077  L_L158  L_L172  0.0054
K_K24078  L_L158  L_L173  0.0051
K_K24079  L_L158  L_L174  0.0047
K_K24080  L_L158  L_L175  0.0045
K_K24081  L_L158  L_L176  0.0042
K_K24082  L_L158  L_L177  0.0040
K_K24083  L_L158  L_L178  0.0038
K_K24084  L_L158  L_L179  0.0036
K_K24085  L_L158  L_L180  0.0034
K_K24086  L_L158  L_L181  0.0033
K_K24087  L_L158  L_L182  0.0032
K_K24088  L_L158  L_L183  0.0030
K_K24089  L_L158  L_L184  0.0029
K_K24090  L_L158  L_L185  0.0028
K_K24091  L_L158  L_L186  0.0027
K_K24092  L_L158  L_L187  0.0026
K_K24093  L_L158  L_L188  0.0025
K_K24094  L_L158  L_L189  0.0024
K_K24095  L_L158  L_L190  0.0024
K_K24096  L_L158  L_L191  0.0023
K_K24097  L_L158  L_L192  0.0022
K_K24098  L_L158  L_L193  0.0022
K_K24099  L_L158  L_L194  0.0021
K_K24100  L_L158  L_L195  0.0020
K_K24101  L_L158  L_L196  0.0020
K_K24102  L_L158  L_L197  0.0019
K_K24103  L_L158  L_L198  0.0019
K_K24104  L_L158  L_L199  0.0019
K_K24105  L_L158  L_L200  0.0018
K_K24106  L_L158  L_L201  0.0018
K_K24107  L_L158  L_L202  0.0017
K_K24108  L_L158  L_L203  0.0017
K_K24109  L_L158  L_L204  0.0017
K_K24110  L_L158  L_L205  0.0016
K_K24111  L_L158  L_L206  0.0016
K_K24112  L_L158  L_L207  0.0015
K_K24113  L_L158  L_L208  0.0015
K_K24114  L_L158  L_L209  0.0015
K_K24115  L_L158  L_L210  0.0015
K_K24116  L_L158  L_L211  0.0014
K_K24117  L_L158  L_L212  0.0014
K_K24118  L_L158  L_L213  0.0014
K_K24119  L_L158  L_L214  0.0014
K_K24120  L_L158  L_L215  0.0013
K_K24121  L_L158  L_L216  0.0013
K_K24122  L_L158  L_L217  0.0013
K_K24123  L_L158  L_L218  0.0013
K_K24124  L_L158  L_L219  0.0013
K_K24125  L_L158  L_L220  0.0012
K_K24126  L_L158  L_L221  0.0012
K_K24127  L_L158  L_L222  0.0012
K_K24128  L_L158  L_L223  0.0012
K_K24129  L_L158  L_L224  0.0011
K_K24130  L_L158  L_L225  0.0011
K_K24131  L_L158  L_L226  0.0011
K_K24132  L_L158  L_L227  0.0011
K_K24133  L_L158  L_L228  0.0011
K_K24134  L_L158  L_L229  0.0011
K_K24135  L_L158  L_L230  0.0011
K_K24136  L_L158  L_L231  0.0010
K_K24137  L_L158  L_L232  0.0010
K_K24138  L_L158  L_L233  0.0010
* *  Branch  NTMP0000000158 - NTMP0000000159
R_R159  NTMP0000000158  nU_159  32.914993m  TC=0,0
V_Ui159  nU_159  nR_159  STIMULUS=U_IND_0000000159
R_V317  nR_159  nV_317  23.280268m  TC=0,0
L_V317  nR_159  nV_317  0.014646uH
R_V318  nV_317  nV_318  7.852787m  TC=0,0
L_V318  nV_317  nV_318  0.073723uH
L_L159  nV_318  NTMP0000000159  6.519695uH
K_K24139  L_L159  L_L160  0.1050
K_K24140  L_L159  L_L161  0.0397
K_K24141  L_L159  L_L162  0.0258
K_K24142  L_L159  L_L163  0.0192
K_K24143  L_L159  L_L164  0.0153
K_K24144  L_L159  L_L165  0.0127
K_K24145  L_L159  L_L166  0.0109
K_K24146  L_L159  L_L167  0.0095
K_K24147  L_L159  L_L168  0.0084
K_K24148  L_L159  L_L169  0.0076
K_K24149  L_L159  L_L170  0.0069
K_K24150  L_L159  L_L171  0.0063
K_K24151  L_L159  L_L172  0.0058
K_K24152  L_L159  L_L173  0.0054
K_K24153  L_L159  L_L174  0.0051
K_K24154  L_L159  L_L175  0.0047
K_K24155  L_L159  L_L176  0.0045
K_K24156  L_L159  L_L177  0.0042
K_K24157  L_L159  L_L178  0.0040
K_K24158  L_L159  L_L179  0.0038
K_K24159  L_L159  L_L180  0.0036
K_K24160  L_L159  L_L181  0.0034
K_K24161  L_L159  L_L182  0.0033
K_K24162  L_L159  L_L183  0.0032
K_K24163  L_L159  L_L184  0.0030
K_K24164  L_L159  L_L185  0.0029
K_K24165  L_L159  L_L186  0.0028
K_K24166  L_L159  L_L187  0.0027
K_K24167  L_L159  L_L188  0.0026
K_K24168  L_L159  L_L189  0.0025
K_K24169  L_L159  L_L190  0.0024
K_K24170  L_L159  L_L191  0.0024
K_K24171  L_L159  L_L192  0.0023
K_K24172  L_L159  L_L193  0.0022
K_K24173  L_L159  L_L194  0.0022
K_K24174  L_L159  L_L195  0.0021
K_K24175  L_L159  L_L196  0.0020
K_K24176  L_L159  L_L197  0.0020
K_K24177  L_L159  L_L198  0.0019
K_K24178  L_L159  L_L199  0.0019
K_K24179  L_L159  L_L200  0.0019
K_K24180  L_L159  L_L201  0.0018
K_K24181  L_L159  L_L202  0.0018
K_K24182  L_L159  L_L203  0.0017
K_K24183  L_L159  L_L204  0.0017
K_K24184  L_L159  L_L205  0.0017
K_K24185  L_L159  L_L206  0.0016
K_K24186  L_L159  L_L207  0.0016
K_K24187  L_L159  L_L208  0.0015
K_K24188  L_L159  L_L209  0.0015
K_K24189  L_L159  L_L210  0.0015
K_K24190  L_L159  L_L211  0.0015
K_K24191  L_L159  L_L212  0.0014
K_K24192  L_L159  L_L213  0.0014
K_K24193  L_L159  L_L214  0.0014
K_K24194  L_L159  L_L215  0.0014
K_K24195  L_L159  L_L216  0.0013
K_K24196  L_L159  L_L217  0.0013
K_K24197  L_L159  L_L218  0.0013
K_K24198  L_L159  L_L219  0.0013
K_K24199  L_L159  L_L220  0.0013
K_K24200  L_L159  L_L221  0.0012
K_K24201  L_L159  L_L222  0.0012
K_K24202  L_L159  L_L223  0.0012
K_K24203  L_L159  L_L224  0.0012
K_K24204  L_L159  L_L225  0.0011
K_K24205  L_L159  L_L226  0.0011
K_K24206  L_L159  L_L227  0.0011
K_K24207  L_L159  L_L228  0.0011
K_K24208  L_L159  L_L229  0.0011
K_K24209  L_L159  L_L230  0.0011
K_K24210  L_L159  L_L231  0.0011
K_K24211  L_L159  L_L232  0.0010
K_K24212  L_L159  L_L233  0.0010
K_K24213  L_L159  L_L234  0.0010
* *  Branch  NTMP0000000159 - NTMP0000000160
R_R160  NTMP0000000159  nU_160  32.914993m  TC=0,0
V_Ui160  nU_160  nR_160  STIMULUS=U_IND_0000000160
R_V319  nR_160  nV_319  23.280268m  TC=0,0
L_V319  nR_160  nV_319  0.014646uH
R_V320  nV_319  nV_320  7.852787m  TC=0,0
L_V320  nV_319  nV_320  0.073723uH
L_L160  nV_320  NTMP0000000160  6.519695uH
K_K24214  L_L160  L_L161  0.1050
K_K24215  L_L160  L_L162  0.0397
K_K24216  L_L160  L_L163  0.0258
K_K24217  L_L160  L_L164  0.0192
K_K24218  L_L160  L_L165  0.0153
K_K24219  L_L160  L_L166  0.0127
K_K24220  L_L160  L_L167  0.0109
K_K24221  L_L160  L_L168  0.0095
K_K24222  L_L160  L_L169  0.0084
K_K24223  L_L160  L_L170  0.0076
K_K24224  L_L160  L_L171  0.0069
K_K24225  L_L160  L_L172  0.0063
K_K24226  L_L160  L_L173  0.0058
K_K24227  L_L160  L_L174  0.0054
K_K24228  L_L160  L_L175  0.0051
K_K24229  L_L160  L_L176  0.0047
K_K24230  L_L160  L_L177  0.0045
K_K24231  L_L160  L_L178  0.0042
K_K24232  L_L160  L_L179  0.0040
K_K24233  L_L160  L_L180  0.0038
K_K24234  L_L160  L_L181  0.0036
K_K24235  L_L160  L_L182  0.0034
K_K24236  L_L160  L_L183  0.0033
K_K24237  L_L160  L_L184  0.0032
K_K24238  L_L160  L_L185  0.0030
K_K24239  L_L160  L_L186  0.0029
K_K24240  L_L160  L_L187  0.0028
K_K24241  L_L160  L_L188  0.0027
K_K24242  L_L160  L_L189  0.0026
K_K24243  L_L160  L_L190  0.0025
K_K24244  L_L160  L_L191  0.0024
K_K24245  L_L160  L_L192  0.0024
K_K24246  L_L160  L_L193  0.0023
K_K24247  L_L160  L_L194  0.0022
K_K24248  L_L160  L_L195  0.0022
K_K24249  L_L160  L_L196  0.0021
K_K24250  L_L160  L_L197  0.0020
K_K24251  L_L160  L_L198  0.0020
K_K24252  L_L160  L_L199  0.0019
K_K24253  L_L160  L_L200  0.0019
K_K24254  L_L160  L_L201  0.0018
K_K24255  L_L160  L_L202  0.0018
K_K24256  L_L160  L_L203  0.0018
K_K24257  L_L160  L_L204  0.0017
K_K24258  L_L160  L_L205  0.0017
K_K24259  L_L160  L_L206  0.0016
K_K24260  L_L160  L_L207  0.0016
K_K24261  L_L160  L_L208  0.0016
K_K24262  L_L160  L_L209  0.0015
K_K24263  L_L160  L_L210  0.0015
K_K24264  L_L160  L_L211  0.0015
K_K24265  L_L160  L_L212  0.0015
K_K24266  L_L160  L_L213  0.0014
K_K24267  L_L160  L_L214  0.0014
K_K24268  L_L160  L_L215  0.0014
K_K24269  L_L160  L_L216  0.0014
K_K24270  L_L160  L_L217  0.0013
K_K24271  L_L160  L_L218  0.0013
K_K24272  L_L160  L_L219  0.0013
K_K24273  L_L160  L_L220  0.0013
K_K24274  L_L160  L_L221  0.0013
K_K24275  L_L160  L_L222  0.0012
K_K24276  L_L160  L_L223  0.0012
K_K24277  L_L160  L_L224  0.0012
K_K24278  L_L160  L_L225  0.0012
K_K24279  L_L160  L_L226  0.0011
K_K24280  L_L160  L_L227  0.0011
K_K24281  L_L160  L_L228  0.0011
K_K24282  L_L160  L_L229  0.0011
K_K24283  L_L160  L_L230  0.0011
K_K24284  L_L160  L_L231  0.0011
K_K24285  L_L160  L_L232  0.0011
K_K24286  L_L160  L_L233  0.0010
K_K24287  L_L160  L_L234  0.0010
K_K24288  L_L160  L_L235  0.0010
* *  Branch  NTMP0000000160 - NTMP0000000161
R_R161  NTMP0000000160  nU_161  32.914993m  TC=0,0
V_Ui161  nU_161  nR_161  STIMULUS=U_IND_0000000161
R_V321  nR_161  nV_321  23.280268m  TC=0,0
L_V321  nR_161  nV_321  0.014646uH
R_V322  nV_321  nV_322  7.852787m  TC=0,0
L_V322  nV_321  nV_322  0.073723uH
L_L161  nV_322  NTMP0000000161  6.519695uH
K_K24289  L_L161  L_L162  0.1050
K_K24290  L_L161  L_L163  0.0397
K_K24291  L_L161  L_L164  0.0258
K_K24292  L_L161  L_L165  0.0192
K_K24293  L_L161  L_L166  0.0153
K_K24294  L_L161  L_L167  0.0127
K_K24295  L_L161  L_L168  0.0109
K_K24296  L_L161  L_L169  0.0095
K_K24297  L_L161  L_L170  0.0084
K_K24298  L_L161  L_L171  0.0076
K_K24299  L_L161  L_L172  0.0069
K_K24300  L_L161  L_L173  0.0063
K_K24301  L_L161  L_L174  0.0058
K_K24302  L_L161  L_L175  0.0054
K_K24303  L_L161  L_L176  0.0051
K_K24304  L_L161  L_L177  0.0047
K_K24305  L_L161  L_L178  0.0045
K_K24306  L_L161  L_L179  0.0042
K_K24307  L_L161  L_L180  0.0040
K_K24308  L_L161  L_L181  0.0038
K_K24309  L_L161  L_L182  0.0036
K_K24310  L_L161  L_L183  0.0034
K_K24311  L_L161  L_L184  0.0033
K_K24312  L_L161  L_L185  0.0032
K_K24313  L_L161  L_L186  0.0030
K_K24314  L_L161  L_L187  0.0029
K_K24315  L_L161  L_L188  0.0028
K_K24316  L_L161  L_L189  0.0027
K_K24317  L_L161  L_L190  0.0026
K_K24318  L_L161  L_L191  0.0025
K_K24319  L_L161  L_L192  0.0024
K_K24320  L_L161  L_L193  0.0024
K_K24321  L_L161  L_L194  0.0023
K_K24322  L_L161  L_L195  0.0022
K_K24323  L_L161  L_L196  0.0022
K_K24324  L_L161  L_L197  0.0021
K_K24325  L_L161  L_L198  0.0020
K_K24326  L_L161  L_L199  0.0020
K_K24327  L_L161  L_L200  0.0019
K_K24328  L_L161  L_L201  0.0019
K_K24329  L_L161  L_L202  0.0018
K_K24330  L_L161  L_L203  0.0018
K_K24331  L_L161  L_L204  0.0018
K_K24332  L_L161  L_L205  0.0017
K_K24333  L_L161  L_L206  0.0017
K_K24334  L_L161  L_L207  0.0016
K_K24335  L_L161  L_L208  0.0016
K_K24336  L_L161  L_L209  0.0016
K_K24337  L_L161  L_L210  0.0016
K_K24338  L_L161  L_L211  0.0015
K_K24339  L_L161  L_L212  0.0015
K_K24340  L_L161  L_L213  0.0015
K_K24341  L_L161  L_L214  0.0014
K_K24342  L_L161  L_L215  0.0014
K_K24343  L_L161  L_L216  0.0014
K_K24344  L_L161  L_L217  0.0014
K_K24345  L_L161  L_L218  0.0013
K_K24346  L_L161  L_L219  0.0013
K_K24347  L_L161  L_L220  0.0013
K_K24348  L_L161  L_L221  0.0013
K_K24349  L_L161  L_L222  0.0013
K_K24350  L_L161  L_L223  0.0012
K_K24351  L_L161  L_L224  0.0012
K_K24352  L_L161  L_L225  0.0012
K_K24353  L_L161  L_L226  0.0012
K_K24354  L_L161  L_L227  0.0011
K_K24355  L_L161  L_L228  0.0011
K_K24356  L_L161  L_L229  0.0011
K_K24357  L_L161  L_L230  0.0011
K_K24358  L_L161  L_L231  0.0011
K_K24359  L_L161  L_L232  0.0011
K_K24360  L_L161  L_L233  0.0011
K_K24361  L_L161  L_L234  0.0010
K_K24362  L_L161  L_L235  0.0010
K_K24363  L_L161  L_L236  0.0010
* *  Branch  NTMP0000000161 - NTMP0000000162
R_R162  NTMP0000000161  nU_162  32.914993m  TC=0,0
V_Ui162  nU_162  nR_162  STIMULUS=U_IND_0000000162
R_V323  nR_162  nV_323  23.280268m  TC=0,0
L_V323  nR_162  nV_323  0.014646uH
R_V324  nV_323  nV_324  7.852787m  TC=0,0
L_V324  nV_323  nV_324  0.073723uH
L_L162  nV_324  NTMP0000000162  6.519695uH
K_K24364  L_L162  L_L163  0.1050
K_K24365  L_L162  L_L164  0.0397
K_K24366  L_L162  L_L165  0.0258
K_K24367  L_L162  L_L166  0.0192
K_K24368  L_L162  L_L167  0.0153
K_K24369  L_L162  L_L168  0.0127
K_K24370  L_L162  L_L169  0.0109
K_K24371  L_L162  L_L170  0.0095
K_K24372  L_L162  L_L171  0.0084
K_K24373  L_L162  L_L172  0.0076
K_K24374  L_L162  L_L173  0.0069
K_K24375  L_L162  L_L174  0.0063
K_K24376  L_L162  L_L175  0.0058
K_K24377  L_L162  L_L176  0.0054
K_K24378  L_L162  L_L177  0.0051
K_K24379  L_L162  L_L178  0.0047
K_K24380  L_L162  L_L179  0.0045
K_K24381  L_L162  L_L180  0.0042
K_K24382  L_L162  L_L181  0.0040
K_K24383  L_L162  L_L182  0.0038
K_K24384  L_L162  L_L183  0.0036
K_K24385  L_L162  L_L184  0.0034
K_K24386  L_L162  L_L185  0.0033
K_K24387  L_L162  L_L186  0.0032
K_K24388  L_L162  L_L187  0.0030
K_K24389  L_L162  L_L188  0.0029
K_K24390  L_L162  L_L189  0.0028
K_K24391  L_L162  L_L190  0.0027
K_K24392  L_L162  L_L191  0.0026
K_K24393  L_L162  L_L192  0.0025
K_K24394  L_L162  L_L193  0.0024
K_K24395  L_L162  L_L194  0.0024
K_K24396  L_L162  L_L195  0.0023
K_K24397  L_L162  L_L196  0.0022
K_K24398  L_L162  L_L197  0.0022
K_K24399  L_L162  L_L198  0.0021
K_K24400  L_L162  L_L199  0.0020
K_K24401  L_L162  L_L200  0.0020
K_K24402  L_L162  L_L201  0.0019
K_K24403  L_L162  L_L202  0.0019
K_K24404  L_L162  L_L203  0.0018
K_K24405  L_L162  L_L204  0.0018
K_K24406  L_L162  L_L205  0.0018
K_K24407  L_L162  L_L206  0.0017
K_K24408  L_L162  L_L207  0.0017
K_K24409  L_L162  L_L208  0.0016
K_K24410  L_L162  L_L209  0.0016
K_K24411  L_L162  L_L210  0.0016
K_K24412  L_L162  L_L211  0.0016
K_K24413  L_L162  L_L212  0.0015
K_K24414  L_L162  L_L213  0.0015
K_K24415  L_L162  L_L214  0.0015
K_K24416  L_L162  L_L215  0.0014
K_K24417  L_L162  L_L216  0.0014
K_K24418  L_L162  L_L217  0.0014
K_K24419  L_L162  L_L218  0.0014
K_K24420  L_L162  L_L219  0.0013
K_K24421  L_L162  L_L220  0.0013
K_K24422  L_L162  L_L221  0.0013
K_K24423  L_L162  L_L222  0.0013
K_K24424  L_L162  L_L223  0.0013
K_K24425  L_L162  L_L224  0.0012
K_K24426  L_L162  L_L225  0.0012
K_K24427  L_L162  L_L226  0.0012
K_K24428  L_L162  L_L227  0.0012
K_K24429  L_L162  L_L228  0.0011
K_K24430  L_L162  L_L229  0.0011
K_K24431  L_L162  L_L230  0.0011
K_K24432  L_L162  L_L231  0.0011
K_K24433  L_L162  L_L232  0.0011
K_K24434  L_L162  L_L233  0.0011
K_K24435  L_L162  L_L234  0.0011
K_K24436  L_L162  L_L235  0.0010
K_K24437  L_L162  L_L236  0.0010
K_K24438  L_L162  L_L237  0.0010
* *  Branch  NTMP0000000162 - NTMP0000000163
R_R163  NTMP0000000162  nU_163  32.914993m  TC=0,0
V_Ui163  nU_163  nR_163  STIMULUS=U_IND_0000000163
R_V325  nR_163  nV_325  23.280268m  TC=0,0
L_V325  nR_163  nV_325  0.014646uH
R_V326  nV_325  nV_326  7.852787m  TC=0,0
L_V326  nV_325  nV_326  0.073723uH
L_L163  nV_326  NTMP0000000163  6.519695uH
K_K24439  L_L163  L_L164  0.1050
K_K24440  L_L163  L_L165  0.0397
K_K24441  L_L163  L_L166  0.0258
K_K24442  L_L163  L_L167  0.0192
K_K24443  L_L163  L_L168  0.0153
K_K24444  L_L163  L_L169  0.0127
K_K24445  L_L163  L_L170  0.0109
K_K24446  L_L163  L_L171  0.0095
K_K24447  L_L163  L_L172  0.0084
K_K24448  L_L163  L_L173  0.0076
K_K24449  L_L163  L_L174  0.0069
K_K24450  L_L163  L_L175  0.0063
K_K24451  L_L163  L_L176  0.0058
K_K24452  L_L163  L_L177  0.0054
K_K24453  L_L163  L_L178  0.0051
K_K24454  L_L163  L_L179  0.0047
K_K24455  L_L163  L_L180  0.0045
K_K24456  L_L163  L_L181  0.0042
K_K24457  L_L163  L_L182  0.0040
K_K24458  L_L163  L_L183  0.0038
K_K24459  L_L163  L_L184  0.0036
K_K24460  L_L163  L_L185  0.0034
K_K24461  L_L163  L_L186  0.0033
K_K24462  L_L163  L_L187  0.0032
K_K24463  L_L163  L_L188  0.0030
K_K24464  L_L163  L_L189  0.0029
K_K24465  L_L163  L_L190  0.0028
K_K24466  L_L163  L_L191  0.0027
K_K24467  L_L163  L_L192  0.0026
K_K24468  L_L163  L_L193  0.0025
K_K24469  L_L163  L_L194  0.0024
K_K24470  L_L163  L_L195  0.0024
K_K24471  L_L163  L_L196  0.0023
K_K24472  L_L163  L_L197  0.0022
K_K24473  L_L163  L_L198  0.0022
K_K24474  L_L163  L_L199  0.0021
K_K24475  L_L163  L_L200  0.0020
K_K24476  L_L163  L_L201  0.0020
K_K24477  L_L163  L_L202  0.0019
K_K24478  L_L163  L_L203  0.0019
K_K24479  L_L163  L_L204  0.0018
K_K24480  L_L163  L_L205  0.0018
K_K24481  L_L163  L_L206  0.0018
K_K24482  L_L163  L_L207  0.0017
K_K24483  L_L163  L_L208  0.0017
K_K24484  L_L163  L_L209  0.0016
K_K24485  L_L163  L_L210  0.0016
K_K24486  L_L163  L_L211  0.0016
K_K24487  L_L163  L_L212  0.0016
K_K24488  L_L163  L_L213  0.0015
K_K24489  L_L163  L_L214  0.0015
K_K24490  L_L163  L_L215  0.0015
K_K24491  L_L163  L_L216  0.0014
K_K24492  L_L163  L_L217  0.0014
K_K24493  L_L163  L_L218  0.0014
K_K24494  L_L163  L_L219  0.0014
K_K24495  L_L163  L_L220  0.0013
K_K24496  L_L163  L_L221  0.0013
K_K24497  L_L163  L_L222  0.0013
K_K24498  L_L163  L_L223  0.0013
K_K24499  L_L163  L_L224  0.0013
K_K24500  L_L163  L_L225  0.0012
K_K24501  L_L163  L_L226  0.0012
K_K24502  L_L163  L_L227  0.0012
K_K24503  L_L163  L_L228  0.0012
K_K24504  L_L163  L_L229  0.0011
K_K24505  L_L163  L_L230  0.0011
K_K24506  L_L163  L_L231  0.0011
K_K24507  L_L163  L_L232  0.0011
K_K24508  L_L163  L_L233  0.0011
K_K24509  L_L163  L_L234  0.0011
K_K24510  L_L163  L_L235  0.0011
K_K24511  L_L163  L_L236  0.0010
K_K24512  L_L163  L_L237  0.0010
K_K24513  L_L163  L_L238  0.0010
* *  Branch  NTMP0000000163 - NTMP0000000164
R_R164  NTMP0000000163  nU_164  32.914993m  TC=0,0
V_Ui164  nU_164  nR_164  STIMULUS=U_IND_0000000164
R_V327  nR_164  nV_327  23.280268m  TC=0,0
L_V327  nR_164  nV_327  0.014646uH
R_V328  nV_327  nV_328  7.852787m  TC=0,0
L_V328  nV_327  nV_328  0.073723uH
L_L164  nV_328  NTMP0000000164  6.519695uH
K_K24514  L_L164  L_L165  0.1050
K_K24515  L_L164  L_L166  0.0397
K_K24516  L_L164  L_L167  0.0258
K_K24517  L_L164  L_L168  0.0192
K_K24518  L_L164  L_L169  0.0153
K_K24519  L_L164  L_L170  0.0127
K_K24520  L_L164  L_L171  0.0109
K_K24521  L_L164  L_L172  0.0095
K_K24522  L_L164  L_L173  0.0084
K_K24523  L_L164  L_L174  0.0076
K_K24524  L_L164  L_L175  0.0069
K_K24525  L_L164  L_L176  0.0063
K_K24526  L_L164  L_L177  0.0058
K_K24527  L_L164  L_L178  0.0054
K_K24528  L_L164  L_L179  0.0051
K_K24529  L_L164  L_L180  0.0047
K_K24530  L_L164  L_L181  0.0045
K_K24531  L_L164  L_L182  0.0042
K_K24532  L_L164  L_L183  0.0040
K_K24533  L_L164  L_L184  0.0038
K_K24534  L_L164  L_L185  0.0036
K_K24535  L_L164  L_L186  0.0034
K_K24536  L_L164  L_L187  0.0033
K_K24537  L_L164  L_L188  0.0032
K_K24538  L_L164  L_L189  0.0030
K_K24539  L_L164  L_L190  0.0029
K_K24540  L_L164  L_L191  0.0028
K_K24541  L_L164  L_L192  0.0027
K_K24542  L_L164  L_L193  0.0026
K_K24543  L_L164  L_L194  0.0025
K_K24544  L_L164  L_L195  0.0024
K_K24545  L_L164  L_L196  0.0024
K_K24546  L_L164  L_L197  0.0023
K_K24547  L_L164  L_L198  0.0022
K_K24548  L_L164  L_L199  0.0022
K_K24549  L_L164  L_L200  0.0021
K_K24550  L_L164  L_L201  0.0020
K_K24551  L_L164  L_L202  0.0020
K_K24552  L_L164  L_L203  0.0019
K_K24553  L_L164  L_L204  0.0019
K_K24554  L_L164  L_L205  0.0018
K_K24555  L_L164  L_L206  0.0018
K_K24556  L_L164  L_L207  0.0018
K_K24557  L_L164  L_L208  0.0017
K_K24558  L_L164  L_L209  0.0017
K_K24559  L_L164  L_L210  0.0016
K_K24560  L_L164  L_L211  0.0016
K_K24561  L_L164  L_L212  0.0016
K_K24562  L_L164  L_L213  0.0016
K_K24563  L_L164  L_L214  0.0015
K_K24564  L_L164  L_L215  0.0015
K_K24565  L_L164  L_L216  0.0015
K_K24566  L_L164  L_L217  0.0014
K_K24567  L_L164  L_L218  0.0014
K_K24568  L_L164  L_L219  0.0014
K_K24569  L_L164  L_L220  0.0014
K_K24570  L_L164  L_L221  0.0013
K_K24571  L_L164  L_L222  0.0013
K_K24572  L_L164  L_L223  0.0013
K_K24573  L_L164  L_L224  0.0013
K_K24574  L_L164  L_L225  0.0013
K_K24575  L_L164  L_L226  0.0012
K_K24576  L_L164  L_L227  0.0012
K_K24577  L_L164  L_L228  0.0012
K_K24578  L_L164  L_L229  0.0012
K_K24579  L_L164  L_L230  0.0011
K_K24580  L_L164  L_L231  0.0011
K_K24581  L_L164  L_L232  0.0011
K_K24582  L_L164  L_L233  0.0011
K_K24583  L_L164  L_L234  0.0011
K_K24584  L_L164  L_L235  0.0011
K_K24585  L_L164  L_L236  0.0011
K_K24586  L_L164  L_L237  0.0010
K_K24587  L_L164  L_L238  0.0010
K_K24588  L_L164  L_L239  0.0010
* *  Branch  NTMP0000000164 - NTMP0000000165
R_R165  NTMP0000000164  nU_165  32.914993m  TC=0,0
V_Ui165  nU_165  nR_165  STIMULUS=U_IND_0000000165
R_V329  nR_165  nV_329  23.280268m  TC=0,0
L_V329  nR_165  nV_329  0.014646uH
R_V330  nV_329  nV_330  7.852787m  TC=0,0
L_V330  nV_329  nV_330  0.073723uH
L_L165  nV_330  NTMP0000000165  6.519695uH
K_K24589  L_L165  L_L166  0.1050
K_K24590  L_L165  L_L167  0.0397
K_K24591  L_L165  L_L168  0.0258
K_K24592  L_L165  L_L169  0.0192
K_K24593  L_L165  L_L170  0.0153
K_K24594  L_L165  L_L171  0.0127
K_K24595  L_L165  L_L172  0.0109
K_K24596  L_L165  L_L173  0.0095
K_K24597  L_L165  L_L174  0.0084
K_K24598  L_L165  L_L175  0.0076
K_K24599  L_L165  L_L176  0.0069
K_K24600  L_L165  L_L177  0.0063
K_K24601  L_L165  L_L178  0.0058
K_K24602  L_L165  L_L179  0.0054
K_K24603  L_L165  L_L180  0.0051
K_K24604  L_L165  L_L181  0.0047
K_K24605  L_L165  L_L182  0.0045
K_K24606  L_L165  L_L183  0.0042
K_K24607  L_L165  L_L184  0.0040
K_K24608  L_L165  L_L185  0.0038
K_K24609  L_L165  L_L186  0.0036
K_K24610  L_L165  L_L187  0.0034
K_K24611  L_L165  L_L188  0.0033
K_K24612  L_L165  L_L189  0.0032
K_K24613  L_L165  L_L190  0.0030
K_K24614  L_L165  L_L191  0.0029
K_K24615  L_L165  L_L192  0.0028
K_K24616  L_L165  L_L193  0.0027
K_K24617  L_L165  L_L194  0.0026
K_K24618  L_L165  L_L195  0.0025
K_K24619  L_L165  L_L196  0.0024
K_K24620  L_L165  L_L197  0.0024
K_K24621  L_L165  L_L198  0.0023
K_K24622  L_L165  L_L199  0.0022
K_K24623  L_L165  L_L200  0.0022
K_K24624  L_L165  L_L201  0.0021
K_K24625  L_L165  L_L202  0.0020
K_K24626  L_L165  L_L203  0.0020
K_K24627  L_L165  L_L204  0.0019
K_K24628  L_L165  L_L205  0.0019
K_K24629  L_L165  L_L206  0.0018
K_K24630  L_L165  L_L207  0.0018
K_K24631  L_L165  L_L208  0.0018
K_K24632  L_L165  L_L209  0.0017
K_K24633  L_L165  L_L210  0.0017
K_K24634  L_L165  L_L211  0.0016
K_K24635  L_L165  L_L212  0.0016
K_K24636  L_L165  L_L213  0.0016
K_K24637  L_L165  L_L214  0.0016
K_K24638  L_L165  L_L215  0.0015
K_K24639  L_L165  L_L216  0.0015
K_K24640  L_L165  L_L217  0.0015
K_K24641  L_L165  L_L218  0.0014
K_K24642  L_L165  L_L219  0.0014
K_K24643  L_L165  L_L220  0.0014
K_K24644  L_L165  L_L221  0.0014
K_K24645  L_L165  L_L222  0.0013
K_K24646  L_L165  L_L223  0.0013
K_K24647  L_L165  L_L224  0.0013
K_K24648  L_L165  L_L225  0.0013
K_K24649  L_L165  L_L226  0.0013
K_K24650  L_L165  L_L227  0.0012
K_K24651  L_L165  L_L228  0.0012
K_K24652  L_L165  L_L229  0.0012
K_K24653  L_L165  L_L230  0.0012
K_K24654  L_L165  L_L231  0.0011
K_K24655  L_L165  L_L232  0.0011
K_K24656  L_L165  L_L233  0.0011
K_K24657  L_L165  L_L234  0.0011
K_K24658  L_L165  L_L235  0.0011
K_K24659  L_L165  L_L236  0.0011
K_K24660  L_L165  L_L237  0.0011
K_K24661  L_L165  L_L238  0.0010
K_K24662  L_L165  L_L239  0.0010
K_K24663  L_L165  L_L240  0.0010
* *  Branch  NTMP0000000165 - NTMP0000000166
R_R166  NTMP0000000165  nU_166  32.914993m  TC=0,0
V_Ui166  nU_166  nR_166  STIMULUS=U_IND_0000000166
R_V331  nR_166  nV_331  23.280268m  TC=0,0
L_V331  nR_166  nV_331  0.014646uH
R_V332  nV_331  nV_332  7.852787m  TC=0,0
L_V332  nV_331  nV_332  0.073723uH
L_L166  nV_332  NTMP0000000166  6.519695uH
K_K24664  L_L166  L_L167  0.1050
K_K24665  L_L166  L_L168  0.0397
K_K24666  L_L166  L_L169  0.0258
K_K24667  L_L166  L_L170  0.0192
K_K24668  L_L166  L_L171  0.0153
K_K24669  L_L166  L_L172  0.0127
K_K24670  L_L166  L_L173  0.0109
K_K24671  L_L166  L_L174  0.0095
K_K24672  L_L166  L_L175  0.0084
K_K24673  L_L166  L_L176  0.0076
K_K24674  L_L166  L_L177  0.0069
K_K24675  L_L166  L_L178  0.0063
K_K24676  L_L166  L_L179  0.0058
K_K24677  L_L166  L_L180  0.0054
K_K24678  L_L166  L_L181  0.0051
K_K24679  L_L166  L_L182  0.0047
K_K24680  L_L166  L_L183  0.0045
K_K24681  L_L166  L_L184  0.0042
K_K24682  L_L166  L_L185  0.0040
K_K24683  L_L166  L_L186  0.0038
K_K24684  L_L166  L_L187  0.0036
K_K24685  L_L166  L_L188  0.0034
K_K24686  L_L166  L_L189  0.0033
K_K24687  L_L166  L_L190  0.0032
K_K24688  L_L166  L_L191  0.0030
K_K24689  L_L166  L_L192  0.0029
K_K24690  L_L166  L_L193  0.0028
K_K24691  L_L166  L_L194  0.0027
K_K24692  L_L166  L_L195  0.0026
K_K24693  L_L166  L_L196  0.0025
K_K24694  L_L166  L_L197  0.0024
K_K24695  L_L166  L_L198  0.0024
K_K24696  L_L166  L_L199  0.0023
K_K24697  L_L166  L_L200  0.0022
K_K24698  L_L166  L_L201  0.0022
K_K24699  L_L166  L_L202  0.0021
K_K24700  L_L166  L_L203  0.0020
K_K24701  L_L166  L_L204  0.0020
K_K24702  L_L166  L_L205  0.0019
K_K24703  L_L166  L_L206  0.0019
K_K24704  L_L166  L_L207  0.0018
K_K24705  L_L166  L_L208  0.0018
K_K24706  L_L166  L_L209  0.0018
K_K24707  L_L166  L_L210  0.0017
K_K24708  L_L166  L_L211  0.0017
K_K24709  L_L166  L_L212  0.0016
K_K24710  L_L166  L_L213  0.0016
K_K24711  L_L166  L_L214  0.0016
K_K24712  L_L166  L_L215  0.0015
K_K24713  L_L166  L_L216  0.0015
K_K24714  L_L166  L_L217  0.0015
K_K24715  L_L166  L_L218  0.0015
K_K24716  L_L166  L_L219  0.0014
K_K24717  L_L166  L_L220  0.0014
K_K24718  L_L166  L_L221  0.0014
K_K24719  L_L166  L_L222  0.0014
K_K24720  L_L166  L_L223  0.0013
K_K24721  L_L166  L_L224  0.0013
K_K24722  L_L166  L_L225  0.0013
K_K24723  L_L166  L_L226  0.0013
K_K24724  L_L166  L_L227  0.0013
K_K24725  L_L166  L_L228  0.0012
K_K24726  L_L166  L_L229  0.0012
K_K24727  L_L166  L_L230  0.0012
K_K24728  L_L166  L_L231  0.0012
K_K24729  L_L166  L_L232  0.0011
K_K24730  L_L166  L_L233  0.0011
K_K24731  L_L166  L_L234  0.0011
K_K24732  L_L166  L_L235  0.0011
K_K24733  L_L166  L_L236  0.0011
K_K24734  L_L166  L_L237  0.0011
K_K24735  L_L166  L_L238  0.0011
K_K24736  L_L166  L_L239  0.0010
K_K24737  L_L166  L_L240  0.0010
K_K24738  L_L166  L_L241  0.0010
* *  Branch  NTMP0000000166 - NTMP0000000167
R_R167  NTMP0000000166  nU_167  32.914993m  TC=0,0
V_Ui167  nU_167  nR_167  STIMULUS=U_IND_0000000167
R_V333  nR_167  nV_333  23.280268m  TC=0,0
L_V333  nR_167  nV_333  0.014646uH
R_V334  nV_333  nV_334  7.852787m  TC=0,0
L_V334  nV_333  nV_334  0.073723uH
L_L167  nV_334  NTMP0000000167  6.519695uH
K_K24739  L_L167  L_L168  0.1050
K_K24740  L_L167  L_L169  0.0397
K_K24741  L_L167  L_L170  0.0258
K_K24742  L_L167  L_L171  0.0192
K_K24743  L_L167  L_L172  0.0153
K_K24744  L_L167  L_L173  0.0127
K_K24745  L_L167  L_L174  0.0109
K_K24746  L_L167  L_L175  0.0095
K_K24747  L_L167  L_L176  0.0084
K_K24748  L_L167  L_L177  0.0076
K_K24749  L_L167  L_L178  0.0069
K_K24750  L_L167  L_L179  0.0063
K_K24751  L_L167  L_L180  0.0058
K_K24752  L_L167  L_L181  0.0054
K_K24753  L_L167  L_L182  0.0051
K_K24754  L_L167  L_L183  0.0047
K_K24755  L_L167  L_L184  0.0045
K_K24756  L_L167  L_L185  0.0042
K_K24757  L_L167  L_L186  0.0040
K_K24758  L_L167  L_L187  0.0038
K_K24759  L_L167  L_L188  0.0036
K_K24760  L_L167  L_L189  0.0034
K_K24761  L_L167  L_L190  0.0033
K_K24762  L_L167  L_L191  0.0032
K_K24763  L_L167  L_L192  0.0030
K_K24764  L_L167  L_L193  0.0029
K_K24765  L_L167  L_L194  0.0028
K_K24766  L_L167  L_L195  0.0027
K_K24767  L_L167  L_L196  0.0026
K_K24768  L_L167  L_L197  0.0025
K_K24769  L_L167  L_L198  0.0024
K_K24770  L_L167  L_L199  0.0024
K_K24771  L_L167  L_L200  0.0023
K_K24772  L_L167  L_L201  0.0022
K_K24773  L_L167  L_L202  0.0022
K_K24774  L_L167  L_L203  0.0021
K_K24775  L_L167  L_L204  0.0020
K_K24776  L_L167  L_L205  0.0020
K_K24777  L_L167  L_L206  0.0019
K_K24778  L_L167  L_L207  0.0019
K_K24779  L_L167  L_L208  0.0019
K_K24780  L_L167  L_L209  0.0018
K_K24781  L_L167  L_L210  0.0018
K_K24782  L_L167  L_L211  0.0017
K_K24783  L_L167  L_L212  0.0017
K_K24784  L_L167  L_L213  0.0017
K_K24785  L_L167  L_L214  0.0016
K_K24786  L_L167  L_L215  0.0016
K_K24787  L_L167  L_L216  0.0015
K_K24788  L_L167  L_L217  0.0015
K_K24789  L_L167  L_L218  0.0015
K_K24790  L_L167  L_L219  0.0015
K_K24791  L_L167  L_L220  0.0014
K_K24792  L_L167  L_L221  0.0014
K_K24793  L_L167  L_L222  0.0014
K_K24794  L_L167  L_L223  0.0014
K_K24795  L_L167  L_L224  0.0013
K_K24796  L_L167  L_L225  0.0013
K_K24797  L_L167  L_L226  0.0013
K_K24798  L_L167  L_L227  0.0013
K_K24799  L_L167  L_L228  0.0013
K_K24800  L_L167  L_L229  0.0012
K_K24801  L_L167  L_L230  0.0012
K_K24802  L_L167  L_L231  0.0012
K_K24803  L_L167  L_L232  0.0012
K_K24804  L_L167  L_L233  0.0011
K_K24805  L_L167  L_L234  0.0011
K_K24806  L_L167  L_L235  0.0011
K_K24807  L_L167  L_L236  0.0011
K_K24808  L_L167  L_L237  0.0011
K_K24809  L_L167  L_L238  0.0011
K_K24810  L_L167  L_L239  0.0011
K_K24811  L_L167  L_L240  0.0010
K_K24812  L_L167  L_L241  0.0010
K_K24813  L_L167  L_L242  0.0010
* *  Branch  NTMP0000000167 - NTMP0000000168
R_R168  NTMP0000000167  nU_168  32.914993m  TC=0,0
V_Ui168  nU_168  nR_168  STIMULUS=U_IND_0000000168
R_V335  nR_168  nV_335  23.280268m  TC=0,0
L_V335  nR_168  nV_335  0.014646uH
R_V336  nV_335  nV_336  7.852787m  TC=0,0
L_V336  nV_335  nV_336  0.073723uH
L_L168  nV_336  NTMP0000000168  6.519695uH
K_K24814  L_L168  L_L169  0.1050
K_K24815  L_L168  L_L170  0.0397
K_K24816  L_L168  L_L171  0.0258
K_K24817  L_L168  L_L172  0.0192
K_K24818  L_L168  L_L173  0.0153
K_K24819  L_L168  L_L174  0.0127
K_K24820  L_L168  L_L175  0.0109
K_K24821  L_L168  L_L176  0.0095
K_K24822  L_L168  L_L177  0.0084
K_K24823  L_L168  L_L178  0.0076
K_K24824  L_L168  L_L179  0.0069
K_K24825  L_L168  L_L180  0.0063
K_K24826  L_L168  L_L181  0.0058
K_K24827  L_L168  L_L182  0.0054
K_K24828  L_L168  L_L183  0.0051
K_K24829  L_L168  L_L184  0.0047
K_K24830  L_L168  L_L185  0.0045
K_K24831  L_L168  L_L186  0.0042
K_K24832  L_L168  L_L187  0.0040
K_K24833  L_L168  L_L188  0.0038
K_K24834  L_L168  L_L189  0.0036
K_K24835  L_L168  L_L190  0.0034
K_K24836  L_L168  L_L191  0.0033
K_K24837  L_L168  L_L192  0.0032
K_K24838  L_L168  L_L193  0.0030
K_K24839  L_L168  L_L194  0.0029
K_K24840  L_L168  L_L195  0.0028
K_K24841  L_L168  L_L196  0.0027
K_K24842  L_L168  L_L197  0.0026
K_K24843  L_L168  L_L198  0.0025
K_K24844  L_L168  L_L199  0.0024
K_K24845  L_L168  L_L200  0.0024
K_K24846  L_L168  L_L201  0.0023
K_K24847  L_L168  L_L202  0.0022
K_K24848  L_L168  L_L203  0.0022
K_K24849  L_L168  L_L204  0.0021
K_K24850  L_L168  L_L205  0.0020
K_K24851  L_L168  L_L206  0.0020
K_K24852  L_L168  L_L207  0.0019
K_K24853  L_L168  L_L208  0.0019
K_K24854  L_L168  L_L209  0.0019
K_K24855  L_L168  L_L210  0.0018
K_K24856  L_L168  L_L211  0.0018
K_K24857  L_L168  L_L212  0.0017
K_K24858  L_L168  L_L213  0.0017
K_K24859  L_L168  L_L214  0.0017
K_K24860  L_L168  L_L215  0.0016
K_K24861  L_L168  L_L216  0.0016
K_K24862  L_L168  L_L217  0.0015
K_K24863  L_L168  L_L218  0.0015
K_K24864  L_L168  L_L219  0.0015
K_K24865  L_L168  L_L220  0.0015
K_K24866  L_L168  L_L221  0.0014
K_K24867  L_L168  L_L222  0.0014
K_K24868  L_L168  L_L223  0.0014
K_K24869  L_L168  L_L224  0.0014
K_K24870  L_L168  L_L225  0.0013
K_K24871  L_L168  L_L226  0.0013
K_K24872  L_L168  L_L227  0.0013
K_K24873  L_L168  L_L228  0.0013
K_K24874  L_L168  L_L229  0.0013
K_K24875  L_L168  L_L230  0.0012
K_K24876  L_L168  L_L231  0.0012
K_K24877  L_L168  L_L232  0.0012
K_K24878  L_L168  L_L233  0.0012
K_K24879  L_L168  L_L234  0.0011
K_K24880  L_L168  L_L235  0.0011
K_K24881  L_L168  L_L236  0.0011
K_K24882  L_L168  L_L237  0.0011
K_K24883  L_L168  L_L238  0.0011
K_K24884  L_L168  L_L239  0.0011
K_K24885  L_L168  L_L240  0.0011
K_K24886  L_L168  L_L241  0.0010
K_K24887  L_L168  L_L242  0.0010
K_K24888  L_L168  L_L243  0.0010
* *  Branch  NTMP0000000168 - NTMP0000000169
R_R169  NTMP0000000168  nU_169  32.914993m  TC=0,0
V_Ui169  nU_169  nR_169  STIMULUS=U_IND_0000000169
R_V337  nR_169  nV_337  23.280268m  TC=0,0
L_V337  nR_169  nV_337  0.014646uH
R_V338  nV_337  nV_338  7.852787m  TC=0,0
L_V338  nV_337  nV_338  0.073723uH
L_L169  nV_338  NTMP0000000169  6.519695uH
K_K24889  L_L169  L_L170  0.1050
K_K24890  L_L169  L_L171  0.0397
K_K24891  L_L169  L_L172  0.0258
K_K24892  L_L169  L_L173  0.0192
K_K24893  L_L169  L_L174  0.0153
K_K24894  L_L169  L_L175  0.0127
K_K24895  L_L169  L_L176  0.0109
K_K24896  L_L169  L_L177  0.0095
K_K24897  L_L169  L_L178  0.0084
K_K24898  L_L169  L_L179  0.0076
K_K24899  L_L169  L_L180  0.0069
K_K24900  L_L169  L_L181  0.0063
K_K24901  L_L169  L_L182  0.0058
K_K24902  L_L169  L_L183  0.0054
K_K24903  L_L169  L_L184  0.0051
K_K24904  L_L169  L_L185  0.0047
K_K24905  L_L169  L_L186  0.0045
K_K24906  L_L169  L_L187  0.0042
K_K24907  L_L169  L_L188  0.0040
K_K24908  L_L169  L_L189  0.0038
K_K24909  L_L169  L_L190  0.0036
K_K24910  L_L169  L_L191  0.0034
K_K24911  L_L169  L_L192  0.0033
K_K24912  L_L169  L_L193  0.0032
K_K24913  L_L169  L_L194  0.0030
K_K24914  L_L169  L_L195  0.0029
K_K24915  L_L169  L_L196  0.0028
K_K24916  L_L169  L_L197  0.0027
K_K24917  L_L169  L_L198  0.0026
K_K24918  L_L169  L_L199  0.0025
K_K24919  L_L169  L_L200  0.0024
K_K24920  L_L169  L_L201  0.0024
K_K24921  L_L169  L_L202  0.0023
K_K24922  L_L169  L_L203  0.0022
K_K24923  L_L169  L_L204  0.0022
K_K24924  L_L169  L_L205  0.0021
K_K24925  L_L169  L_L206  0.0020
K_K24926  L_L169  L_L207  0.0020
K_K24927  L_L169  L_L208  0.0019
K_K24928  L_L169  L_L209  0.0019
K_K24929  L_L169  L_L210  0.0019
K_K24930  L_L169  L_L211  0.0018
K_K24931  L_L169  L_L212  0.0018
K_K24932  L_L169  L_L213  0.0017
K_K24933  L_L169  L_L214  0.0017
K_K24934  L_L169  L_L215  0.0017
K_K24935  L_L169  L_L216  0.0016
K_K24936  L_L169  L_L217  0.0016
K_K24937  L_L169  L_L218  0.0015
K_K24938  L_L169  L_L219  0.0015
K_K24939  L_L169  L_L220  0.0015
K_K24940  L_L169  L_L221  0.0015
K_K24941  L_L169  L_L222  0.0014
K_K24942  L_L169  L_L223  0.0014
K_K24943  L_L169  L_L224  0.0014
K_K24944  L_L169  L_L225  0.0014
K_K24945  L_L169  L_L226  0.0013
K_K24946  L_L169  L_L227  0.0013
K_K24947  L_L169  L_L228  0.0013
K_K24948  L_L169  L_L229  0.0013
K_K24949  L_L169  L_L230  0.0013
K_K24950  L_L169  L_L231  0.0012
K_K24951  L_L169  L_L232  0.0012
K_K24952  L_L169  L_L233  0.0012
K_K24953  L_L169  L_L234  0.0012
K_K24954  L_L169  L_L235  0.0011
K_K24955  L_L169  L_L236  0.0011
K_K24956  L_L169  L_L237  0.0011
K_K24957  L_L169  L_L238  0.0011
K_K24958  L_L169  L_L239  0.0011
K_K24959  L_L169  L_L240  0.0011
K_K24960  L_L169  L_L241  0.0011
K_K24961  L_L169  L_L242  0.0010
K_K24962  L_L169  L_L243  0.0010
K_K24963  L_L169  L_L244  0.0010
* *  Branch  NTMP0000000169 - NTMP0000000170
R_R170  NTMP0000000169  nU_170  32.914993m  TC=0,0
V_Ui170  nU_170  nR_170  STIMULUS=U_IND_0000000170
R_V339  nR_170  nV_339  23.280268m  TC=0,0
L_V339  nR_170  nV_339  0.014646uH
R_V340  nV_339  nV_340  7.852787m  TC=0,0
L_V340  nV_339  nV_340  0.073723uH
L_L170  nV_340  NTMP0000000170  6.519695uH
K_K24964  L_L170  L_L171  0.1050
K_K24965  L_L170  L_L172  0.0397
K_K24966  L_L170  L_L173  0.0258
K_K24967  L_L170  L_L174  0.0192
K_K24968  L_L170  L_L175  0.0153
K_K24969  L_L170  L_L176  0.0127
K_K24970  L_L170  L_L177  0.0109
K_K24971  L_L170  L_L178  0.0095
K_K24972  L_L170  L_L179  0.0084
K_K24973  L_L170  L_L180  0.0076
K_K24974  L_L170  L_L181  0.0069
K_K24975  L_L170  L_L182  0.0063
K_K24976  L_L170  L_L183  0.0058
K_K24977  L_L170  L_L184  0.0054
K_K24978  L_L170  L_L185  0.0051
K_K24979  L_L170  L_L186  0.0047
K_K24980  L_L170  L_L187  0.0045
K_K24981  L_L170  L_L188  0.0042
K_K24982  L_L170  L_L189  0.0040
K_K24983  L_L170  L_L190  0.0038
K_K24984  L_L170  L_L191  0.0036
K_K24985  L_L170  L_L192  0.0034
K_K24986  L_L170  L_L193  0.0033
K_K24987  L_L170  L_L194  0.0032
K_K24988  L_L170  L_L195  0.0030
K_K24989  L_L170  L_L196  0.0029
K_K24990  L_L170  L_L197  0.0028
K_K24991  L_L170  L_L198  0.0027
K_K24992  L_L170  L_L199  0.0026
K_K24993  L_L170  L_L200  0.0025
K_K24994  L_L170  L_L201  0.0024
K_K24995  L_L170  L_L202  0.0024
K_K24996  L_L170  L_L203  0.0023
K_K24997  L_L170  L_L204  0.0022
K_K24998  L_L170  L_L205  0.0022
K_K24999  L_L170  L_L206  0.0021
K_K25000  L_L170  L_L207  0.0020
K_K25001  L_L170  L_L208  0.0020
K_K25002  L_L170  L_L209  0.0019
K_K25003  L_L170  L_L210  0.0019
K_K25004  L_L170  L_L211  0.0019
K_K25005  L_L170  L_L212  0.0018
K_K25006  L_L170  L_L213  0.0018
K_K25007  L_L170  L_L214  0.0017
K_K25008  L_L170  L_L215  0.0017
K_K25009  L_L170  L_L216  0.0017
K_K25010  L_L170  L_L217  0.0016
K_K25011  L_L170  L_L218  0.0016
K_K25012  L_L170  L_L219  0.0015
K_K25013  L_L170  L_L220  0.0015
K_K25014  L_L170  L_L221  0.0015
K_K25015  L_L170  L_L222  0.0015
K_K25016  L_L170  L_L223  0.0014
K_K25017  L_L170  L_L224  0.0014
K_K25018  L_L170  L_L225  0.0014
K_K25019  L_L170  L_L226  0.0014
K_K25020  L_L170  L_L227  0.0013
K_K25021  L_L170  L_L228  0.0013
K_K25022  L_L170  L_L229  0.0013
K_K25023  L_L170  L_L230  0.0013
K_K25024  L_L170  L_L231  0.0013
K_K25025  L_L170  L_L232  0.0012
K_K25026  L_L170  L_L233  0.0012
K_K25027  L_L170  L_L234  0.0012
K_K25028  L_L170  L_L235  0.0012
K_K25029  L_L170  L_L236  0.0011
K_K25030  L_L170  L_L237  0.0011
K_K25031  L_L170  L_L238  0.0011
K_K25032  L_L170  L_L239  0.0011
K_K25033  L_L170  L_L240  0.0011
K_K25034  L_L170  L_L241  0.0011
K_K25035  L_L170  L_L242  0.0011
K_K25036  L_L170  L_L243  0.0010
K_K25037  L_L170  L_L244  0.0010
K_K25038  L_L170  L_L245  0.0010
* *  Branch  NTMP0000000170 - NTMP0000000171
R_R171  NTMP0000000170  nU_171  32.914993m  TC=0,0
V_Ui171  nU_171  nR_171  STIMULUS=U_IND_0000000171
R_V341  nR_171  nV_341  23.280268m  TC=0,0
L_V341  nR_171  nV_341  0.014646uH
R_V342  nV_341  nV_342  7.852787m  TC=0,0
L_V342  nV_341  nV_342  0.073723uH
L_L171  nV_342  NTMP0000000171  6.519695uH
K_K25039  L_L171  L_L172  0.1050
K_K25040  L_L171  L_L173  0.0397
K_K25041  L_L171  L_L174  0.0258
K_K25042  L_L171  L_L175  0.0192
K_K25043  L_L171  L_L176  0.0153
K_K25044  L_L171  L_L177  0.0127
K_K25045  L_L171  L_L178  0.0109
K_K25046  L_L171  L_L179  0.0095
K_K25047  L_L171  L_L180  0.0084
K_K25048  L_L171  L_L181  0.0076
K_K25049  L_L171  L_L182  0.0069
K_K25050  L_L171  L_L183  0.0063
K_K25051  L_L171  L_L184  0.0058
K_K25052  L_L171  L_L185  0.0054
K_K25053  L_L171  L_L186  0.0051
K_K25054  L_L171  L_L187  0.0047
K_K25055  L_L171  L_L188  0.0045
K_K25056  L_L171  L_L189  0.0042
K_K25057  L_L171  L_L190  0.0040
K_K25058  L_L171  L_L191  0.0038
K_K25059  L_L171  L_L192  0.0036
K_K25060  L_L171  L_L193  0.0034
K_K25061  L_L171  L_L194  0.0033
K_K25062  L_L171  L_L195  0.0032
K_K25063  L_L171  L_L196  0.0030
K_K25064  L_L171  L_L197  0.0029
K_K25065  L_L171  L_L198  0.0028
K_K25066  L_L171  L_L199  0.0027
K_K25067  L_L171  L_L200  0.0026
K_K25068  L_L171  L_L201  0.0025
K_K25069  L_L171  L_L202  0.0024
K_K25070  L_L171  L_L203  0.0024
K_K25071  L_L171  L_L204  0.0023
K_K25072  L_L171  L_L205  0.0022
K_K25073  L_L171  L_L206  0.0022
K_K25074  L_L171  L_L207  0.0021
K_K25075  L_L171  L_L208  0.0020
K_K25076  L_L171  L_L209  0.0020
K_K25077  L_L171  L_L210  0.0019
K_K25078  L_L171  L_L211  0.0019
K_K25079  L_L171  L_L212  0.0019
K_K25080  L_L171  L_L213  0.0018
K_K25081  L_L171  L_L214  0.0018
K_K25082  L_L171  L_L215  0.0017
K_K25083  L_L171  L_L216  0.0017
K_K25084  L_L171  L_L217  0.0017
K_K25085  L_L171  L_L218  0.0016
K_K25086  L_L171  L_L219  0.0016
K_K25087  L_L171  L_L220  0.0015
K_K25088  L_L171  L_L221  0.0015
K_K25089  L_L171  L_L222  0.0015
K_K25090  L_L171  L_L223  0.0015
K_K25091  L_L171  L_L224  0.0014
K_K25092  L_L171  L_L225  0.0014
K_K25093  L_L171  L_L226  0.0014
K_K25094  L_L171  L_L227  0.0014
K_K25095  L_L171  L_L228  0.0013
K_K25096  L_L171  L_L229  0.0013
K_K25097  L_L171  L_L230  0.0013
K_K25098  L_L171  L_L231  0.0013
K_K25099  L_L171  L_L232  0.0013
K_K25100  L_L171  L_L233  0.0012
K_K25101  L_L171  L_L234  0.0012
K_K25102  L_L171  L_L235  0.0012
K_K25103  L_L171  L_L236  0.0012
K_K25104  L_L171  L_L237  0.0011
K_K25105  L_L171  L_L238  0.0011
K_K25106  L_L171  L_L239  0.0011
K_K25107  L_L171  L_L240  0.0011
K_K25108  L_L171  L_L241  0.0011
K_K25109  L_L171  L_L242  0.0011
K_K25110  L_L171  L_L243  0.0011
K_K25111  L_L171  L_L244  0.0010
K_K25112  L_L171  L_L245  0.0010
K_K25113  L_L171  L_L246  0.0010
* *  Branch  NTMP0000000171 - NTMP0000000172
R_R172  NTMP0000000171  nU_172  32.914993m  TC=0,0
V_Ui172  nU_172  nR_172  STIMULUS=U_IND_0000000172
R_V343  nR_172  nV_343  23.280268m  TC=0,0
L_V343  nR_172  nV_343  0.014646uH
R_V344  nV_343  nV_344  7.852787m  TC=0,0
L_V344  nV_343  nV_344  0.073723uH
L_L172  nV_344  NTMP0000000172  6.519695uH
K_K25114  L_L172  L_L173  0.1050
K_K25115  L_L172  L_L174  0.0397
K_K25116  L_L172  L_L175  0.0258
K_K25117  L_L172  L_L176  0.0192
K_K25118  L_L172  L_L177  0.0153
K_K25119  L_L172  L_L178  0.0127
K_K25120  L_L172  L_L179  0.0109
K_K25121  L_L172  L_L180  0.0095
K_K25122  L_L172  L_L181  0.0084
K_K25123  L_L172  L_L182  0.0076
K_K25124  L_L172  L_L183  0.0069
K_K25125  L_L172  L_L184  0.0063
K_K25126  L_L172  L_L185  0.0058
K_K25127  L_L172  L_L186  0.0054
K_K25128  L_L172  L_L187  0.0051
K_K25129  L_L172  L_L188  0.0047
K_K25130  L_L172  L_L189  0.0045
K_K25131  L_L172  L_L190  0.0042
K_K25132  L_L172  L_L191  0.0040
K_K25133  L_L172  L_L192  0.0038
K_K25134  L_L172  L_L193  0.0036
K_K25135  L_L172  L_L194  0.0034
K_K25136  L_L172  L_L195  0.0033
K_K25137  L_L172  L_L196  0.0032
K_K25138  L_L172  L_L197  0.0030
K_K25139  L_L172  L_L198  0.0029
K_K25140  L_L172  L_L199  0.0028
K_K25141  L_L172  L_L200  0.0027
K_K25142  L_L172  L_L201  0.0026
K_K25143  L_L172  L_L202  0.0025
K_K25144  L_L172  L_L203  0.0024
K_K25145  L_L172  L_L204  0.0024
K_K25146  L_L172  L_L205  0.0023
K_K25147  L_L172  L_L206  0.0022
K_K25148  L_L172  L_L207  0.0022
K_K25149  L_L172  L_L208  0.0021
K_K25150  L_L172  L_L209  0.0020
K_K25151  L_L172  L_L210  0.0020
K_K25152  L_L172  L_L211  0.0019
K_K25153  L_L172  L_L212  0.0019
K_K25154  L_L172  L_L213  0.0019
K_K25155  L_L172  L_L214  0.0018
K_K25156  L_L172  L_L215  0.0018
K_K25157  L_L172  L_L216  0.0017
K_K25158  L_L172  L_L217  0.0017
K_K25159  L_L172  L_L218  0.0017
K_K25160  L_L172  L_L219  0.0016
K_K25161  L_L172  L_L220  0.0016
K_K25162  L_L172  L_L221  0.0015
K_K25163  L_L172  L_L222  0.0015
K_K25164  L_L172  L_L223  0.0015
K_K25165  L_L172  L_L224  0.0015
K_K25166  L_L172  L_L225  0.0014
K_K25167  L_L172  L_L226  0.0014
K_K25168  L_L172  L_L227  0.0014
K_K25169  L_L172  L_L228  0.0014
K_K25170  L_L172  L_L229  0.0013
K_K25171  L_L172  L_L230  0.0013
K_K25172  L_L172  L_L231  0.0013
K_K25173  L_L172  L_L232  0.0013
K_K25174  L_L172  L_L233  0.0013
K_K25175  L_L172  L_L234  0.0012
K_K25176  L_L172  L_L235  0.0012
K_K25177  L_L172  L_L236  0.0012
K_K25178  L_L172  L_L237  0.0012
K_K25179  L_L172  L_L238  0.0011
K_K25180  L_L172  L_L239  0.0011
K_K25181  L_L172  L_L240  0.0011
K_K25182  L_L172  L_L241  0.0011
K_K25183  L_L172  L_L242  0.0011
K_K25184  L_L172  L_L243  0.0011
K_K25185  L_L172  L_L244  0.0011
K_K25186  L_L172  L_L245  0.0010
K_K25187  L_L172  L_L246  0.0010
K_K25188  L_L172  L_L247  0.0010
* *  Branch  NTMP0000000172 - NTMP0000000173
R_R173  NTMP0000000172  nU_173  32.914993m  TC=0,0
V_Ui173  nU_173  nR_173  STIMULUS=U_IND_0000000173
R_V345  nR_173  nV_345  23.280268m  TC=0,0
L_V345  nR_173  nV_345  0.014646uH
R_V346  nV_345  nV_346  7.852787m  TC=0,0
L_V346  nV_345  nV_346  0.073723uH
L_L173  nV_346  NTMP0000000173  6.519695uH
K_K25189  L_L173  L_L174  0.1050
K_K25190  L_L173  L_L175  0.0397
K_K25191  L_L173  L_L176  0.0258
K_K25192  L_L173  L_L177  0.0192
K_K25193  L_L173  L_L178  0.0153
K_K25194  L_L173  L_L179  0.0127
K_K25195  L_L173  L_L180  0.0109
K_K25196  L_L173  L_L181  0.0095
K_K25197  L_L173  L_L182  0.0084
K_K25198  L_L173  L_L183  0.0076
K_K25199  L_L173  L_L184  0.0069
K_K25200  L_L173  L_L185  0.0063
K_K25201  L_L173  L_L186  0.0058
K_K25202  L_L173  L_L187  0.0054
K_K25203  L_L173  L_L188  0.0051
K_K25204  L_L173  L_L189  0.0047
K_K25205  L_L173  L_L190  0.0045
K_K25206  L_L173  L_L191  0.0042
K_K25207  L_L173  L_L192  0.0040
K_K25208  L_L173  L_L193  0.0038
K_K25209  L_L173  L_L194  0.0036
K_K25210  L_L173  L_L195  0.0034
K_K25211  L_L173  L_L196  0.0033
K_K25212  L_L173  L_L197  0.0032
K_K25213  L_L173  L_L198  0.0030
K_K25214  L_L173  L_L199  0.0029
K_K25215  L_L173  L_L200  0.0028
K_K25216  L_L173  L_L201  0.0027
K_K25217  L_L173  L_L202  0.0026
K_K25218  L_L173  L_L203  0.0025
K_K25219  L_L173  L_L204  0.0024
K_K25220  L_L173  L_L205  0.0024
K_K25221  L_L173  L_L206  0.0023
K_K25222  L_L173  L_L207  0.0022
K_K25223  L_L173  L_L208  0.0022
K_K25224  L_L173  L_L209  0.0021
K_K25225  L_L173  L_L210  0.0020
K_K25226  L_L173  L_L211  0.0020
K_K25227  L_L173  L_L212  0.0019
K_K25228  L_L173  L_L213  0.0019
K_K25229  L_L173  L_L214  0.0019
K_K25230  L_L173  L_L215  0.0018
K_K25231  L_L173  L_L216  0.0018
K_K25232  L_L173  L_L217  0.0017
K_K25233  L_L173  L_L218  0.0017
K_K25234  L_L173  L_L219  0.0017
K_K25235  L_L173  L_L220  0.0016
K_K25236  L_L173  L_L221  0.0016
K_K25237  L_L173  L_L222  0.0015
K_K25238  L_L173  L_L223  0.0015
K_K25239  L_L173  L_L224  0.0015
K_K25240  L_L173  L_L225  0.0015
K_K25241  L_L173  L_L226  0.0014
K_K25242  L_L173  L_L227  0.0014
K_K25243  L_L173  L_L228  0.0014
K_K25244  L_L173  L_L229  0.0014
K_K25245  L_L173  L_L230  0.0013
K_K25246  L_L173  L_L231  0.0013
K_K25247  L_L173  L_L232  0.0013
K_K25248  L_L173  L_L233  0.0013
K_K25249  L_L173  L_L234  0.0013
K_K25250  L_L173  L_L235  0.0012
K_K25251  L_L173  L_L236  0.0012
K_K25252  L_L173  L_L237  0.0012
K_K25253  L_L173  L_L238  0.0012
K_K25254  L_L173  L_L239  0.0011
K_K25255  L_L173  L_L240  0.0011
K_K25256  L_L173  L_L241  0.0011
K_K25257  L_L173  L_L242  0.0011
K_K25258  L_L173  L_L243  0.0011
K_K25259  L_L173  L_L244  0.0011
K_K25260  L_L173  L_L245  0.0011
K_K25261  L_L173  L_L246  0.0010
K_K25262  L_L173  L_L247  0.0010
K_K25263  L_L173  L_L248  0.0010
* *  Branch  NTMP0000000173 - NTMP0000000174
R_R174  NTMP0000000173  nU_174  32.914993m  TC=0,0
V_Ui174  nU_174  nR_174  STIMULUS=U_IND_0000000174
R_V347  nR_174  nV_347  23.280268m  TC=0,0
L_V347  nR_174  nV_347  0.014646uH
R_V348  nV_347  nV_348  7.852787m  TC=0,0
L_V348  nV_347  nV_348  0.073723uH
L_L174  nV_348  NTMP0000000174  6.519695uH
K_K25264  L_L174  L_L175  0.1050
K_K25265  L_L174  L_L176  0.0397
K_K25266  L_L174  L_L177  0.0258
K_K25267  L_L174  L_L178  0.0192
K_K25268  L_L174  L_L179  0.0153
K_K25269  L_L174  L_L180  0.0127
K_K25270  L_L174  L_L181  0.0109
K_K25271  L_L174  L_L182  0.0095
K_K25272  L_L174  L_L183  0.0084
K_K25273  L_L174  L_L184  0.0076
K_K25274  L_L174  L_L185  0.0069
K_K25275  L_L174  L_L186  0.0063
K_K25276  L_L174  L_L187  0.0058
K_K25277  L_L174  L_L188  0.0054
K_K25278  L_L174  L_L189  0.0051
K_K25279  L_L174  L_L190  0.0047
K_K25280  L_L174  L_L191  0.0045
K_K25281  L_L174  L_L192  0.0042
K_K25282  L_L174  L_L193  0.0040
K_K25283  L_L174  L_L194  0.0038
K_K25284  L_L174  L_L195  0.0036
K_K25285  L_L174  L_L196  0.0034
K_K25286  L_L174  L_L197  0.0033
K_K25287  L_L174  L_L198  0.0032
K_K25288  L_L174  L_L199  0.0030
K_K25289  L_L174  L_L200  0.0029
K_K25290  L_L174  L_L201  0.0028
K_K25291  L_L174  L_L202  0.0027
K_K25292  L_L174  L_L203  0.0026
K_K25293  L_L174  L_L204  0.0025
K_K25294  L_L174  L_L205  0.0024
K_K25295  L_L174  L_L206  0.0024
K_K25296  L_L174  L_L207  0.0023
K_K25297  L_L174  L_L208  0.0022
K_K25298  L_L174  L_L209  0.0022
K_K25299  L_L174  L_L210  0.0021
K_K25300  L_L174  L_L211  0.0020
K_K25301  L_L174  L_L212  0.0020
K_K25302  L_L174  L_L213  0.0019
K_K25303  L_L174  L_L214  0.0019
K_K25304  L_L174  L_L215  0.0019
K_K25305  L_L174  L_L216  0.0018
K_K25306  L_L174  L_L217  0.0018
K_K25307  L_L174  L_L218  0.0017
K_K25308  L_L174  L_L219  0.0017
K_K25309  L_L174  L_L220  0.0017
K_K25310  L_L174  L_L221  0.0016
K_K25311  L_L174  L_L222  0.0016
K_K25312  L_L174  L_L223  0.0015
K_K25313  L_L174  L_L224  0.0015
K_K25314  L_L174  L_L225  0.0015
K_K25315  L_L174  L_L226  0.0015
K_K25316  L_L174  L_L227  0.0014
K_K25317  L_L174  L_L228  0.0014
K_K25318  L_L174  L_L229  0.0014
K_K25319  L_L174  L_L230  0.0014
K_K25320  L_L174  L_L231  0.0013
K_K25321  L_L174  L_L232  0.0013
K_K25322  L_L174  L_L233  0.0013
K_K25323  L_L174  L_L234  0.0013
K_K25324  L_L174  L_L235  0.0013
K_K25325  L_L174  L_L236  0.0012
K_K25326  L_L174  L_L237  0.0012
K_K25327  L_L174  L_L238  0.0012
K_K25328  L_L174  L_L239  0.0012
K_K25329  L_L174  L_L240  0.0011
K_K25330  L_L174  L_L241  0.0011
K_K25331  L_L174  L_L242  0.0011
K_K25332  L_L174  L_L243  0.0011
K_K25333  L_L174  L_L244  0.0011
K_K25334  L_L174  L_L245  0.0011
K_K25335  L_L174  L_L246  0.0011
K_K25336  L_L174  L_L247  0.0010
K_K25337  L_L174  L_L248  0.0010
K_K25338  L_L174  L_L249  0.0010
* *  Branch  NTMP0000000174 - NTMP0000000175
R_R175  NTMP0000000174  nU_175  32.914993m  TC=0,0
V_Ui175  nU_175  nR_175  STIMULUS=U_IND_0000000175
R_V349  nR_175  nV_349  23.280268m  TC=0,0
L_V349  nR_175  nV_349  0.014646uH
R_V350  nV_349  nV_350  7.852787m  TC=0,0
L_V350  nV_349  nV_350  0.073723uH
L_L175  nV_350  NTMP0000000175  6.519695uH
K_K25339  L_L175  L_L176  0.1050
K_K25340  L_L175  L_L177  0.0397
K_K25341  L_L175  L_L178  0.0258
K_K25342  L_L175  L_L179  0.0192
K_K25343  L_L175  L_L180  0.0153
K_K25344  L_L175  L_L181  0.0127
K_K25345  L_L175  L_L182  0.0109
K_K25346  L_L175  L_L183  0.0095
K_K25347  L_L175  L_L184  0.0084
K_K25348  L_L175  L_L185  0.0076
K_K25349  L_L175  L_L186  0.0069
K_K25350  L_L175  L_L187  0.0063
K_K25351  L_L175  L_L188  0.0058
K_K25352  L_L175  L_L189  0.0054
K_K25353  L_L175  L_L190  0.0051
K_K25354  L_L175  L_L191  0.0047
K_K25355  L_L175  L_L192  0.0045
K_K25356  L_L175  L_L193  0.0042
K_K25357  L_L175  L_L194  0.0040
K_K25358  L_L175  L_L195  0.0038
K_K25359  L_L175  L_L196  0.0036
K_K25360  L_L175  L_L197  0.0034
K_K25361  L_L175  L_L198  0.0033
K_K25362  L_L175  L_L199  0.0032
K_K25363  L_L175  L_L200  0.0030
K_K25364  L_L175  L_L201  0.0029
K_K25365  L_L175  L_L202  0.0028
K_K25366  L_L175  L_L203  0.0027
K_K25367  L_L175  L_L204  0.0026
K_K25368  L_L175  L_L205  0.0025
K_K25369  L_L175  L_L206  0.0024
K_K25370  L_L175  L_L207  0.0024
K_K25371  L_L175  L_L208  0.0023
K_K25372  L_L175  L_L209  0.0022
K_K25373  L_L175  L_L210  0.0022
K_K25374  L_L175  L_L211  0.0021
K_K25375  L_L175  L_L212  0.0020
K_K25376  L_L175  L_L213  0.0020
K_K25377  L_L175  L_L214  0.0019
K_K25378  L_L175  L_L215  0.0019
K_K25379  L_L175  L_L216  0.0018
K_K25380  L_L175  L_L217  0.0018
K_K25381  L_L175  L_L218  0.0018
K_K25382  L_L175  L_L219  0.0017
K_K25383  L_L175  L_L220  0.0017
K_K25384  L_L175  L_L221  0.0016
K_K25385  L_L175  L_L222  0.0016
K_K25386  L_L175  L_L223  0.0016
K_K25387  L_L175  L_L224  0.0015
K_K25388  L_L175  L_L225  0.0015
K_K25389  L_L175  L_L226  0.0015
K_K25390  L_L175  L_L227  0.0015
K_K25391  L_L175  L_L228  0.0014
K_K25392  L_L175  L_L229  0.0014
K_K25393  L_L175  L_L230  0.0014
K_K25394  L_L175  L_L231  0.0014
K_K25395  L_L175  L_L232  0.0013
K_K25396  L_L175  L_L233  0.0013
K_K25397  L_L175  L_L234  0.0013
K_K25398  L_L175  L_L235  0.0013
K_K25399  L_L175  L_L236  0.0013
K_K25400  L_L175  L_L237  0.0012
K_K25401  L_L175  L_L238  0.0012
K_K25402  L_L175  L_L239  0.0012
K_K25403  L_L175  L_L240  0.0012
K_K25404  L_L175  L_L241  0.0011
K_K25405  L_L175  L_L242  0.0011
K_K25406  L_L175  L_L243  0.0011
K_K25407  L_L175  L_L244  0.0011
K_K25408  L_L175  L_L245  0.0011
K_K25409  L_L175  L_L246  0.0011
K_K25410  L_L175  L_L247  0.0011
K_K25411  L_L175  L_L248  0.0010
K_K25412  L_L175  L_L249  0.0010
K_K25413  L_L175  L_L250  0.0010
* *  Branch  NTMP0000000175 - NTMP0000000176
R_R176  NTMP0000000175  nU_176  32.914993m  TC=0,0
V_Ui176  nU_176  nR_176  STIMULUS=U_IND_0000000176
R_V351  nR_176  nV_351  23.280268m  TC=0,0
L_V351  nR_176  nV_351  0.014646uH
R_V352  nV_351  nV_352  7.852787m  TC=0,0
L_V352  nV_351  nV_352  0.073723uH
L_L176  nV_352  NTMP0000000176  6.519695uH
K_K25414  L_L176  L_L177  0.1050
K_K25415  L_L176  L_L178  0.0397
K_K25416  L_L176  L_L179  0.0258
K_K25417  L_L176  L_L180  0.0192
K_K25418  L_L176  L_L181  0.0153
K_K25419  L_L176  L_L182  0.0127
K_K25420  L_L176  L_L183  0.0109
K_K25421  L_L176  L_L184  0.0095
K_K25422  L_L176  L_L185  0.0084
K_K25423  L_L176  L_L186  0.0076
K_K25424  L_L176  L_L187  0.0069
K_K25425  L_L176  L_L188  0.0063
K_K25426  L_L176  L_L189  0.0058
K_K25427  L_L176  L_L190  0.0054
K_K25428  L_L176  L_L191  0.0051
K_K25429  L_L176  L_L192  0.0047
K_K25430  L_L176  L_L193  0.0045
K_K25431  L_L176  L_L194  0.0042
K_K25432  L_L176  L_L195  0.0040
K_K25433  L_L176  L_L196  0.0038
K_K25434  L_L176  L_L197  0.0036
K_K25435  L_L176  L_L198  0.0034
K_K25436  L_L176  L_L199  0.0033
K_K25437  L_L176  L_L200  0.0032
K_K25438  L_L176  L_L201  0.0030
K_K25439  L_L176  L_L202  0.0029
K_K25440  L_L176  L_L203  0.0028
K_K25441  L_L176  L_L204  0.0027
K_K25442  L_L176  L_L205  0.0026
K_K25443  L_L176  L_L206  0.0025
K_K25444  L_L176  L_L207  0.0024
K_K25445  L_L176  L_L208  0.0024
K_K25446  L_L176  L_L209  0.0023
K_K25447  L_L176  L_L210  0.0022
K_K25448  L_L176  L_L211  0.0022
K_K25449  L_L176  L_L212  0.0021
K_K25450  L_L176  L_L213  0.0020
K_K25451  L_L176  L_L214  0.0020
K_K25452  L_L176  L_L215  0.0019
K_K25453  L_L176  L_L216  0.0019
K_K25454  L_L176  L_L217  0.0018
K_K25455  L_L176  L_L218  0.0018
K_K25456  L_L176  L_L219  0.0018
K_K25457  L_L176  L_L220  0.0017
K_K25458  L_L176  L_L221  0.0017
K_K25459  L_L176  L_L222  0.0016
K_K25460  L_L176  L_L223  0.0016
K_K25461  L_L176  L_L224  0.0016
K_K25462  L_L176  L_L225  0.0016
K_K25463  L_L176  L_L226  0.0015
K_K25464  L_L176  L_L227  0.0015
K_K25465  L_L176  L_L228  0.0015
K_K25466  L_L176  L_L229  0.0014
K_K25467  L_L176  L_L230  0.0014
K_K25468  L_L176  L_L231  0.0014
K_K25469  L_L176  L_L232  0.0014
K_K25470  L_L176  L_L233  0.0013
K_K25471  L_L176  L_L234  0.0013
K_K25472  L_L176  L_L235  0.0013
K_K25473  L_L176  L_L236  0.0013
K_K25474  L_L176  L_L237  0.0013
K_K25475  L_L176  L_L238  0.0012
K_K25476  L_L176  L_L239  0.0012
K_K25477  L_L176  L_L240  0.0012
K_K25478  L_L176  L_L241  0.0012
K_K25479  L_L176  L_L242  0.0011
K_K25480  L_L176  L_L243  0.0011
K_K25481  L_L176  L_L244  0.0011
K_K25482  L_L176  L_L245  0.0011
K_K25483  L_L176  L_L246  0.0011
K_K25484  L_L176  L_L247  0.0011
K_K25485  L_L176  L_L248  0.0011
K_K25486  L_L176  L_L249  0.0010
K_K25487  L_L176  L_L250  0.0010
K_K25488  L_L176  L_L251  0.0010
* *  Branch  NTMP0000000176 - NTMP0000000177
R_R177  NTMP0000000176  nU_177  32.914993m  TC=0,0
V_Ui177  nU_177  nR_177  STIMULUS=U_IND_0000000177
R_V353  nR_177  nV_353  23.280268m  TC=0,0
L_V353  nR_177  nV_353  0.014646uH
R_V354  nV_353  nV_354  7.852787m  TC=0,0
L_V354  nV_353  nV_354  0.073723uH
L_L177  nV_354  NTMP0000000177  6.519695uH
K_K25489  L_L177  L_L178  0.1050
K_K25490  L_L177  L_L179  0.0397
K_K25491  L_L177  L_L180  0.0258
K_K25492  L_L177  L_L181  0.0192
K_K25493  L_L177  L_L182  0.0153
K_K25494  L_L177  L_L183  0.0127
K_K25495  L_L177  L_L184  0.0109
K_K25496  L_L177  L_L185  0.0095
K_K25497  L_L177  L_L186  0.0084
K_K25498  L_L177  L_L187  0.0076
K_K25499  L_L177  L_L188  0.0069
K_K25500  L_L177  L_L189  0.0063
K_K25501  L_L177  L_L190  0.0058
K_K25502  L_L177  L_L191  0.0054
K_K25503  L_L177  L_L192  0.0051
K_K25504  L_L177  L_L193  0.0047
K_K25505  L_L177  L_L194  0.0045
K_K25506  L_L177  L_L195  0.0042
K_K25507  L_L177  L_L196  0.0040
K_K25508  L_L177  L_L197  0.0038
K_K25509  L_L177  L_L198  0.0036
K_K25510  L_L177  L_L199  0.0034
K_K25511  L_L177  L_L200  0.0033
K_K25512  L_L177  L_L201  0.0032
K_K25513  L_L177  L_L202  0.0030
K_K25514  L_L177  L_L203  0.0029
K_K25515  L_L177  L_L204  0.0028
K_K25516  L_L177  L_L205  0.0027
K_K25517  L_L177  L_L206  0.0026
K_K25518  L_L177  L_L207  0.0025
K_K25519  L_L177  L_L208  0.0024
K_K25520  L_L177  L_L209  0.0024
K_K25521  L_L177  L_L210  0.0023
K_K25522  L_L177  L_L211  0.0022
K_K25523  L_L177  L_L212  0.0022
K_K25524  L_L177  L_L213  0.0021
K_K25525  L_L177  L_L214  0.0020
K_K25526  L_L177  L_L215  0.0020
K_K25527  L_L177  L_L216  0.0019
K_K25528  L_L177  L_L217  0.0019
K_K25529  L_L177  L_L218  0.0018
K_K25530  L_L177  L_L219  0.0018
K_K25531  L_L177  L_L220  0.0018
K_K25532  L_L177  L_L221  0.0017
K_K25533  L_L177  L_L222  0.0017
K_K25534  L_L177  L_L223  0.0016
K_K25535  L_L177  L_L224  0.0016
K_K25536  L_L177  L_L225  0.0016
K_K25537  L_L177  L_L226  0.0016
K_K25538  L_L177  L_L227  0.0015
K_K25539  L_L177  L_L228  0.0015
K_K25540  L_L177  L_L229  0.0015
K_K25541  L_L177  L_L230  0.0014
K_K25542  L_L177  L_L231  0.0014
K_K25543  L_L177  L_L232  0.0014
K_K25544  L_L177  L_L233  0.0014
K_K25545  L_L177  L_L234  0.0013
K_K25546  L_L177  L_L235  0.0013
K_K25547  L_L177  L_L236  0.0013
K_K25548  L_L177  L_L237  0.0013
K_K25549  L_L177  L_L238  0.0013
K_K25550  L_L177  L_L239  0.0012
K_K25551  L_L177  L_L240  0.0012
K_K25552  L_L177  L_L241  0.0012
K_K25553  L_L177  L_L242  0.0012
K_K25554  L_L177  L_L243  0.0011
K_K25555  L_L177  L_L244  0.0011
K_K25556  L_L177  L_L245  0.0011
K_K25557  L_L177  L_L246  0.0011
K_K25558  L_L177  L_L247  0.0011
K_K25559  L_L177  L_L248  0.0011
K_K25560  L_L177  L_L249  0.0011
K_K25561  L_L177  L_L250  0.0010
K_K25562  L_L177  L_L251  0.0010
K_K25563  L_L177  L_L252  0.0010
* *  Branch  NTMP0000000177 - NTMP0000000178
R_R178  NTMP0000000177  nU_178  32.914993m  TC=0,0
V_Ui178  nU_178  nR_178  STIMULUS=U_IND_0000000178
R_V355  nR_178  nV_355  23.280268m  TC=0,0
L_V355  nR_178  nV_355  0.014646uH
R_V356  nV_355  nV_356  7.852787m  TC=0,0
L_V356  nV_355  nV_356  0.073723uH
L_L178  nV_356  NTMP0000000178  6.519695uH
K_K25564  L_L178  L_L179  0.1050
K_K25565  L_L178  L_L180  0.0397
K_K25566  L_L178  L_L181  0.0258
K_K25567  L_L178  L_L182  0.0192
K_K25568  L_L178  L_L183  0.0153
K_K25569  L_L178  L_L184  0.0127
K_K25570  L_L178  L_L185  0.0109
K_K25571  L_L178  L_L186  0.0095
K_K25572  L_L178  L_L187  0.0084
K_K25573  L_L178  L_L188  0.0076
K_K25574  L_L178  L_L189  0.0069
K_K25575  L_L178  L_L190  0.0063
K_K25576  L_L178  L_L191  0.0058
K_K25577  L_L178  L_L192  0.0054
K_K25578  L_L178  L_L193  0.0051
K_K25579  L_L178  L_L194  0.0047
K_K25580  L_L178  L_L195  0.0045
K_K25581  L_L178  L_L196  0.0042
K_K25582  L_L178  L_L197  0.0040
K_K25583  L_L178  L_L198  0.0038
K_K25584  L_L178  L_L199  0.0036
K_K25585  L_L178  L_L200  0.0034
K_K25586  L_L178  L_L201  0.0033
K_K25587  L_L178  L_L202  0.0032
K_K25588  L_L178  L_L203  0.0030
K_K25589  L_L178  L_L204  0.0029
K_K25590  L_L178  L_L205  0.0028
K_K25591  L_L178  L_L206  0.0027
K_K25592  L_L178  L_L207  0.0026
K_K25593  L_L178  L_L208  0.0025
K_K25594  L_L178  L_L209  0.0024
K_K25595  L_L178  L_L210  0.0024
K_K25596  L_L178  L_L211  0.0023
K_K25597  L_L178  L_L212  0.0022
K_K25598  L_L178  L_L213  0.0022
K_K25599  L_L178  L_L214  0.0021
K_K25600  L_L178  L_L215  0.0020
K_K25601  L_L178  L_L216  0.0020
K_K25602  L_L178  L_L217  0.0019
K_K25603  L_L178  L_L218  0.0019
K_K25604  L_L178  L_L219  0.0018
K_K25605  L_L178  L_L220  0.0018
K_K25606  L_L178  L_L221  0.0018
K_K25607  L_L178  L_L222  0.0017
K_K25608  L_L178  L_L223  0.0017
K_K25609  L_L178  L_L224  0.0016
K_K25610  L_L178  L_L225  0.0016
K_K25611  L_L178  L_L226  0.0016
K_K25612  L_L178  L_L227  0.0016
K_K25613  L_L178  L_L228  0.0015
K_K25614  L_L178  L_L229  0.0015
K_K25615  L_L178  L_L230  0.0015
K_K25616  L_L178  L_L231  0.0014
K_K25617  L_L178  L_L232  0.0014
K_K25618  L_L178  L_L233  0.0014
K_K25619  L_L178  L_L234  0.0014
K_K25620  L_L178  L_L235  0.0013
K_K25621  L_L178  L_L236  0.0013
K_K25622  L_L178  L_L237  0.0013
K_K25623  L_L178  L_L238  0.0013
K_K25624  L_L178  L_L239  0.0013
K_K25625  L_L178  L_L240  0.0012
K_K25626  L_L178  L_L241  0.0012
K_K25627  L_L178  L_L242  0.0012
K_K25628  L_L178  L_L243  0.0012
K_K25629  L_L178  L_L244  0.0011
K_K25630  L_L178  L_L245  0.0011
K_K25631  L_L178  L_L246  0.0011
K_K25632  L_L178  L_L247  0.0011
K_K25633  L_L178  L_L248  0.0011
K_K25634  L_L178  L_L249  0.0011
K_K25635  L_L178  L_L250  0.0011
K_K25636  L_L178  L_L251  0.0010
K_K25637  L_L178  L_L252  0.0010
K_K25638  L_L178  L_L253  0.0010
* *  Branch  NTMP0000000178 - NTMP0000000179
R_R179  NTMP0000000178  nU_179  32.914993m  TC=0,0
V_Ui179  nU_179  nR_179  STIMULUS=U_IND_0000000179
R_V357  nR_179  nV_357  23.280268m  TC=0,0
L_V357  nR_179  nV_357  0.014646uH
R_V358  nV_357  nV_358  7.852787m  TC=0,0
L_V358  nV_357  nV_358  0.073723uH
L_L179  nV_358  NTMP0000000179  6.519695uH
K_K25639  L_L179  L_L180  0.1050
K_K25640  L_L179  L_L181  0.0397
K_K25641  L_L179  L_L182  0.0258
K_K25642  L_L179  L_L183  0.0192
K_K25643  L_L179  L_L184  0.0153
K_K25644  L_L179  L_L185  0.0127
K_K25645  L_L179  L_L186  0.0109
K_K25646  L_L179  L_L187  0.0095
K_K25647  L_L179  L_L188  0.0084
K_K25648  L_L179  L_L189  0.0076
K_K25649  L_L179  L_L190  0.0069
K_K25650  L_L179  L_L191  0.0063
K_K25651  L_L179  L_L192  0.0058
K_K25652  L_L179  L_L193  0.0054
K_K25653  L_L179  L_L194  0.0051
K_K25654  L_L179  L_L195  0.0047
K_K25655  L_L179  L_L196  0.0045
K_K25656  L_L179  L_L197  0.0042
K_K25657  L_L179  L_L198  0.0040
K_K25658  L_L179  L_L199  0.0038
K_K25659  L_L179  L_L200  0.0036
K_K25660  L_L179  L_L201  0.0034
K_K25661  L_L179  L_L202  0.0033
K_K25662  L_L179  L_L203  0.0032
K_K25663  L_L179  L_L204  0.0030
K_K25664  L_L179  L_L205  0.0029
K_K25665  L_L179  L_L206  0.0028
K_K25666  L_L179  L_L207  0.0027
K_K25667  L_L179  L_L208  0.0026
K_K25668  L_L179  L_L209  0.0025
K_K25669  L_L179  L_L210  0.0024
K_K25670  L_L179  L_L211  0.0024
K_K25671  L_L179  L_L212  0.0023
K_K25672  L_L179  L_L213  0.0022
K_K25673  L_L179  L_L214  0.0022
K_K25674  L_L179  L_L215  0.0021
K_K25675  L_L179  L_L216  0.0020
K_K25676  L_L179  L_L217  0.0020
K_K25677  L_L179  L_L218  0.0019
K_K25678  L_L179  L_L219  0.0019
K_K25679  L_L179  L_L220  0.0018
K_K25680  L_L179  L_L221  0.0018
K_K25681  L_L179  L_L222  0.0018
K_K25682  L_L179  L_L223  0.0017
K_K25683  L_L179  L_L224  0.0017
K_K25684  L_L179  L_L225  0.0016
K_K25685  L_L179  L_L226  0.0016
K_K25686  L_L179  L_L227  0.0016
K_K25687  L_L179  L_L228  0.0016
K_K25688  L_L179  L_L229  0.0015
K_K25689  L_L179  L_L230  0.0015
K_K25690  L_L179  L_L231  0.0015
K_K25691  L_L179  L_L232  0.0014
K_K25692  L_L179  L_L233  0.0014
K_K25693  L_L179  L_L234  0.0014
K_K25694  L_L179  L_L235  0.0014
K_K25695  L_L179  L_L236  0.0013
K_K25696  L_L179  L_L237  0.0013
K_K25697  L_L179  L_L238  0.0013
K_K25698  L_L179  L_L239  0.0013
K_K25699  L_L179  L_L240  0.0013
K_K25700  L_L179  L_L241  0.0012
K_K25701  L_L179  L_L242  0.0012
K_K25702  L_L179  L_L243  0.0012
K_K25703  L_L179  L_L244  0.0012
K_K25704  L_L179  L_L245  0.0011
K_K25705  L_L179  L_L246  0.0011
K_K25706  L_L179  L_L247  0.0011
K_K25707  L_L179  L_L248  0.0011
K_K25708  L_L179  L_L249  0.0011
K_K25709  L_L179  L_L250  0.0011
K_K25710  L_L179  L_L251  0.0011
K_K25711  L_L179  L_L252  0.0010
K_K25712  L_L179  L_L253  0.0010
K_K25713  L_L179  L_L254  0.0010
* *  Branch  NTMP0000000179 - NTMP0000000180
R_R180  NTMP0000000179  nU_180  32.914993m  TC=0,0
V_Ui180  nU_180  nR_180  STIMULUS=U_IND_0000000180
R_V359  nR_180  nV_359  23.280268m  TC=0,0
L_V359  nR_180  nV_359  0.014646uH
R_V360  nV_359  nV_360  7.852787m  TC=0,0
L_V360  nV_359  nV_360  0.073723uH
L_L180  nV_360  NTMP0000000180  6.519695uH
K_K25714  L_L180  L_L181  0.1050
K_K25715  L_L180  L_L182  0.0397
K_K25716  L_L180  L_L183  0.0258
K_K25717  L_L180  L_L184  0.0192
K_K25718  L_L180  L_L185  0.0153
K_K25719  L_L180  L_L186  0.0127
K_K25720  L_L180  L_L187  0.0109
K_K25721  L_L180  L_L188  0.0095
K_K25722  L_L180  L_L189  0.0084
K_K25723  L_L180  L_L190  0.0076
K_K25724  L_L180  L_L191  0.0069
K_K25725  L_L180  L_L192  0.0063
K_K25726  L_L180  L_L193  0.0058
K_K25727  L_L180  L_L194  0.0054
K_K25728  L_L180  L_L195  0.0051
K_K25729  L_L180  L_L196  0.0047
K_K25730  L_L180  L_L197  0.0045
K_K25731  L_L180  L_L198  0.0042
K_K25732  L_L180  L_L199  0.0040
K_K25733  L_L180  L_L200  0.0038
K_K25734  L_L180  L_L201  0.0036
K_K25735  L_L180  L_L202  0.0034
K_K25736  L_L180  L_L203  0.0033
K_K25737  L_L180  L_L204  0.0032
K_K25738  L_L180  L_L205  0.0030
K_K25739  L_L180  L_L206  0.0029
K_K25740  L_L180  L_L207  0.0028
K_K25741  L_L180  L_L208  0.0027
K_K25742  L_L180  L_L209  0.0026
K_K25743  L_L180  L_L210  0.0025
K_K25744  L_L180  L_L211  0.0024
K_K25745  L_L180  L_L212  0.0024
K_K25746  L_L180  L_L213  0.0023
K_K25747  L_L180  L_L214  0.0022
K_K25748  L_L180  L_L215  0.0022
K_K25749  L_L180  L_L216  0.0021
K_K25750  L_L180  L_L217  0.0020
K_K25751  L_L180  L_L218  0.0020
K_K25752  L_L180  L_L219  0.0019
K_K25753  L_L180  L_L220  0.0019
K_K25754  L_L180  L_L221  0.0018
K_K25755  L_L180  L_L222  0.0018
K_K25756  L_L180  L_L223  0.0018
K_K25757  L_L180  L_L224  0.0017
K_K25758  L_L180  L_L225  0.0017
K_K25759  L_L180  L_L226  0.0016
K_K25760  L_L180  L_L227  0.0016
K_K25761  L_L180  L_L228  0.0016
K_K25762  L_L180  L_L229  0.0015
K_K25763  L_L180  L_L230  0.0015
K_K25764  L_L180  L_L231  0.0015
K_K25765  L_L180  L_L232  0.0015
K_K25766  L_L180  L_L233  0.0014
K_K25767  L_L180  L_L234  0.0014
K_K25768  L_L180  L_L235  0.0014
K_K25769  L_L180  L_L236  0.0014
K_K25770  L_L180  L_L237  0.0013
K_K25771  L_L180  L_L238  0.0013
K_K25772  L_L180  L_L239  0.0013
K_K25773  L_L180  L_L240  0.0013
K_K25774  L_L180  L_L241  0.0013
K_K25775  L_L180  L_L242  0.0012
K_K25776  L_L180  L_L243  0.0012
K_K25777  L_L180  L_L244  0.0012
K_K25778  L_L180  L_L245  0.0012
K_K25779  L_L180  L_L246  0.0011
K_K25780  L_L180  L_L247  0.0011
K_K25781  L_L180  L_L248  0.0011
K_K25782  L_L180  L_L249  0.0011
K_K25783  L_L180  L_L250  0.0011
K_K25784  L_L180  L_L251  0.0011
K_K25785  L_L180  L_L252  0.0011
K_K25786  L_L180  L_L253  0.0010
K_K25787  L_L180  L_L254  0.0010
K_K25788  L_L180  L_L255  0.0010
* *  Branch  NTMP0000000180 - NTMP0000000181
R_R181  NTMP0000000180  nU_181  32.914993m  TC=0,0
V_Ui181  nU_181  nR_181  STIMULUS=U_IND_0000000181
R_V361  nR_181  nV_361  23.280268m  TC=0,0
L_V361  nR_181  nV_361  0.014646uH
R_V362  nV_361  nV_362  7.852787m  TC=0,0
L_V362  nV_361  nV_362  0.073723uH
L_L181  nV_362  NTMP0000000181  6.519695uH
K_K25789  L_L181  L_L182  0.1050
K_K25790  L_L181  L_L183  0.0397
K_K25791  L_L181  L_L184  0.0258
K_K25792  L_L181  L_L185  0.0192
K_K25793  L_L181  L_L186  0.0153
K_K25794  L_L181  L_L187  0.0127
K_K25795  L_L181  L_L188  0.0109
K_K25796  L_L181  L_L189  0.0095
K_K25797  L_L181  L_L190  0.0084
K_K25798  L_L181  L_L191  0.0076
K_K25799  L_L181  L_L192  0.0069
K_K25800  L_L181  L_L193  0.0063
K_K25801  L_L181  L_L194  0.0058
K_K25802  L_L181  L_L195  0.0054
K_K25803  L_L181  L_L196  0.0051
K_K25804  L_L181  L_L197  0.0047
K_K25805  L_L181  L_L198  0.0045
K_K25806  L_L181  L_L199  0.0042
K_K25807  L_L181  L_L200  0.0040
K_K25808  L_L181  L_L201  0.0038
K_K25809  L_L181  L_L202  0.0036
K_K25810  L_L181  L_L203  0.0034
K_K25811  L_L181  L_L204  0.0033
K_K25812  L_L181  L_L205  0.0032
K_K25813  L_L181  L_L206  0.0030
K_K25814  L_L181  L_L207  0.0029
K_K25815  L_L181  L_L208  0.0028
K_K25816  L_L181  L_L209  0.0027
K_K25817  L_L181  L_L210  0.0026
K_K25818  L_L181  L_L211  0.0025
K_K25819  L_L181  L_L212  0.0024
K_K25820  L_L181  L_L213  0.0024
K_K25821  L_L181  L_L214  0.0023
K_K25822  L_L181  L_L215  0.0022
K_K25823  L_L181  L_L216  0.0022
K_K25824  L_L181  L_L217  0.0021
K_K25825  L_L181  L_L218  0.0020
K_K25826  L_L181  L_L219  0.0020
K_K25827  L_L181  L_L220  0.0019
K_K25828  L_L181  L_L221  0.0019
K_K25829  L_L181  L_L222  0.0018
K_K25830  L_L181  L_L223  0.0018
K_K25831  L_L181  L_L224  0.0018
K_K25832  L_L181  L_L225  0.0017
K_K25833  L_L181  L_L226  0.0017
K_K25834  L_L181  L_L227  0.0016
K_K25835  L_L181  L_L228  0.0016
K_K25836  L_L181  L_L229  0.0016
K_K25837  L_L181  L_L230  0.0015
K_K25838  L_L181  L_L231  0.0015
K_K25839  L_L181  L_L232  0.0015
K_K25840  L_L181  L_L233  0.0015
K_K25841  L_L181  L_L234  0.0014
K_K25842  L_L181  L_L235  0.0014
K_K25843  L_L181  L_L236  0.0014
K_K25844  L_L181  L_L237  0.0014
K_K25845  L_L181  L_L238  0.0013
K_K25846  L_L181  L_L239  0.0013
K_K25847  L_L181  L_L240  0.0013
K_K25848  L_L181  L_L241  0.0013
K_K25849  L_L181  L_L242  0.0013
K_K25850  L_L181  L_L243  0.0012
K_K25851  L_L181  L_L244  0.0012
K_K25852  L_L181  L_L245  0.0012
K_K25853  L_L181  L_L246  0.0012
K_K25854  L_L181  L_L247  0.0011
K_K25855  L_L181  L_L248  0.0011
K_K25856  L_L181  L_L249  0.0011
K_K25857  L_L181  L_L250  0.0011
K_K25858  L_L181  L_L251  0.0011
K_K25859  L_L181  L_L252  0.0011
K_K25860  L_L181  L_L253  0.0011
K_K25861  L_L181  L_L254  0.0010
K_K25862  L_L181  L_L255  0.0010
K_K25863  L_L181  L_L256  0.0010
* *  Branch  NTMP0000000181 - NTMP0000000182
R_R182  NTMP0000000181  nU_182  32.914993m  TC=0,0
V_Ui182  nU_182  nR_182  STIMULUS=U_IND_0000000182
R_V363  nR_182  nV_363  23.280268m  TC=0,0
L_V363  nR_182  nV_363  0.014646uH
R_V364  nV_363  nV_364  7.852787m  TC=0,0
L_V364  nV_363  nV_364  0.073723uH
L_L182  nV_364  NTMP0000000182  6.519695uH
K_K25864  L_L182  L_L183  0.1050
K_K25865  L_L182  L_L184  0.0397
K_K25866  L_L182  L_L185  0.0258
K_K25867  L_L182  L_L186  0.0192
K_K25868  L_L182  L_L187  0.0153
K_K25869  L_L182  L_L188  0.0127
K_K25870  L_L182  L_L189  0.0109
K_K25871  L_L182  L_L190  0.0095
K_K25872  L_L182  L_L191  0.0084
K_K25873  L_L182  L_L192  0.0076
K_K25874  L_L182  L_L193  0.0069
K_K25875  L_L182  L_L194  0.0063
K_K25876  L_L182  L_L195  0.0058
K_K25877  L_L182  L_L196  0.0054
K_K25878  L_L182  L_L197  0.0051
K_K25879  L_L182  L_L198  0.0047
K_K25880  L_L182  L_L199  0.0045
K_K25881  L_L182  L_L200  0.0042
K_K25882  L_L182  L_L201  0.0040
K_K25883  L_L182  L_L202  0.0038
K_K25884  L_L182  L_L203  0.0036
K_K25885  L_L182  L_L204  0.0034
K_K25886  L_L182  L_L205  0.0033
K_K25887  L_L182  L_L206  0.0032
K_K25888  L_L182  L_L207  0.0030
K_K25889  L_L182  L_L208  0.0029
K_K25890  L_L182  L_L209  0.0028
K_K25891  L_L182  L_L210  0.0027
K_K25892  L_L182  L_L211  0.0026
K_K25893  L_L182  L_L212  0.0025
K_K25894  L_L182  L_L213  0.0024
K_K25895  L_L182  L_L214  0.0024
K_K25896  L_L182  L_L215  0.0023
K_K25897  L_L182  L_L216  0.0022
K_K25898  L_L182  L_L217  0.0022
K_K25899  L_L182  L_L218  0.0021
K_K25900  L_L182  L_L219  0.0020
K_K25901  L_L182  L_L220  0.0020
K_K25902  L_L182  L_L221  0.0019
K_K25903  L_L182  L_L222  0.0019
K_K25904  L_L182  L_L223  0.0018
K_K25905  L_L182  L_L224  0.0018
K_K25906  L_L182  L_L225  0.0018
K_K25907  L_L182  L_L226  0.0017
K_K25908  L_L182  L_L227  0.0017
K_K25909  L_L182  L_L228  0.0016
K_K25910  L_L182  L_L229  0.0016
K_K25911  L_L182  L_L230  0.0016
K_K25912  L_L182  L_L231  0.0015
K_K25913  L_L182  L_L232  0.0015
K_K25914  L_L182  L_L233  0.0015
K_K25915  L_L182  L_L234  0.0015
K_K25916  L_L182  L_L235  0.0014
K_K25917  L_L182  L_L236  0.0014
K_K25918  L_L182  L_L237  0.0014
K_K25919  L_L182  L_L238  0.0014
K_K25920  L_L182  L_L239  0.0013
K_K25921  L_L182  L_L240  0.0013
K_K25922  L_L182  L_L241  0.0013
K_K25923  L_L182  L_L242  0.0013
K_K25924  L_L182  L_L243  0.0013
K_K25925  L_L182  L_L244  0.0012
K_K25926  L_L182  L_L245  0.0012
K_K25927  L_L182  L_L246  0.0012
K_K25928  L_L182  L_L247  0.0012
K_K25929  L_L182  L_L248  0.0011
K_K25930  L_L182  L_L249  0.0011
K_K25931  L_L182  L_L250  0.0011
K_K25932  L_L182  L_L251  0.0011
K_K25933  L_L182  L_L252  0.0011
K_K25934  L_L182  L_L253  0.0011
K_K25935  L_L182  L_L254  0.0011
K_K25936  L_L182  L_L255  0.0010
K_K25937  L_L182  L_L256  0.0010
K_K25938  L_L182  L_L257  0.0010
* *  Branch  NTMP0000000182 - NTMP0000000183
R_R183  NTMP0000000182  nU_183  32.914993m  TC=0,0
V_Ui183  nU_183  nR_183  STIMULUS=U_IND_0000000183
R_V365  nR_183  nV_365  23.280268m  TC=0,0
L_V365  nR_183  nV_365  0.014646uH
R_V366  nV_365  nV_366  7.852787m  TC=0,0
L_V366  nV_365  nV_366  0.073723uH
L_L183  nV_366  NTMP0000000183  6.519695uH
K_K25939  L_L183  L_L184  0.1050
K_K25940  L_L183  L_L185  0.0397
K_K25941  L_L183  L_L186  0.0258
K_K25942  L_L183  L_L187  0.0192
K_K25943  L_L183  L_L188  0.0153
K_K25944  L_L183  L_L189  0.0127
K_K25945  L_L183  L_L190  0.0109
K_K25946  L_L183  L_L191  0.0095
K_K25947  L_L183  L_L192  0.0084
K_K25948  L_L183  L_L193  0.0076
K_K25949  L_L183  L_L194  0.0069
K_K25950  L_L183  L_L195  0.0063
K_K25951  L_L183  L_L196  0.0058
K_K25952  L_L183  L_L197  0.0054
K_K25953  L_L183  L_L198  0.0051
K_K25954  L_L183  L_L199  0.0047
K_K25955  L_L183  L_L200  0.0045
K_K25956  L_L183  L_L201  0.0042
K_K25957  L_L183  L_L202  0.0040
K_K25958  L_L183  L_L203  0.0038
K_K25959  L_L183  L_L204  0.0036
K_K25960  L_L183  L_L205  0.0034
K_K25961  L_L183  L_L206  0.0033
K_K25962  L_L183  L_L207  0.0032
K_K25963  L_L183  L_L208  0.0030
K_K25964  L_L183  L_L209  0.0029
K_K25965  L_L183  L_L210  0.0028
K_K25966  L_L183  L_L211  0.0027
K_K25967  L_L183  L_L212  0.0026
K_K25968  L_L183  L_L213  0.0025
K_K25969  L_L183  L_L214  0.0024
K_K25970  L_L183  L_L215  0.0024
K_K25971  L_L183  L_L216  0.0023
K_K25972  L_L183  L_L217  0.0022
K_K25973  L_L183  L_L218  0.0022
K_K25974  L_L183  L_L219  0.0021
K_K25975  L_L183  L_L220  0.0020
K_K25976  L_L183  L_L221  0.0020
K_K25977  L_L183  L_L222  0.0019
K_K25978  L_L183  L_L223  0.0019
K_K25979  L_L183  L_L224  0.0019
K_K25980  L_L183  L_L225  0.0018
K_K25981  L_L183  L_L226  0.0018
K_K25982  L_L183  L_L227  0.0017
K_K25983  L_L183  L_L228  0.0017
K_K25984  L_L183  L_L229  0.0017
K_K25985  L_L183  L_L230  0.0016
K_K25986  L_L183  L_L231  0.0016
K_K25987  L_L183  L_L232  0.0015
K_K25988  L_L183  L_L233  0.0015
K_K25989  L_L183  L_L234  0.0015
K_K25990  L_L183  L_L235  0.0015
K_K25991  L_L183  L_L236  0.0014
K_K25992  L_L183  L_L237  0.0014
K_K25993  L_L183  L_L238  0.0014
K_K25994  L_L183  L_L239  0.0014
K_K25995  L_L183  L_L240  0.0013
K_K25996  L_L183  L_L241  0.0013
K_K25997  L_L183  L_L242  0.0013
K_K25998  L_L183  L_L243  0.0013
K_K25999  L_L183  L_L244  0.0013
K_K26000  L_L183  L_L245  0.0012
K_K26001  L_L183  L_L246  0.0012
K_K26002  L_L183  L_L247  0.0012
K_K26003  L_L183  L_L248  0.0012
K_K26004  L_L183  L_L249  0.0011
K_K26005  L_L183  L_L250  0.0011
K_K26006  L_L183  L_L251  0.0011
K_K26007  L_L183  L_L252  0.0011
K_K26008  L_L183  L_L253  0.0011
K_K26009  L_L183  L_L254  0.0011
K_K26010  L_L183  L_L255  0.0011
K_K26011  L_L183  L_L256  0.0010
K_K26012  L_L183  L_L257  0.0010
K_K26013  L_L183  L_L258  0.0010
* *  Branch  NTMP0000000183 - NTMP0000000184
R_R184  NTMP0000000183  nU_184  32.914993m  TC=0,0
V_Ui184  nU_184  nR_184  STIMULUS=U_IND_0000000184
R_V367  nR_184  nV_367  23.280268m  TC=0,0
L_V367  nR_184  nV_367  0.014646uH
R_V368  nV_367  nV_368  7.852787m  TC=0,0
L_V368  nV_367  nV_368  0.073723uH
L_L184  nV_368  NTMP0000000184  6.519695uH
K_K26014  L_L184  L_L185  0.1050
K_K26015  L_L184  L_L186  0.0397
K_K26016  L_L184  L_L187  0.0258
K_K26017  L_L184  L_L188  0.0192
K_K26018  L_L184  L_L189  0.0153
K_K26019  L_L184  L_L190  0.0127
K_K26020  L_L184  L_L191  0.0109
K_K26021  L_L184  L_L192  0.0095
K_K26022  L_L184  L_L193  0.0084
K_K26023  L_L184  L_L194  0.0076
K_K26024  L_L184  L_L195  0.0069
K_K26025  L_L184  L_L196  0.0063
K_K26026  L_L184  L_L197  0.0058
K_K26027  L_L184  L_L198  0.0054
K_K26028  L_L184  L_L199  0.0051
K_K26029  L_L184  L_L200  0.0047
K_K26030  L_L184  L_L201  0.0045
K_K26031  L_L184  L_L202  0.0042
K_K26032  L_L184  L_L203  0.0040
K_K26033  L_L184  L_L204  0.0038
K_K26034  L_L184  L_L205  0.0036
K_K26035  L_L184  L_L206  0.0034
K_K26036  L_L184  L_L207  0.0033
K_K26037  L_L184  L_L208  0.0032
K_K26038  L_L184  L_L209  0.0030
K_K26039  L_L184  L_L210  0.0029
K_K26040  L_L184  L_L211  0.0028
K_K26041  L_L184  L_L212  0.0027
K_K26042  L_L184  L_L213  0.0026
K_K26043  L_L184  L_L214  0.0025
K_K26044  L_L184  L_L215  0.0024
K_K26045  L_L184  L_L216  0.0024
K_K26046  L_L184  L_L217  0.0023
K_K26047  L_L184  L_L218  0.0022
K_K26048  L_L184  L_L219  0.0022
K_K26049  L_L184  L_L220  0.0021
K_K26050  L_L184  L_L221  0.0020
K_K26051  L_L184  L_L222  0.0020
K_K26052  L_L184  L_L223  0.0019
K_K26053  L_L184  L_L224  0.0019
K_K26054  L_L184  L_L225  0.0019
K_K26055  L_L184  L_L226  0.0018
K_K26056  L_L184  L_L227  0.0018
K_K26057  L_L184  L_L228  0.0017
K_K26058  L_L184  L_L229  0.0017
K_K26059  L_L184  L_L230  0.0017
K_K26060  L_L184  L_L231  0.0016
K_K26061  L_L184  L_L232  0.0016
K_K26062  L_L184  L_L233  0.0015
K_K26063  L_L184  L_L234  0.0015
K_K26064  L_L184  L_L235  0.0015
K_K26065  L_L184  L_L236  0.0015
K_K26066  L_L184  L_L237  0.0014
K_K26067  L_L184  L_L238  0.0014
K_K26068  L_L184  L_L239  0.0014
K_K26069  L_L184  L_L240  0.0014
K_K26070  L_L184  L_L241  0.0013
K_K26071  L_L184  L_L242  0.0013
K_K26072  L_L184  L_L243  0.0013
K_K26073  L_L184  L_L244  0.0013
K_K26074  L_L184  L_L245  0.0013
K_K26075  L_L184  L_L246  0.0012
K_K26076  L_L184  L_L247  0.0012
K_K26077  L_L184  L_L248  0.0012
K_K26078  L_L184  L_L249  0.0012
K_K26079  L_L184  L_L250  0.0011
K_K26080  L_L184  L_L251  0.0011
K_K26081  L_L184  L_L252  0.0011
K_K26082  L_L184  L_L253  0.0011
K_K26083  L_L184  L_L254  0.0011
K_K26084  L_L184  L_L255  0.0011
K_K26085  L_L184  L_L256  0.0011
K_K26086  L_L184  L_L257  0.0010
K_K26087  L_L184  L_L258  0.0010
K_K26088  L_L184  L_L259  0.0010
* *  Branch  NTMP0000000184 - NTMP0000000185
R_R185  NTMP0000000184  nU_185  32.914993m  TC=0,0
V_Ui185  nU_185  nR_185  STIMULUS=U_IND_0000000185
R_V369  nR_185  nV_369  23.280268m  TC=0,0
L_V369  nR_185  nV_369  0.014646uH
R_V370  nV_369  nV_370  7.852787m  TC=0,0
L_V370  nV_369  nV_370  0.073723uH
L_L185  nV_370  NTMP0000000185  6.519695uH
K_K26089  L_L185  L_L186  0.1050
K_K26090  L_L185  L_L187  0.0397
K_K26091  L_L185  L_L188  0.0258
K_K26092  L_L185  L_L189  0.0192
K_K26093  L_L185  L_L190  0.0153
K_K26094  L_L185  L_L191  0.0127
K_K26095  L_L185  L_L192  0.0109
K_K26096  L_L185  L_L193  0.0095
K_K26097  L_L185  L_L194  0.0084
K_K26098  L_L185  L_L195  0.0076
K_K26099  L_L185  L_L196  0.0069
K_K26100  L_L185  L_L197  0.0063
K_K26101  L_L185  L_L198  0.0058
K_K26102  L_L185  L_L199  0.0054
K_K26103  L_L185  L_L200  0.0051
K_K26104  L_L185  L_L201  0.0047
K_K26105  L_L185  L_L202  0.0045
K_K26106  L_L185  L_L203  0.0042
K_K26107  L_L185  L_L204  0.0040
K_K26108  L_L185  L_L205  0.0038
K_K26109  L_L185  L_L206  0.0036
K_K26110  L_L185  L_L207  0.0034
K_K26111  L_L185  L_L208  0.0033
K_K26112  L_L185  L_L209  0.0032
K_K26113  L_L185  L_L210  0.0030
K_K26114  L_L185  L_L211  0.0029
K_K26115  L_L185  L_L212  0.0028
K_K26116  L_L185  L_L213  0.0027
K_K26117  L_L185  L_L214  0.0026
K_K26118  L_L185  L_L215  0.0025
K_K26119  L_L185  L_L216  0.0024
K_K26120  L_L185  L_L217  0.0024
K_K26121  L_L185  L_L218  0.0023
K_K26122  L_L185  L_L219  0.0022
K_K26123  L_L185  L_L220  0.0022
K_K26124  L_L185  L_L221  0.0021
K_K26125  L_L185  L_L222  0.0020
K_K26126  L_L185  L_L223  0.0020
K_K26127  L_L185  L_L224  0.0019
K_K26128  L_L185  L_L225  0.0019
K_K26129  L_L185  L_L226  0.0019
K_K26130  L_L185  L_L227  0.0018
K_K26131  L_L185  L_L228  0.0018
K_K26132  L_L185  L_L229  0.0017
K_K26133  L_L185  L_L230  0.0017
K_K26134  L_L185  L_L231  0.0017
K_K26135  L_L185  L_L232  0.0016
K_K26136  L_L185  L_L233  0.0016
K_K26137  L_L185  L_L234  0.0015
K_K26138  L_L185  L_L235  0.0015
K_K26139  L_L185  L_L236  0.0015
K_K26140  L_L185  L_L237  0.0015
K_K26141  L_L185  L_L238  0.0014
K_K26142  L_L185  L_L239  0.0014
K_K26143  L_L185  L_L240  0.0014
K_K26144  L_L185  L_L241  0.0014
K_K26145  L_L185  L_L242  0.0013
K_K26146  L_L185  L_L243  0.0013
K_K26147  L_L185  L_L244  0.0013
K_K26148  L_L185  L_L245  0.0013
K_K26149  L_L185  L_L246  0.0013
K_K26150  L_L185  L_L247  0.0012
K_K26151  L_L185  L_L248  0.0012
K_K26152  L_L185  L_L249  0.0012
K_K26153  L_L185  L_L250  0.0012
K_K26154  L_L185  L_L251  0.0011
K_K26155  L_L185  L_L252  0.0011
K_K26156  L_L185  L_L253  0.0011
K_K26157  L_L185  L_L254  0.0011
K_K26158  L_L185  L_L255  0.0011
K_K26159  L_L185  L_L256  0.0011
K_K26160  L_L185  L_L257  0.0011
K_K26161  L_L185  L_L258  0.0010
K_K26162  L_L185  L_L259  0.0010
K_K26163  L_L185  L_L260  0.0010
* *  Branch  NTMP0000000185 - NTMP0000000186
R_R186  NTMP0000000185  nU_186  32.914993m  TC=0,0
V_Ui186  nU_186  nR_186  STIMULUS=U_IND_0000000186
R_V371  nR_186  nV_371  23.280268m  TC=0,0
L_V371  nR_186  nV_371  0.014646uH
R_V372  nV_371  nV_372  7.852787m  TC=0,0
L_V372  nV_371  nV_372  0.073723uH
L_L186  nV_372  NTMP0000000186  6.519695uH
K_K26164  L_L186  L_L187  0.1050
K_K26165  L_L186  L_L188  0.0397
K_K26166  L_L186  L_L189  0.0258
K_K26167  L_L186  L_L190  0.0192
K_K26168  L_L186  L_L191  0.0153
K_K26169  L_L186  L_L192  0.0127
K_K26170  L_L186  L_L193  0.0109
K_K26171  L_L186  L_L194  0.0095
K_K26172  L_L186  L_L195  0.0084
K_K26173  L_L186  L_L196  0.0076
K_K26174  L_L186  L_L197  0.0069
K_K26175  L_L186  L_L198  0.0063
K_K26176  L_L186  L_L199  0.0058
K_K26177  L_L186  L_L200  0.0054
K_K26178  L_L186  L_L201  0.0051
K_K26179  L_L186  L_L202  0.0047
K_K26180  L_L186  L_L203  0.0045
K_K26181  L_L186  L_L204  0.0042
K_K26182  L_L186  L_L205  0.0040
K_K26183  L_L186  L_L206  0.0038
K_K26184  L_L186  L_L207  0.0036
K_K26185  L_L186  L_L208  0.0034
K_K26186  L_L186  L_L209  0.0033
K_K26187  L_L186  L_L210  0.0032
K_K26188  L_L186  L_L211  0.0030
K_K26189  L_L186  L_L212  0.0029
K_K26190  L_L186  L_L213  0.0028
K_K26191  L_L186  L_L214  0.0027
K_K26192  L_L186  L_L215  0.0026
K_K26193  L_L186  L_L216  0.0025
K_K26194  L_L186  L_L217  0.0024
K_K26195  L_L186  L_L218  0.0024
K_K26196  L_L186  L_L219  0.0023
K_K26197  L_L186  L_L220  0.0022
K_K26198  L_L186  L_L221  0.0022
K_K26199  L_L186  L_L222  0.0021
K_K26200  L_L186  L_L223  0.0020
K_K26201  L_L186  L_L224  0.0020
K_K26202  L_L186  L_L225  0.0019
K_K26203  L_L186  L_L226  0.0019
K_K26204  L_L186  L_L227  0.0019
K_K26205  L_L186  L_L228  0.0018
K_K26206  L_L186  L_L229  0.0018
K_K26207  L_L186  L_L230  0.0017
K_K26208  L_L186  L_L231  0.0017
K_K26209  L_L186  L_L232  0.0017
K_K26210  L_L186  L_L233  0.0016
K_K26211  L_L186  L_L234  0.0016
K_K26212  L_L186  L_L235  0.0015
K_K26213  L_L186  L_L236  0.0015
K_K26214  L_L186  L_L237  0.0015
K_K26215  L_L186  L_L238  0.0015
K_K26216  L_L186  L_L239  0.0014
K_K26217  L_L186  L_L240  0.0014
K_K26218  L_L186  L_L241  0.0014
K_K26219  L_L186  L_L242  0.0014
K_K26220  L_L186  L_L243  0.0013
K_K26221  L_L186  L_L244  0.0013
K_K26222  L_L186  L_L245  0.0013
K_K26223  L_L186  L_L246  0.0013
K_K26224  L_L186  L_L247  0.0013
K_K26225  L_L186  L_L248  0.0012
K_K26226  L_L186  L_L249  0.0012
K_K26227  L_L186  L_L250  0.0012
K_K26228  L_L186  L_L251  0.0012
K_K26229  L_L186  L_L252  0.0011
K_K26230  L_L186  L_L253  0.0011
K_K26231  L_L186  L_L254  0.0011
K_K26232  L_L186  L_L255  0.0011
K_K26233  L_L186  L_L256  0.0011
K_K26234  L_L186  L_L257  0.0011
K_K26235  L_L186  L_L258  0.0011
K_K26236  L_L186  L_L259  0.0010
K_K26237  L_L186  L_L260  0.0010
K_K26238  L_L186  L_L261  0.0010
* *  Branch  NTMP0000000186 - NTMP0000000187
R_R187  NTMP0000000186  nU_187  32.914993m  TC=0,0
V_Ui187  nU_187  nR_187  STIMULUS=U_IND_0000000187
R_V373  nR_187  nV_373  23.280268m  TC=0,0
L_V373  nR_187  nV_373  0.014646uH
R_V374  nV_373  nV_374  7.852787m  TC=0,0
L_V374  nV_373  nV_374  0.073723uH
L_L187  nV_374  NTMP0000000187  6.519695uH
K_K26239  L_L187  L_L188  0.1050
K_K26240  L_L187  L_L189  0.0397
K_K26241  L_L187  L_L190  0.0258
K_K26242  L_L187  L_L191  0.0192
K_K26243  L_L187  L_L192  0.0153
K_K26244  L_L187  L_L193  0.0127
K_K26245  L_L187  L_L194  0.0109
K_K26246  L_L187  L_L195  0.0095
K_K26247  L_L187  L_L196  0.0084
K_K26248  L_L187  L_L197  0.0076
K_K26249  L_L187  L_L198  0.0069
K_K26250  L_L187  L_L199  0.0063
K_K26251  L_L187  L_L200  0.0058
K_K26252  L_L187  L_L201  0.0054
K_K26253  L_L187  L_L202  0.0051
K_K26254  L_L187  L_L203  0.0047
K_K26255  L_L187  L_L204  0.0045
K_K26256  L_L187  L_L205  0.0042
K_K26257  L_L187  L_L206  0.0040
K_K26258  L_L187  L_L207  0.0038
K_K26259  L_L187  L_L208  0.0036
K_K26260  L_L187  L_L209  0.0034
K_K26261  L_L187  L_L210  0.0033
K_K26262  L_L187  L_L211  0.0032
K_K26263  L_L187  L_L212  0.0030
K_K26264  L_L187  L_L213  0.0029
K_K26265  L_L187  L_L214  0.0028
K_K26266  L_L187  L_L215  0.0027
K_K26267  L_L187  L_L216  0.0026
K_K26268  L_L187  L_L217  0.0025
K_K26269  L_L187  L_L218  0.0024
K_K26270  L_L187  L_L219  0.0024
K_K26271  L_L187  L_L220  0.0023
K_K26272  L_L187  L_L221  0.0022
K_K26273  L_L187  L_L222  0.0022
K_K26274  L_L187  L_L223  0.0021
K_K26275  L_L187  L_L224  0.0020
K_K26276  L_L187  L_L225  0.0020
K_K26277  L_L187  L_L226  0.0019
K_K26278  L_L187  L_L227  0.0019
K_K26279  L_L187  L_L228  0.0019
K_K26280  L_L187  L_L229  0.0018
K_K26281  L_L187  L_L230  0.0018
K_K26282  L_L187  L_L231  0.0017
K_K26283  L_L187  L_L232  0.0017
K_K26284  L_L187  L_L233  0.0017
K_K26285  L_L187  L_L234  0.0016
K_K26286  L_L187  L_L235  0.0016
K_K26287  L_L187  L_L236  0.0015
K_K26288  L_L187  L_L237  0.0015
K_K26289  L_L187  L_L238  0.0015
K_K26290  L_L187  L_L239  0.0015
K_K26291  L_L187  L_L240  0.0014
K_K26292  L_L187  L_L241  0.0014
K_K26293  L_L187  L_L242  0.0014
K_K26294  L_L187  L_L243  0.0014
K_K26295  L_L187  L_L244  0.0013
K_K26296  L_L187  L_L245  0.0013
K_K26297  L_L187  L_L246  0.0013
K_K26298  L_L187  L_L247  0.0013
K_K26299  L_L187  L_L248  0.0013
K_K26300  L_L187  L_L249  0.0012
K_K26301  L_L187  L_L250  0.0012
K_K26302  L_L187  L_L251  0.0012
K_K26303  L_L187  L_L252  0.0012
K_K26304  L_L187  L_L253  0.0011
K_K26305  L_L187  L_L254  0.0011
K_K26306  L_L187  L_L255  0.0011
K_K26307  L_L187  L_L256  0.0011
K_K26308  L_L187  L_L257  0.0011
K_K26309  L_L187  L_L258  0.0011
K_K26310  L_L187  L_L259  0.0011
K_K26311  L_L187  L_L260  0.0010
K_K26312  L_L187  L_L261  0.0010
K_K26313  L_L187  L_L262  0.0010
* *  Branch  NTMP0000000187 - NTMP0000000188
R_R188  NTMP0000000187  nU_188  32.914993m  TC=0,0
V_Ui188  nU_188  nR_188  STIMULUS=U_IND_0000000188
R_V375  nR_188  nV_375  23.280268m  TC=0,0
L_V375  nR_188  nV_375  0.014646uH
R_V376  nV_375  nV_376  7.852787m  TC=0,0
L_V376  nV_375  nV_376  0.073723uH
L_L188  nV_376  NTMP0000000188  6.519695uH
K_K26314  L_L188  L_L189  0.1050
K_K26315  L_L188  L_L190  0.0397
K_K26316  L_L188  L_L191  0.0258
K_K26317  L_L188  L_L192  0.0192
K_K26318  L_L188  L_L193  0.0153
K_K26319  L_L188  L_L194  0.0127
K_K26320  L_L188  L_L195  0.0109
K_K26321  L_L188  L_L196  0.0095
K_K26322  L_L188  L_L197  0.0084
K_K26323  L_L188  L_L198  0.0076
K_K26324  L_L188  L_L199  0.0069
K_K26325  L_L188  L_L200  0.0063
K_K26326  L_L188  L_L201  0.0058
K_K26327  L_L188  L_L202  0.0054
K_K26328  L_L188  L_L203  0.0051
K_K26329  L_L188  L_L204  0.0047
K_K26330  L_L188  L_L205  0.0045
K_K26331  L_L188  L_L206  0.0042
K_K26332  L_L188  L_L207  0.0040
K_K26333  L_L188  L_L208  0.0038
K_K26334  L_L188  L_L209  0.0036
K_K26335  L_L188  L_L210  0.0034
K_K26336  L_L188  L_L211  0.0033
K_K26337  L_L188  L_L212  0.0032
K_K26338  L_L188  L_L213  0.0030
K_K26339  L_L188  L_L214  0.0029
K_K26340  L_L188  L_L215  0.0028
K_K26341  L_L188  L_L216  0.0027
K_K26342  L_L188  L_L217  0.0026
K_K26343  L_L188  L_L218  0.0025
K_K26344  L_L188  L_L219  0.0024
K_K26345  L_L188  L_L220  0.0024
K_K26346  L_L188  L_L221  0.0023
K_K26347  L_L188  L_L222  0.0022
K_K26348  L_L188  L_L223  0.0022
K_K26349  L_L188  L_L224  0.0021
K_K26350  L_L188  L_L225  0.0020
K_K26351  L_L188  L_L226  0.0020
K_K26352  L_L188  L_L227  0.0019
K_K26353  L_L188  L_L228  0.0019
K_K26354  L_L188  L_L229  0.0019
K_K26355  L_L188  L_L230  0.0018
K_K26356  L_L188  L_L231  0.0018
K_K26357  L_L188  L_L232  0.0017
K_K26358  L_L188  L_L233  0.0017
K_K26359  L_L188  L_L234  0.0017
K_K26360  L_L188  L_L235  0.0016
K_K26361  L_L188  L_L236  0.0016
K_K26362  L_L188  L_L237  0.0015
K_K26363  L_L188  L_L238  0.0015
K_K26364  L_L188  L_L239  0.0015
K_K26365  L_L188  L_L240  0.0015
K_K26366  L_L188  L_L241  0.0014
K_K26367  L_L188  L_L242  0.0014
K_K26368  L_L188  L_L243  0.0014
K_K26369  L_L188  L_L244  0.0014
K_K26370  L_L188  L_L245  0.0013
K_K26371  L_L188  L_L246  0.0013
K_K26372  L_L188  L_L247  0.0013
K_K26373  L_L188  L_L248  0.0013
K_K26374  L_L188  L_L249  0.0013
K_K26375  L_L188  L_L250  0.0012
K_K26376  L_L188  L_L251  0.0012
K_K26377  L_L188  L_L252  0.0012
K_K26378  L_L188  L_L253  0.0012
K_K26379  L_L188  L_L254  0.0011
K_K26380  L_L188  L_L255  0.0011
K_K26381  L_L188  L_L256  0.0011
K_K26382  L_L188  L_L257  0.0011
K_K26383  L_L188  L_L258  0.0011
K_K26384  L_L188  L_L259  0.0011
K_K26385  L_L188  L_L260  0.0011
K_K26386  L_L188  L_L261  0.0010
K_K26387  L_L188  L_L262  0.0010
K_K26388  L_L188  L_L263  0.0010
* *  Branch  NTMP0000000188 - NTMP0000000189
R_R189  NTMP0000000188  nU_189  32.914993m  TC=0,0
V_Ui189  nU_189  nR_189  STIMULUS=U_IND_0000000189
R_V377  nR_189  nV_377  23.280268m  TC=0,0
L_V377  nR_189  nV_377  0.014646uH
R_V378  nV_377  nV_378  7.852787m  TC=0,0
L_V378  nV_377  nV_378  0.073723uH
L_L189  nV_378  NTMP0000000189  6.519695uH
K_K26389  L_L189  L_L190  0.1050
K_K26390  L_L189  L_L191  0.0397
K_K26391  L_L189  L_L192  0.0258
K_K26392  L_L189  L_L193  0.0192
K_K26393  L_L189  L_L194  0.0153
K_K26394  L_L189  L_L195  0.0127
K_K26395  L_L189  L_L196  0.0109
K_K26396  L_L189  L_L197  0.0095
K_K26397  L_L189  L_L198  0.0084
K_K26398  L_L189  L_L199  0.0076
K_K26399  L_L189  L_L200  0.0069
K_K26400  L_L189  L_L201  0.0063
K_K26401  L_L189  L_L202  0.0058
K_K26402  L_L189  L_L203  0.0054
K_K26403  L_L189  L_L204  0.0051
K_K26404  L_L189  L_L205  0.0047
K_K26405  L_L189  L_L206  0.0045
K_K26406  L_L189  L_L207  0.0042
K_K26407  L_L189  L_L208  0.0040
K_K26408  L_L189  L_L209  0.0038
K_K26409  L_L189  L_L210  0.0036
K_K26410  L_L189  L_L211  0.0034
K_K26411  L_L189  L_L212  0.0033
K_K26412  L_L189  L_L213  0.0032
K_K26413  L_L189  L_L214  0.0030
K_K26414  L_L189  L_L215  0.0029
K_K26415  L_L189  L_L216  0.0028
K_K26416  L_L189  L_L217  0.0027
K_K26417  L_L189  L_L218  0.0026
K_K26418  L_L189  L_L219  0.0025
K_K26419  L_L189  L_L220  0.0024
K_K26420  L_L189  L_L221  0.0024
K_K26421  L_L189  L_L222  0.0023
K_K26422  L_L189  L_L223  0.0022
K_K26423  L_L189  L_L224  0.0022
K_K26424  L_L189  L_L225  0.0021
K_K26425  L_L189  L_L226  0.0020
K_K26426  L_L189  L_L227  0.0020
K_K26427  L_L189  L_L228  0.0019
K_K26428  L_L189  L_L229  0.0019
K_K26429  L_L189  L_L230  0.0019
K_K26430  L_L189  L_L231  0.0018
K_K26431  L_L189  L_L232  0.0018
K_K26432  L_L189  L_L233  0.0017
K_K26433  L_L189  L_L234  0.0017
K_K26434  L_L189  L_L235  0.0017
K_K26435  L_L189  L_L236  0.0016
K_K26436  L_L189  L_L237  0.0016
K_K26437  L_L189  L_L238  0.0015
K_K26438  L_L189  L_L239  0.0015
K_K26439  L_L189  L_L240  0.0015
K_K26440  L_L189  L_L241  0.0015
K_K26441  L_L189  L_L242  0.0014
K_K26442  L_L189  L_L243  0.0014
K_K26443  L_L189  L_L244  0.0014
K_K26444  L_L189  L_L245  0.0014
K_K26445  L_L189  L_L246  0.0013
K_K26446  L_L189  L_L247  0.0013
K_K26447  L_L189  L_L248  0.0013
K_K26448  L_L189  L_L249  0.0013
K_K26449  L_L189  L_L250  0.0013
K_K26450  L_L189  L_L251  0.0012
K_K26451  L_L189  L_L252  0.0012
K_K26452  L_L189  L_L253  0.0012
K_K26453  L_L189  L_L254  0.0012
K_K26454  L_L189  L_L255  0.0011
K_K26455  L_L189  L_L256  0.0011
K_K26456  L_L189  L_L257  0.0011
K_K26457  L_L189  L_L258  0.0011
K_K26458  L_L189  L_L259  0.0011
K_K26459  L_L189  L_L260  0.0011
K_K26460  L_L189  L_L261  0.0011
K_K26461  L_L189  L_L262  0.0010
K_K26462  L_L189  L_L263  0.0010
K_K26463  L_L189  L_L264  0.0010
* *  Branch  NTMP0000000189 - NTMP0000000190
R_R190  NTMP0000000189  nU_190  32.914993m  TC=0,0
V_Ui190  nU_190  nR_190  STIMULUS=U_IND_0000000190
R_V379  nR_190  nV_379  23.280268m  TC=0,0
L_V379  nR_190  nV_379  0.014646uH
R_V380  nV_379  nV_380  7.852787m  TC=0,0
L_V380  nV_379  nV_380  0.073723uH
L_L190  nV_380  NTMP0000000190  6.519695uH
K_K26464  L_L190  L_L191  0.1050
K_K26465  L_L190  L_L192  0.0397
K_K26466  L_L190  L_L193  0.0258
K_K26467  L_L190  L_L194  0.0192
K_K26468  L_L190  L_L195  0.0153
K_K26469  L_L190  L_L196  0.0127
K_K26470  L_L190  L_L197  0.0109
K_K26471  L_L190  L_L198  0.0095
K_K26472  L_L190  L_L199  0.0084
K_K26473  L_L190  L_L200  0.0076
K_K26474  L_L190  L_L201  0.0069
K_K26475  L_L190  L_L202  0.0063
K_K26476  L_L190  L_L203  0.0058
K_K26477  L_L190  L_L204  0.0054
K_K26478  L_L190  L_L205  0.0051
K_K26479  L_L190  L_L206  0.0047
K_K26480  L_L190  L_L207  0.0045
K_K26481  L_L190  L_L208  0.0042
K_K26482  L_L190  L_L209  0.0040
K_K26483  L_L190  L_L210  0.0038
K_K26484  L_L190  L_L211  0.0036
K_K26485  L_L190  L_L212  0.0034
K_K26486  L_L190  L_L213  0.0033
K_K26487  L_L190  L_L214  0.0032
K_K26488  L_L190  L_L215  0.0030
K_K26489  L_L190  L_L216  0.0029
K_K26490  L_L190  L_L217  0.0028
K_K26491  L_L190  L_L218  0.0027
K_K26492  L_L190  L_L219  0.0026
K_K26493  L_L190  L_L220  0.0025
K_K26494  L_L190  L_L221  0.0024
K_K26495  L_L190  L_L222  0.0024
K_K26496  L_L190  L_L223  0.0023
K_K26497  L_L190  L_L224  0.0022
K_K26498  L_L190  L_L225  0.0022
K_K26499  L_L190  L_L226  0.0021
K_K26500  L_L190  L_L227  0.0020
K_K26501  L_L190  L_L228  0.0020
K_K26502  L_L190  L_L229  0.0019
K_K26503  L_L190  L_L230  0.0019
K_K26504  L_L190  L_L231  0.0019
K_K26505  L_L190  L_L232  0.0018
K_K26506  L_L190  L_L233  0.0018
K_K26507  L_L190  L_L234  0.0017
K_K26508  L_L190  L_L235  0.0017
K_K26509  L_L190  L_L236  0.0017
K_K26510  L_L190  L_L237  0.0016
K_K26511  L_L190  L_L238  0.0016
K_K26512  L_L190  L_L239  0.0015
K_K26513  L_L190  L_L240  0.0015
K_K26514  L_L190  L_L241  0.0015
K_K26515  L_L190  L_L242  0.0015
K_K26516  L_L190  L_L243  0.0014
K_K26517  L_L190  L_L244  0.0014
K_K26518  L_L190  L_L245  0.0014
K_K26519  L_L190  L_L246  0.0014
K_K26520  L_L190  L_L247  0.0013
K_K26521  L_L190  L_L248  0.0013
K_K26522  L_L190  L_L249  0.0013
K_K26523  L_L190  L_L250  0.0013
K_K26524  L_L190  L_L251  0.0013
K_K26525  L_L190  L_L252  0.0012
K_K26526  L_L190  L_L253  0.0012
K_K26527  L_L190  L_L254  0.0012
K_K26528  L_L190  L_L255  0.0012
K_K26529  L_L190  L_L256  0.0011
K_K26530  L_L190  L_L257  0.0011
K_K26531  L_L190  L_L258  0.0011
K_K26532  L_L190  L_L259  0.0011
K_K26533  L_L190  L_L260  0.0011
K_K26534  L_L190  L_L261  0.0011
K_K26535  L_L190  L_L262  0.0011
K_K26536  L_L190  L_L263  0.0010
K_K26537  L_L190  L_L264  0.0010
K_K26538  L_L190  L_L265  0.0010
* *  Branch  NTMP0000000190 - NTMP0000000191
R_R191  NTMP0000000190  nU_191  32.914993m  TC=0,0
V_Ui191  nU_191  nR_191  STIMULUS=U_IND_0000000191
R_V381  nR_191  nV_381  23.280268m  TC=0,0
L_V381  nR_191  nV_381  0.014646uH
R_V382  nV_381  nV_382  7.852787m  TC=0,0
L_V382  nV_381  nV_382  0.073723uH
L_L191  nV_382  NTMP0000000191  6.519695uH
K_K26539  L_L191  L_L192  0.1050
K_K26540  L_L191  L_L193  0.0397
K_K26541  L_L191  L_L194  0.0258
K_K26542  L_L191  L_L195  0.0192
K_K26543  L_L191  L_L196  0.0153
K_K26544  L_L191  L_L197  0.0127
K_K26545  L_L191  L_L198  0.0109
K_K26546  L_L191  L_L199  0.0095
K_K26547  L_L191  L_L200  0.0084
K_K26548  L_L191  L_L201  0.0076
K_K26549  L_L191  L_L202  0.0069
K_K26550  L_L191  L_L203  0.0063
K_K26551  L_L191  L_L204  0.0058
K_K26552  L_L191  L_L205  0.0054
K_K26553  L_L191  L_L206  0.0051
K_K26554  L_L191  L_L207  0.0047
K_K26555  L_L191  L_L208  0.0045
K_K26556  L_L191  L_L209  0.0042
K_K26557  L_L191  L_L210  0.0040
K_K26558  L_L191  L_L211  0.0038
K_K26559  L_L191  L_L212  0.0036
K_K26560  L_L191  L_L213  0.0034
K_K26561  L_L191  L_L214  0.0033
K_K26562  L_L191  L_L215  0.0032
K_K26563  L_L191  L_L216  0.0030
K_K26564  L_L191  L_L217  0.0029
K_K26565  L_L191  L_L218  0.0028
K_K26566  L_L191  L_L219  0.0027
K_K26567  L_L191  L_L220  0.0026
K_K26568  L_L191  L_L221  0.0025
K_K26569  L_L191  L_L222  0.0024
K_K26570  L_L191  L_L223  0.0024
K_K26571  L_L191  L_L224  0.0023
K_K26572  L_L191  L_L225  0.0022
K_K26573  L_L191  L_L226  0.0022
K_K26574  L_L191  L_L227  0.0021
K_K26575  L_L191  L_L228  0.0020
K_K26576  L_L191  L_L229  0.0020
K_K26577  L_L191  L_L230  0.0019
K_K26578  L_L191  L_L231  0.0019
K_K26579  L_L191  L_L232  0.0019
K_K26580  L_L191  L_L233  0.0018
K_K26581  L_L191  L_L234  0.0018
K_K26582  L_L191  L_L235  0.0017
K_K26583  L_L191  L_L236  0.0017
K_K26584  L_L191  L_L237  0.0017
K_K26585  L_L191  L_L238  0.0016
K_K26586  L_L191  L_L239  0.0016
K_K26587  L_L191  L_L240  0.0015
K_K26588  L_L191  L_L241  0.0015
K_K26589  L_L191  L_L242  0.0015
K_K26590  L_L191  L_L243  0.0015
K_K26591  L_L191  L_L244  0.0014
K_K26592  L_L191  L_L245  0.0014
K_K26593  L_L191  L_L246  0.0014
K_K26594  L_L191  L_L247  0.0014
K_K26595  L_L191  L_L248  0.0013
K_K26596  L_L191  L_L249  0.0013
K_K26597  L_L191  L_L250  0.0013
K_K26598  L_L191  L_L251  0.0013
K_K26599  L_L191  L_L252  0.0013
K_K26600  L_L191  L_L253  0.0012
K_K26601  L_L191  L_L254  0.0012
K_K26602  L_L191  L_L255  0.0012
K_K26603  L_L191  L_L256  0.0012
K_K26604  L_L191  L_L257  0.0011
K_K26605  L_L191  L_L258  0.0011
K_K26606  L_L191  L_L259  0.0011
K_K26607  L_L191  L_L260  0.0011
K_K26608  L_L191  L_L261  0.0011
K_K26609  L_L191  L_L262  0.0011
K_K26610  L_L191  L_L263  0.0011
K_K26611  L_L191  L_L264  0.0010
K_K26612  L_L191  L_L265  0.0010
K_K26613  L_L191  L_L266  0.0010
* *  Branch  NTMP0000000191 - NTMP0000000192
R_R192  NTMP0000000191  nU_192  32.914993m  TC=0,0
V_Ui192  nU_192  nR_192  STIMULUS=U_IND_0000000192
R_V383  nR_192  nV_383  23.280268m  TC=0,0
L_V383  nR_192  nV_383  0.014646uH
R_V384  nV_383  nV_384  7.852787m  TC=0,0
L_V384  nV_383  nV_384  0.073723uH
L_L192  nV_384  NTMP0000000192  6.519695uH
K_K26614  L_L192  L_L193  0.1050
K_K26615  L_L192  L_L194  0.0397
K_K26616  L_L192  L_L195  0.0258
K_K26617  L_L192  L_L196  0.0192
K_K26618  L_L192  L_L197  0.0153
K_K26619  L_L192  L_L198  0.0127
K_K26620  L_L192  L_L199  0.0109
K_K26621  L_L192  L_L200  0.0095
K_K26622  L_L192  L_L201  0.0084
K_K26623  L_L192  L_L202  0.0076
K_K26624  L_L192  L_L203  0.0069
K_K26625  L_L192  L_L204  0.0063
K_K26626  L_L192  L_L205  0.0058
K_K26627  L_L192  L_L206  0.0054
K_K26628  L_L192  L_L207  0.0051
K_K26629  L_L192  L_L208  0.0047
K_K26630  L_L192  L_L209  0.0045
K_K26631  L_L192  L_L210  0.0042
K_K26632  L_L192  L_L211  0.0040
K_K26633  L_L192  L_L212  0.0038
K_K26634  L_L192  L_L213  0.0036
K_K26635  L_L192  L_L214  0.0034
K_K26636  L_L192  L_L215  0.0033
K_K26637  L_L192  L_L216  0.0032
K_K26638  L_L192  L_L217  0.0030
K_K26639  L_L192  L_L218  0.0029
K_K26640  L_L192  L_L219  0.0028
K_K26641  L_L192  L_L220  0.0027
K_K26642  L_L192  L_L221  0.0026
K_K26643  L_L192  L_L222  0.0025
K_K26644  L_L192  L_L223  0.0024
K_K26645  L_L192  L_L224  0.0024
K_K26646  L_L192  L_L225  0.0023
K_K26647  L_L192  L_L226  0.0022
K_K26648  L_L192  L_L227  0.0022
K_K26649  L_L192  L_L228  0.0021
K_K26650  L_L192  L_L229  0.0020
K_K26651  L_L192  L_L230  0.0020
K_K26652  L_L192  L_L231  0.0019
K_K26653  L_L192  L_L232  0.0019
K_K26654  L_L192  L_L233  0.0019
K_K26655  L_L192  L_L234  0.0018
K_K26656  L_L192  L_L235  0.0018
K_K26657  L_L192  L_L236  0.0017
K_K26658  L_L192  L_L237  0.0017
K_K26659  L_L192  L_L238  0.0017
K_K26660  L_L192  L_L239  0.0016
K_K26661  L_L192  L_L240  0.0016
K_K26662  L_L192  L_L241  0.0015
K_K26663  L_L192  L_L242  0.0015
K_K26664  L_L192  L_L243  0.0015
K_K26665  L_L192  L_L244  0.0015
K_K26666  L_L192  L_L245  0.0014
K_K26667  L_L192  L_L246  0.0014
K_K26668  L_L192  L_L247  0.0014
K_K26669  L_L192  L_L248  0.0014
K_K26670  L_L192  L_L249  0.0013
K_K26671  L_L192  L_L250  0.0013
K_K26672  L_L192  L_L251  0.0013
K_K26673  L_L192  L_L252  0.0013
K_K26674  L_L192  L_L253  0.0013
K_K26675  L_L192  L_L254  0.0012
K_K26676  L_L192  L_L255  0.0012
K_K26677  L_L192  L_L256  0.0012
K_K26678  L_L192  L_L257  0.0012
K_K26679  L_L192  L_L258  0.0011
K_K26680  L_L192  L_L259  0.0011
K_K26681  L_L192  L_L260  0.0011
K_K26682  L_L192  L_L261  0.0011
K_K26683  L_L192  L_L262  0.0011
K_K26684  L_L192  L_L263  0.0011
K_K26685  L_L192  L_L264  0.0011
K_K26686  L_L192  L_L265  0.0010
K_K26687  L_L192  L_L266  0.0010
K_K26688  L_L192  L_L267  0.0010
* *  Branch  NTMP0000000192 - NTMP0000000193
R_R193  NTMP0000000192  nU_193  32.914993m  TC=0,0
V_Ui193  nU_193  nR_193  STIMULUS=U_IND_0000000193
R_V385  nR_193  nV_385  23.280268m  TC=0,0
L_V385  nR_193  nV_385  0.014646uH
R_V386  nV_385  nV_386  7.852787m  TC=0,0
L_V386  nV_385  nV_386  0.073723uH
L_L193  nV_386  NTMP0000000193  6.519695uH
K_K26689  L_L193  L_L194  0.1050
K_K26690  L_L193  L_L195  0.0397
K_K26691  L_L193  L_L196  0.0258
K_K26692  L_L193  L_L197  0.0192
K_K26693  L_L193  L_L198  0.0153
K_K26694  L_L193  L_L199  0.0127
K_K26695  L_L193  L_L200  0.0109
K_K26696  L_L193  L_L201  0.0095
K_K26697  L_L193  L_L202  0.0084
K_K26698  L_L193  L_L203  0.0076
K_K26699  L_L193  L_L204  0.0069
K_K26700  L_L193  L_L205  0.0063
K_K26701  L_L193  L_L206  0.0058
K_K26702  L_L193  L_L207  0.0054
K_K26703  L_L193  L_L208  0.0051
K_K26704  L_L193  L_L209  0.0047
K_K26705  L_L193  L_L210  0.0045
K_K26706  L_L193  L_L211  0.0042
K_K26707  L_L193  L_L212  0.0040
K_K26708  L_L193  L_L213  0.0038
K_K26709  L_L193  L_L214  0.0036
K_K26710  L_L193  L_L215  0.0034
K_K26711  L_L193  L_L216  0.0033
K_K26712  L_L193  L_L217  0.0032
K_K26713  L_L193  L_L218  0.0030
K_K26714  L_L193  L_L219  0.0029
K_K26715  L_L193  L_L220  0.0028
K_K26716  L_L193  L_L221  0.0027
K_K26717  L_L193  L_L222  0.0026
K_K26718  L_L193  L_L223  0.0025
K_K26719  L_L193  L_L224  0.0024
K_K26720  L_L193  L_L225  0.0024
K_K26721  L_L193  L_L226  0.0023
K_K26722  L_L193  L_L227  0.0022
K_K26723  L_L193  L_L228  0.0022
K_K26724  L_L193  L_L229  0.0021
K_K26725  L_L193  L_L230  0.0020
K_K26726  L_L193  L_L231  0.0020
K_K26727  L_L193  L_L232  0.0019
K_K26728  L_L193  L_L233  0.0019
K_K26729  L_L193  L_L234  0.0019
K_K26730  L_L193  L_L235  0.0018
K_K26731  L_L193  L_L236  0.0018
K_K26732  L_L193  L_L237  0.0017
K_K26733  L_L193  L_L238  0.0017
K_K26734  L_L193  L_L239  0.0017
K_K26735  L_L193  L_L240  0.0016
K_K26736  L_L193  L_L241  0.0016
K_K26737  L_L193  L_L242  0.0015
K_K26738  L_L193  L_L243  0.0015
K_K26739  L_L193  L_L244  0.0015
K_K26740  L_L193  L_L245  0.0015
K_K26741  L_L193  L_L246  0.0014
K_K26742  L_L193  L_L247  0.0014
K_K26743  L_L193  L_L248  0.0014
K_K26744  L_L193  L_L249  0.0014
K_K26745  L_L193  L_L250  0.0013
K_K26746  L_L193  L_L251  0.0013
K_K26747  L_L193  L_L252  0.0013
K_K26748  L_L193  L_L253  0.0013
K_K26749  L_L193  L_L254  0.0013
K_K26750  L_L193  L_L255  0.0012
K_K26751  L_L193  L_L256  0.0012
K_K26752  L_L193  L_L257  0.0012
K_K26753  L_L193  L_L258  0.0012
K_K26754  L_L193  L_L259  0.0011
K_K26755  L_L193  L_L260  0.0011
K_K26756  L_L193  L_L261  0.0011
K_K26757  L_L193  L_L262  0.0011
K_K26758  L_L193  L_L263  0.0011
K_K26759  L_L193  L_L264  0.0011
K_K26760  L_L193  L_L265  0.0011
K_K26761  L_L193  L_L266  0.0010
K_K26762  L_L193  L_L267  0.0010
K_K26763  L_L193  L_L268  0.0010
* *  Branch  NTMP0000000193 - NTMP0000000194
R_R194  NTMP0000000193  nU_194  32.914993m  TC=0,0
V_Ui194  nU_194  nR_194  STIMULUS=U_IND_0000000194
R_V387  nR_194  nV_387  23.280268m  TC=0,0
L_V387  nR_194  nV_387  0.014646uH
R_V388  nV_387  nV_388  7.852787m  TC=0,0
L_V388  nV_387  nV_388  0.073723uH
L_L194  nV_388  NTMP0000000194  6.519695uH
K_K26764  L_L194  L_L195  0.1050
K_K26765  L_L194  L_L196  0.0397
K_K26766  L_L194  L_L197  0.0258
K_K26767  L_L194  L_L198  0.0192
K_K26768  L_L194  L_L199  0.0153
K_K26769  L_L194  L_L200  0.0127
K_K26770  L_L194  L_L201  0.0109
K_K26771  L_L194  L_L202  0.0095
K_K26772  L_L194  L_L203  0.0084
K_K26773  L_L194  L_L204  0.0076
K_K26774  L_L194  L_L205  0.0069
K_K26775  L_L194  L_L206  0.0063
K_K26776  L_L194  L_L207  0.0058
K_K26777  L_L194  L_L208  0.0054
K_K26778  L_L194  L_L209  0.0051
K_K26779  L_L194  L_L210  0.0047
K_K26780  L_L194  L_L211  0.0045
K_K26781  L_L194  L_L212  0.0042
K_K26782  L_L194  L_L213  0.0040
K_K26783  L_L194  L_L214  0.0038
K_K26784  L_L194  L_L215  0.0036
K_K26785  L_L194  L_L216  0.0034
K_K26786  L_L194  L_L217  0.0033
K_K26787  L_L194  L_L218  0.0032
K_K26788  L_L194  L_L219  0.0030
K_K26789  L_L194  L_L220  0.0029
K_K26790  L_L194  L_L221  0.0028
K_K26791  L_L194  L_L222  0.0027
K_K26792  L_L194  L_L223  0.0026
K_K26793  L_L194  L_L224  0.0025
K_K26794  L_L194  L_L225  0.0024
K_K26795  L_L194  L_L226  0.0024
K_K26796  L_L194  L_L227  0.0023
K_K26797  L_L194  L_L228  0.0022
K_K26798  L_L194  L_L229  0.0022
K_K26799  L_L194  L_L230  0.0021
K_K26800  L_L194  L_L231  0.0020
K_K26801  L_L194  L_L232  0.0020
K_K26802  L_L194  L_L233  0.0019
K_K26803  L_L194  L_L234  0.0019
K_K26804  L_L194  L_L235  0.0019
K_K26805  L_L194  L_L236  0.0018
K_K26806  L_L194  L_L237  0.0018
K_K26807  L_L194  L_L238  0.0017
K_K26808  L_L194  L_L239  0.0017
K_K26809  L_L194  L_L240  0.0017
K_K26810  L_L194  L_L241  0.0016
K_K26811  L_L194  L_L242  0.0016
K_K26812  L_L194  L_L243  0.0015
K_K26813  L_L194  L_L244  0.0015
K_K26814  L_L194  L_L245  0.0015
K_K26815  L_L194  L_L246  0.0015
K_K26816  L_L194  L_L247  0.0014
K_K26817  L_L194  L_L248  0.0014
K_K26818  L_L194  L_L249  0.0014
K_K26819  L_L194  L_L250  0.0014
K_K26820  L_L194  L_L251  0.0013
K_K26821  L_L194  L_L252  0.0013
K_K26822  L_L194  L_L253  0.0013
K_K26823  L_L194  L_L254  0.0013
K_K26824  L_L194  L_L255  0.0013
K_K26825  L_L194  L_L256  0.0012
K_K26826  L_L194  L_L257  0.0012
K_K26827  L_L194  L_L258  0.0012
K_K26828  L_L194  L_L259  0.0012
K_K26829  L_L194  L_L260  0.0011
K_K26830  L_L194  L_L261  0.0011
K_K26831  L_L194  L_L262  0.0011
K_K26832  L_L194  L_L263  0.0011
K_K26833  L_L194  L_L264  0.0011
K_K26834  L_L194  L_L265  0.0011
K_K26835  L_L194  L_L266  0.0011
K_K26836  L_L194  L_L267  0.0010
K_K26837  L_L194  L_L268  0.0010
K_K26838  L_L194  L_L269  0.0010
* *  Branch  NTMP0000000194 - NTMP0000000195
R_R195  NTMP0000000194  nU_195  32.914993m  TC=0,0
V_Ui195  nU_195  nR_195  STIMULUS=U_IND_0000000195
R_V389  nR_195  nV_389  23.280268m  TC=0,0
L_V389  nR_195  nV_389  0.014646uH
R_V390  nV_389  nV_390  7.852787m  TC=0,0
L_V390  nV_389  nV_390  0.073723uH
L_L195  nV_390  NTMP0000000195  6.519695uH
K_K26839  L_L195  L_L196  0.1050
K_K26840  L_L195  L_L197  0.0397
K_K26841  L_L195  L_L198  0.0258
K_K26842  L_L195  L_L199  0.0192
K_K26843  L_L195  L_L200  0.0153
K_K26844  L_L195  L_L201  0.0127
K_K26845  L_L195  L_L202  0.0109
K_K26846  L_L195  L_L203  0.0095
K_K26847  L_L195  L_L204  0.0084
K_K26848  L_L195  L_L205  0.0076
K_K26849  L_L195  L_L206  0.0069
K_K26850  L_L195  L_L207  0.0063
K_K26851  L_L195  L_L208  0.0058
K_K26852  L_L195  L_L209  0.0054
K_K26853  L_L195  L_L210  0.0051
K_K26854  L_L195  L_L211  0.0047
K_K26855  L_L195  L_L212  0.0045
K_K26856  L_L195  L_L213  0.0042
K_K26857  L_L195  L_L214  0.0040
K_K26858  L_L195  L_L215  0.0038
K_K26859  L_L195  L_L216  0.0036
K_K26860  L_L195  L_L217  0.0034
K_K26861  L_L195  L_L218  0.0033
K_K26862  L_L195  L_L219  0.0032
K_K26863  L_L195  L_L220  0.0030
K_K26864  L_L195  L_L221  0.0029
K_K26865  L_L195  L_L222  0.0028
K_K26866  L_L195  L_L223  0.0027
K_K26867  L_L195  L_L224  0.0026
K_K26868  L_L195  L_L225  0.0025
K_K26869  L_L195  L_L226  0.0024
K_K26870  L_L195  L_L227  0.0024
K_K26871  L_L195  L_L228  0.0023
K_K26872  L_L195  L_L229  0.0022
K_K26873  L_L195  L_L230  0.0022
K_K26874  L_L195  L_L231  0.0021
K_K26875  L_L195  L_L232  0.0020
K_K26876  L_L195  L_L233  0.0020
K_K26877  L_L195  L_L234  0.0019
K_K26878  L_L195  L_L235  0.0019
K_K26879  L_L195  L_L236  0.0019
K_K26880  L_L195  L_L237  0.0018
K_K26881  L_L195  L_L238  0.0018
K_K26882  L_L195  L_L239  0.0017
K_K26883  L_L195  L_L240  0.0017
K_K26884  L_L195  L_L241  0.0017
K_K26885  L_L195  L_L242  0.0016
K_K26886  L_L195  L_L243  0.0016
K_K26887  L_L195  L_L244  0.0015
K_K26888  L_L195  L_L245  0.0015
K_K26889  L_L195  L_L246  0.0015
K_K26890  L_L195  L_L247  0.0015
K_K26891  L_L195  L_L248  0.0014
K_K26892  L_L195  L_L249  0.0014
K_K26893  L_L195  L_L250  0.0014
K_K26894  L_L195  L_L251  0.0014
K_K26895  L_L195  L_L252  0.0013
K_K26896  L_L195  L_L253  0.0013
K_K26897  L_L195  L_L254  0.0013
K_K26898  L_L195  L_L255  0.0013
K_K26899  L_L195  L_L256  0.0013
K_K26900  L_L195  L_L257  0.0012
K_K26901  L_L195  L_L258  0.0012
K_K26902  L_L195  L_L259  0.0012
K_K26903  L_L195  L_L260  0.0012
K_K26904  L_L195  L_L261  0.0011
K_K26905  L_L195  L_L262  0.0011
K_K26906  L_L195  L_L263  0.0011
K_K26907  L_L195  L_L264  0.0011
K_K26908  L_L195  L_L265  0.0011
K_K26909  L_L195  L_L266  0.0011
K_K26910  L_L195  L_L267  0.0011
K_K26911  L_L195  L_L268  0.0010
K_K26912  L_L195  L_L269  0.0010
K_K26913  L_L195  L_L270  0.0010
* *  Branch  NTMP0000000195 - NTMP0000000196
R_R196  NTMP0000000195  nU_196  32.914993m  TC=0,0
V_Ui196  nU_196  nR_196  STIMULUS=U_IND_0000000196
R_V391  nR_196  nV_391  23.280268m  TC=0,0
L_V391  nR_196  nV_391  0.014646uH
R_V392  nV_391  nV_392  7.852787m  TC=0,0
L_V392  nV_391  nV_392  0.073723uH
L_L196  nV_392  NTMP0000000196  6.519695uH
K_K26914  L_L196  L_L197  0.1050
K_K26915  L_L196  L_L198  0.0397
K_K26916  L_L196  L_L199  0.0258
K_K26917  L_L196  L_L200  0.0192
K_K26918  L_L196  L_L201  0.0153
K_K26919  L_L196  L_L202  0.0127
K_K26920  L_L196  L_L203  0.0109
K_K26921  L_L196  L_L204  0.0095
K_K26922  L_L196  L_L205  0.0084
K_K26923  L_L196  L_L206  0.0076
K_K26924  L_L196  L_L207  0.0069
K_K26925  L_L196  L_L208  0.0063
K_K26926  L_L196  L_L209  0.0058
K_K26927  L_L196  L_L210  0.0054
K_K26928  L_L196  L_L211  0.0051
K_K26929  L_L196  L_L212  0.0047
K_K26930  L_L196  L_L213  0.0045
K_K26931  L_L196  L_L214  0.0042
K_K26932  L_L196  L_L215  0.0040
K_K26933  L_L196  L_L216  0.0038
K_K26934  L_L196  L_L217  0.0036
K_K26935  L_L196  L_L218  0.0034
K_K26936  L_L196  L_L219  0.0033
K_K26937  L_L196  L_L220  0.0032
K_K26938  L_L196  L_L221  0.0030
K_K26939  L_L196  L_L222  0.0029
K_K26940  L_L196  L_L223  0.0028
K_K26941  L_L196  L_L224  0.0027
K_K26942  L_L196  L_L225  0.0026
K_K26943  L_L196  L_L226  0.0025
K_K26944  L_L196  L_L227  0.0024
K_K26945  L_L196  L_L228  0.0024
K_K26946  L_L196  L_L229  0.0023
K_K26947  L_L196  L_L230  0.0022
K_K26948  L_L196  L_L231  0.0022
K_K26949  L_L196  L_L232  0.0021
K_K26950  L_L196  L_L233  0.0020
K_K26951  L_L196  L_L234  0.0020
K_K26952  L_L196  L_L235  0.0019
K_K26953  L_L196  L_L236  0.0019
K_K26954  L_L196  L_L237  0.0019
K_K26955  L_L196  L_L238  0.0018
K_K26956  L_L196  L_L239  0.0018
K_K26957  L_L196  L_L240  0.0017
K_K26958  L_L196  L_L241  0.0017
K_K26959  L_L196  L_L242  0.0017
K_K26960  L_L196  L_L243  0.0016
K_K26961  L_L196  L_L244  0.0016
K_K26962  L_L196  L_L245  0.0015
K_K26963  L_L196  L_L246  0.0015
K_K26964  L_L196  L_L247  0.0015
K_K26965  L_L196  L_L248  0.0015
K_K26966  L_L196  L_L249  0.0014
K_K26967  L_L196  L_L250  0.0014
K_K26968  L_L196  L_L251  0.0014
K_K26969  L_L196  L_L252  0.0014
K_K26970  L_L196  L_L253  0.0013
K_K26971  L_L196  L_L254  0.0013
K_K26972  L_L196  L_L255  0.0013
K_K26973  L_L196  L_L256  0.0013
K_K26974  L_L196  L_L257  0.0013
K_K26975  L_L196  L_L258  0.0012
K_K26976  L_L196  L_L259  0.0012
K_K26977  L_L196  L_L260  0.0012
K_K26978  L_L196  L_L261  0.0012
K_K26979  L_L196  L_L262  0.0011
K_K26980  L_L196  L_L263  0.0011
K_K26981  L_L196  L_L264  0.0011
K_K26982  L_L196  L_L265  0.0011
K_K26983  L_L196  L_L266  0.0011
K_K26984  L_L196  L_L267  0.0011
K_K26985  L_L196  L_L268  0.0011
K_K26986  L_L196  L_L269  0.0010
K_K26987  L_L196  L_L270  0.0010
K_K26988  L_L196  L_L271  0.0010
* *  Branch  NTMP0000000196 - NTMP0000000197
R_R197  NTMP0000000196  nU_197  32.914993m  TC=0,0
V_Ui197  nU_197  nR_197  STIMULUS=U_IND_0000000197
R_V393  nR_197  nV_393  23.280268m  TC=0,0
L_V393  nR_197  nV_393  0.014646uH
R_V394  nV_393  nV_394  7.852787m  TC=0,0
L_V394  nV_393  nV_394  0.073723uH
L_L197  nV_394  NTMP0000000197  6.519695uH
K_K26989  L_L197  L_L198  0.1050
K_K26990  L_L197  L_L199  0.0397
K_K26991  L_L197  L_L200  0.0258
K_K26992  L_L197  L_L201  0.0192
K_K26993  L_L197  L_L202  0.0153
K_K26994  L_L197  L_L203  0.0127
K_K26995  L_L197  L_L204  0.0109
K_K26996  L_L197  L_L205  0.0095
K_K26997  L_L197  L_L206  0.0084
K_K26998  L_L197  L_L207  0.0076
K_K26999  L_L197  L_L208  0.0069
K_K27000  L_L197  L_L209  0.0063
K_K27001  L_L197  L_L210  0.0058
K_K27002  L_L197  L_L211  0.0054
K_K27003  L_L197  L_L212  0.0051
K_K27004  L_L197  L_L213  0.0047
K_K27005  L_L197  L_L214  0.0045
K_K27006  L_L197  L_L215  0.0042
K_K27007  L_L197  L_L216  0.0040
K_K27008  L_L197  L_L217  0.0038
K_K27009  L_L197  L_L218  0.0036
K_K27010  L_L197  L_L219  0.0034
K_K27011  L_L197  L_L220  0.0033
K_K27012  L_L197  L_L221  0.0032
K_K27013  L_L197  L_L222  0.0030
K_K27014  L_L197  L_L223  0.0029
K_K27015  L_L197  L_L224  0.0028
K_K27016  L_L197  L_L225  0.0027
K_K27017  L_L197  L_L226  0.0026
K_K27018  L_L197  L_L227  0.0025
K_K27019  L_L197  L_L228  0.0024
K_K27020  L_L197  L_L229  0.0024
K_K27021  L_L197  L_L230  0.0023
K_K27022  L_L197  L_L231  0.0022
K_K27023  L_L197  L_L232  0.0022
K_K27024  L_L197  L_L233  0.0021
K_K27025  L_L197  L_L234  0.0020
K_K27026  L_L197  L_L235  0.0020
K_K27027  L_L197  L_L236  0.0019
K_K27028  L_L197  L_L237  0.0019
K_K27029  L_L197  L_L238  0.0019
K_K27030  L_L197  L_L239  0.0018
K_K27031  L_L197  L_L240  0.0018
K_K27032  L_L197  L_L241  0.0017
K_K27033  L_L197  L_L242  0.0017
K_K27034  L_L197  L_L243  0.0017
K_K27035  L_L197  L_L244  0.0016
K_K27036  L_L197  L_L245  0.0016
K_K27037  L_L197  L_L246  0.0015
K_K27038  L_L197  L_L247  0.0015
K_K27039  L_L197  L_L248  0.0015
K_K27040  L_L197  L_L249  0.0015
K_K27041  L_L197  L_L250  0.0014
K_K27042  L_L197  L_L251  0.0014
K_K27043  L_L197  L_L252  0.0014
K_K27044  L_L197  L_L253  0.0014
K_K27045  L_L197  L_L254  0.0013
K_K27046  L_L197  L_L255  0.0013
K_K27047  L_L197  L_L256  0.0013
K_K27048  L_L197  L_L257  0.0013
K_K27049  L_L197  L_L258  0.0013
K_K27050  L_L197  L_L259  0.0012
K_K27051  L_L197  L_L260  0.0012
K_K27052  L_L197  L_L261  0.0012
K_K27053  L_L197  L_L262  0.0012
K_K27054  L_L197  L_L263  0.0011
K_K27055  L_L197  L_L264  0.0011
K_K27056  L_L197  L_L265  0.0011
K_K27057  L_L197  L_L266  0.0011
K_K27058  L_L197  L_L267  0.0011
K_K27059  L_L197  L_L268  0.0011
K_K27060  L_L197  L_L269  0.0011
K_K27061  L_L197  L_L270  0.0010
K_K27062  L_L197  L_L271  0.0010
K_K27063  L_L197  L_L272  0.0010
* *  Branch  NTMP0000000197 - NTMP0000000198
R_R198  NTMP0000000197  nU_198  32.914993m  TC=0,0
V_Ui198  nU_198  nR_198  STIMULUS=U_IND_0000000198
R_V395  nR_198  nV_395  23.280268m  TC=0,0
L_V395  nR_198  nV_395  0.014646uH
R_V396  nV_395  nV_396  7.852787m  TC=0,0
L_V396  nV_395  nV_396  0.073723uH
L_L198  nV_396  NTMP0000000198  6.519695uH
K_K27064  L_L198  L_L199  0.1050
K_K27065  L_L198  L_L200  0.0397
K_K27066  L_L198  L_L201  0.0258
K_K27067  L_L198  L_L202  0.0192
K_K27068  L_L198  L_L203  0.0153
K_K27069  L_L198  L_L204  0.0127
K_K27070  L_L198  L_L205  0.0109
K_K27071  L_L198  L_L206  0.0095
K_K27072  L_L198  L_L207  0.0084
K_K27073  L_L198  L_L208  0.0076
K_K27074  L_L198  L_L209  0.0069
K_K27075  L_L198  L_L210  0.0063
K_K27076  L_L198  L_L211  0.0058
K_K27077  L_L198  L_L212  0.0054
K_K27078  L_L198  L_L213  0.0051
K_K27079  L_L198  L_L214  0.0047
K_K27080  L_L198  L_L215  0.0045
K_K27081  L_L198  L_L216  0.0042
K_K27082  L_L198  L_L217  0.0040
K_K27083  L_L198  L_L218  0.0038
K_K27084  L_L198  L_L219  0.0036
K_K27085  L_L198  L_L220  0.0034
K_K27086  L_L198  L_L221  0.0033
K_K27087  L_L198  L_L222  0.0032
K_K27088  L_L198  L_L223  0.0030
K_K27089  L_L198  L_L224  0.0029
K_K27090  L_L198  L_L225  0.0028
K_K27091  L_L198  L_L226  0.0027
K_K27092  L_L198  L_L227  0.0026
K_K27093  L_L198  L_L228  0.0025
K_K27094  L_L198  L_L229  0.0024
K_K27095  L_L198  L_L230  0.0024
K_K27096  L_L198  L_L231  0.0023
K_K27097  L_L198  L_L232  0.0022
K_K27098  L_L198  L_L233  0.0022
K_K27099  L_L198  L_L234  0.0021
K_K27100  L_L198  L_L235  0.0020
K_K27101  L_L198  L_L236  0.0020
K_K27102  L_L198  L_L237  0.0019
K_K27103  L_L198  L_L238  0.0019
K_K27104  L_L198  L_L239  0.0019
K_K27105  L_L198  L_L240  0.0018
K_K27106  L_L198  L_L241  0.0018
K_K27107  L_L198  L_L242  0.0017
K_K27108  L_L198  L_L243  0.0017
K_K27109  L_L198  L_L244  0.0017
K_K27110  L_L198  L_L245  0.0016
K_K27111  L_L198  L_L246  0.0016
K_K27112  L_L198  L_L247  0.0015
K_K27113  L_L198  L_L248  0.0015
K_K27114  L_L198  L_L249  0.0015
K_K27115  L_L198  L_L250  0.0015
K_K27116  L_L198  L_L251  0.0014
K_K27117  L_L198  L_L252  0.0014
K_K27118  L_L198  L_L253  0.0014
K_K27119  L_L198  L_L254  0.0014
K_K27120  L_L198  L_L255  0.0013
K_K27121  L_L198  L_L256  0.0013
K_K27122  L_L198  L_L257  0.0013
K_K27123  L_L198  L_L258  0.0013
K_K27124  L_L198  L_L259  0.0013
K_K27125  L_L198  L_L260  0.0012
K_K27126  L_L198  L_L261  0.0012
K_K27127  L_L198  L_L262  0.0012
K_K27128  L_L198  L_L263  0.0012
K_K27129  L_L198  L_L264  0.0011
K_K27130  L_L198  L_L265  0.0011
K_K27131  L_L198  L_L266  0.0011
K_K27132  L_L198  L_L267  0.0011
K_K27133  L_L198  L_L268  0.0011
K_K27134  L_L198  L_L269  0.0011
K_K27135  L_L198  L_L270  0.0011
K_K27136  L_L198  L_L271  0.0010
K_K27137  L_L198  L_L272  0.0010
K_K27138  L_L198  L_L273  0.0010
* *  Branch  NTMP0000000198 - NTMP0000000199
R_R199  NTMP0000000198  nU_199  32.914993m  TC=0,0
V_Ui199  nU_199  nR_199  STIMULUS=U_IND_0000000199
R_V397  nR_199  nV_397  23.280268m  TC=0,0
L_V397  nR_199  nV_397  0.014646uH
R_V398  nV_397  nV_398  7.852787m  TC=0,0
L_V398  nV_397  nV_398  0.073723uH
L_L199  nV_398  NTMP0000000199  6.519695uH
K_K27139  L_L199  L_L200  0.1050
K_K27140  L_L199  L_L201  0.0397
K_K27141  L_L199  L_L202  0.0258
K_K27142  L_L199  L_L203  0.0192
K_K27143  L_L199  L_L204  0.0153
K_K27144  L_L199  L_L205  0.0127
K_K27145  L_L199  L_L206  0.0109
K_K27146  L_L199  L_L207  0.0095
K_K27147  L_L199  L_L208  0.0084
K_K27148  L_L199  L_L209  0.0076
K_K27149  L_L199  L_L210  0.0069
K_K27150  L_L199  L_L211  0.0063
K_K27151  L_L199  L_L212  0.0058
K_K27152  L_L199  L_L213  0.0054
K_K27153  L_L199  L_L214  0.0051
K_K27154  L_L199  L_L215  0.0047
K_K27155  L_L199  L_L216  0.0045
K_K27156  L_L199  L_L217  0.0042
K_K27157  L_L199  L_L218  0.0040
K_K27158  L_L199  L_L219  0.0038
K_K27159  L_L199  L_L220  0.0036
K_K27160  L_L199  L_L221  0.0034
K_K27161  L_L199  L_L222  0.0033
K_K27162  L_L199  L_L223  0.0032
K_K27163  L_L199  L_L224  0.0030
K_K27164  L_L199  L_L225  0.0029
K_K27165  L_L199  L_L226  0.0028
K_K27166  L_L199  L_L227  0.0027
K_K27167  L_L199  L_L228  0.0026
K_K27168  L_L199  L_L229  0.0025
K_K27169  L_L199  L_L230  0.0024
K_K27170  L_L199  L_L231  0.0024
K_K27171  L_L199  L_L232  0.0023
K_K27172  L_L199  L_L233  0.0022
K_K27173  L_L199  L_L234  0.0022
K_K27174  L_L199  L_L235  0.0021
K_K27175  L_L199  L_L236  0.0020
K_K27176  L_L199  L_L237  0.0020
K_K27177  L_L199  L_L238  0.0019
K_K27178  L_L199  L_L239  0.0019
K_K27179  L_L199  L_L240  0.0019
K_K27180  L_L199  L_L241  0.0018
K_K27181  L_L199  L_L242  0.0018
K_K27182  L_L199  L_L243  0.0017
K_K27183  L_L199  L_L244  0.0017
K_K27184  L_L199  L_L245  0.0017
K_K27185  L_L199  L_L246  0.0016
K_K27186  L_L199  L_L247  0.0016
K_K27187  L_L199  L_L248  0.0015
K_K27188  L_L199  L_L249  0.0015
K_K27189  L_L199  L_L250  0.0015
K_K27190  L_L199  L_L251  0.0015
K_K27191  L_L199  L_L252  0.0014
K_K27192  L_L199  L_L253  0.0014
K_K27193  L_L199  L_L254  0.0014
K_K27194  L_L199  L_L255  0.0014
K_K27195  L_L199  L_L256  0.0013
K_K27196  L_L199  L_L257  0.0013
K_K27197  L_L199  L_L258  0.0013
K_K27198  L_L199  L_L259  0.0013
K_K27199  L_L199  L_L260  0.0013
K_K27200  L_L199  L_L261  0.0012
K_K27201  L_L199  L_L262  0.0012
K_K27202  L_L199  L_L263  0.0012
K_K27203  L_L199  L_L264  0.0012
K_K27204  L_L199  L_L265  0.0011
K_K27205  L_L199  L_L266  0.0011
K_K27206  L_L199  L_L267  0.0011
K_K27207  L_L199  L_L268  0.0011
K_K27208  L_L199  L_L269  0.0011
K_K27209  L_L199  L_L270  0.0011
K_K27210  L_L199  L_L271  0.0011
K_K27211  L_L199  L_L272  0.0010
K_K27212  L_L199  L_L273  0.0010
K_K27213  L_L199  L_L274  0.0010
* *  Branch  NTMP0000000199 - NTMP0000000200
R_R200  NTMP0000000199  nU_200  32.914993m  TC=0,0
V_Ui200  nU_200  nR_200  STIMULUS=U_IND_0000000200
R_V399  nR_200  nV_399  23.280268m  TC=0,0
L_V399  nR_200  nV_399  0.014646uH
R_V400  nV_399  nV_400  7.852787m  TC=0,0
L_V400  nV_399  nV_400  0.073723uH
L_L200  nV_400  NTMP0000000200  6.519695uH
K_K27214  L_L200  L_L201  0.1050
K_K27215  L_L200  L_L202  0.0397
K_K27216  L_L200  L_L203  0.0258
K_K27217  L_L200  L_L204  0.0192
K_K27218  L_L200  L_L205  0.0153
K_K27219  L_L200  L_L206  0.0127
K_K27220  L_L200  L_L207  0.0109
K_K27221  L_L200  L_L208  0.0095
K_K27222  L_L200  L_L209  0.0084
K_K27223  L_L200  L_L210  0.0076
K_K27224  L_L200  L_L211  0.0069
K_K27225  L_L200  L_L212  0.0063
K_K27226  L_L200  L_L213  0.0058
K_K27227  L_L200  L_L214  0.0054
K_K27228  L_L200  L_L215  0.0051
K_K27229  L_L200  L_L216  0.0047
K_K27230  L_L200  L_L217  0.0045
K_K27231  L_L200  L_L218  0.0042
K_K27232  L_L200  L_L219  0.0040
K_K27233  L_L200  L_L220  0.0038
K_K27234  L_L200  L_L221  0.0036
K_K27235  L_L200  L_L222  0.0034
K_K27236  L_L200  L_L223  0.0033
K_K27237  L_L200  L_L224  0.0032
K_K27238  L_L200  L_L225  0.0030
K_K27239  L_L200  L_L226  0.0029
K_K27240  L_L200  L_L227  0.0028
K_K27241  L_L200  L_L228  0.0027
K_K27242  L_L200  L_L229  0.0026
K_K27243  L_L200  L_L230  0.0025
K_K27244  L_L200  L_L231  0.0024
K_K27245  L_L200  L_L232  0.0024
K_K27246  L_L200  L_L233  0.0023
K_K27247  L_L200  L_L234  0.0022
K_K27248  L_L200  L_L235  0.0022
K_K27249  L_L200  L_L236  0.0021
K_K27250  L_L200  L_L237  0.0020
K_K27251  L_L200  L_L238  0.0020
K_K27252  L_L200  L_L239  0.0019
K_K27253  L_L200  L_L240  0.0019
K_K27254  L_L200  L_L241  0.0019
K_K27255  L_L200  L_L242  0.0018
K_K27256  L_L200  L_L243  0.0018
K_K27257  L_L200  L_L244  0.0017
K_K27258  L_L200  L_L245  0.0017
K_K27259  L_L200  L_L246  0.0017
K_K27260  L_L200  L_L247  0.0016
K_K27261  L_L200  L_L248  0.0016
K_K27262  L_L200  L_L249  0.0015
K_K27263  L_L200  L_L250  0.0015
K_K27264  L_L200  L_L251  0.0015
K_K27265  L_L200  L_L252  0.0015
K_K27266  L_L200  L_L253  0.0014
K_K27267  L_L200  L_L254  0.0014
K_K27268  L_L200  L_L255  0.0014
K_K27269  L_L200  L_L256  0.0014
K_K27270  L_L200  L_L257  0.0013
K_K27271  L_L200  L_L258  0.0013
K_K27272  L_L200  L_L259  0.0013
K_K27273  L_L200  L_L260  0.0013
K_K27274  L_L200  L_L261  0.0013
K_K27275  L_L200  L_L262  0.0012
K_K27276  L_L200  L_L263  0.0012
K_K27277  L_L200  L_L264  0.0012
K_K27278  L_L200  L_L265  0.0012
K_K27279  L_L200  L_L266  0.0011
K_K27280  L_L200  L_L267  0.0011
K_K27281  L_L200  L_L268  0.0011
K_K27282  L_L200  L_L269  0.0011
K_K27283  L_L200  L_L270  0.0011
K_K27284  L_L200  L_L271  0.0011
K_K27285  L_L200  L_L272  0.0011
K_K27286  L_L200  L_L273  0.0010
K_K27287  L_L200  L_L274  0.0010
K_K27288  L_L200  L_L275  0.0010
* *  Branch  NTMP0000000200 - NTMP0000000201
R_R201  NTMP0000000200  nU_201  32.914993m  TC=0,0
V_Ui201  nU_201  nR_201  STIMULUS=U_IND_0000000201
R_V401  nR_201  nV_401  23.280268m  TC=0,0
L_V401  nR_201  nV_401  0.014646uH
R_V402  nV_401  nV_402  7.852787m  TC=0,0
L_V402  nV_401  nV_402  0.073723uH
L_L201  nV_402  NTMP0000000201  6.519695uH
K_K27289  L_L201  L_L202  0.1050
K_K27290  L_L201  L_L203  0.0397
K_K27291  L_L201  L_L204  0.0258
K_K27292  L_L201  L_L205  0.0192
K_K27293  L_L201  L_L206  0.0153
K_K27294  L_L201  L_L207  0.0127
K_K27295  L_L201  L_L208  0.0109
K_K27296  L_L201  L_L209  0.0095
K_K27297  L_L201  L_L210  0.0084
K_K27298  L_L201  L_L211  0.0076
K_K27299  L_L201  L_L212  0.0069
K_K27300  L_L201  L_L213  0.0063
K_K27301  L_L201  L_L214  0.0058
K_K27302  L_L201  L_L215  0.0054
K_K27303  L_L201  L_L216  0.0051
K_K27304  L_L201  L_L217  0.0047
K_K27305  L_L201  L_L218  0.0045
K_K27306  L_L201  L_L219  0.0042
K_K27307  L_L201  L_L220  0.0040
K_K27308  L_L201  L_L221  0.0038
K_K27309  L_L201  L_L222  0.0036
K_K27310  L_L201  L_L223  0.0034
K_K27311  L_L201  L_L224  0.0033
K_K27312  L_L201  L_L225  0.0032
K_K27313  L_L201  L_L226  0.0030
K_K27314  L_L201  L_L227  0.0029
K_K27315  L_L201  L_L228  0.0028
K_K27316  L_L201  L_L229  0.0027
K_K27317  L_L201  L_L230  0.0026
K_K27318  L_L201  L_L231  0.0025
K_K27319  L_L201  L_L232  0.0024
K_K27320  L_L201  L_L233  0.0024
K_K27321  L_L201  L_L234  0.0023
K_K27322  L_L201  L_L235  0.0022
K_K27323  L_L201  L_L236  0.0022
K_K27324  L_L201  L_L237  0.0021
K_K27325  L_L201  L_L238  0.0020
K_K27326  L_L201  L_L239  0.0020
K_K27327  L_L201  L_L240  0.0019
K_K27328  L_L201  L_L241  0.0019
K_K27329  L_L201  L_L242  0.0019
K_K27330  L_L201  L_L243  0.0018
K_K27331  L_L201  L_L244  0.0018
K_K27332  L_L201  L_L245  0.0017
K_K27333  L_L201  L_L246  0.0017
K_K27334  L_L201  L_L247  0.0017
K_K27335  L_L201  L_L248  0.0016
K_K27336  L_L201  L_L249  0.0016
K_K27337  L_L201  L_L250  0.0015
K_K27338  L_L201  L_L251  0.0015
K_K27339  L_L201  L_L252  0.0015
K_K27340  L_L201  L_L253  0.0015
K_K27341  L_L201  L_L254  0.0014
K_K27342  L_L201  L_L255  0.0014
K_K27343  L_L201  L_L256  0.0014
K_K27344  L_L201  L_L257  0.0014
K_K27345  L_L201  L_L258  0.0013
K_K27346  L_L201  L_L259  0.0013
K_K27347  L_L201  L_L260  0.0013
K_K27348  L_L201  L_L261  0.0013
K_K27349  L_L201  L_L262  0.0013
K_K27350  L_L201  L_L263  0.0012
K_K27351  L_L201  L_L264  0.0012
K_K27352  L_L201  L_L265  0.0012
K_K27353  L_L201  L_L266  0.0012
K_K27354  L_L201  L_L267  0.0011
K_K27355  L_L201  L_L268  0.0011
K_K27356  L_L201  L_L269  0.0011
K_K27357  L_L201  L_L270  0.0011
K_K27358  L_L201  L_L271  0.0011
K_K27359  L_L201  L_L272  0.0011
K_K27360  L_L201  L_L273  0.0011
K_K27361  L_L201  L_L274  0.0010
K_K27362  L_L201  L_L275  0.0010
K_K27363  L_L201  L_L276  0.0010
* *  Branch  NTMP0000000201 - NTMP0000000202
R_R202  NTMP0000000201  nU_202  32.914993m  TC=0,0
V_Ui202  nU_202  nR_202  STIMULUS=U_IND_0000000202
R_V403  nR_202  nV_403  23.280268m  TC=0,0
L_V403  nR_202  nV_403  0.014646uH
R_V404  nV_403  nV_404  7.852787m  TC=0,0
L_V404  nV_403  nV_404  0.073723uH
L_L202  nV_404  NTMP0000000202  6.519695uH
K_K27364  L_L202  L_L203  0.1050
K_K27365  L_L202  L_L204  0.0397
K_K27366  L_L202  L_L205  0.0258
K_K27367  L_L202  L_L206  0.0192
K_K27368  L_L202  L_L207  0.0153
K_K27369  L_L202  L_L208  0.0127
K_K27370  L_L202  L_L209  0.0109
K_K27371  L_L202  L_L210  0.0095
K_K27372  L_L202  L_L211  0.0084
K_K27373  L_L202  L_L212  0.0076
K_K27374  L_L202  L_L213  0.0069
K_K27375  L_L202  L_L214  0.0063
K_K27376  L_L202  L_L215  0.0058
K_K27377  L_L202  L_L216  0.0054
K_K27378  L_L202  L_L217  0.0051
K_K27379  L_L202  L_L218  0.0047
K_K27380  L_L202  L_L219  0.0045
K_K27381  L_L202  L_L220  0.0042
K_K27382  L_L202  L_L221  0.0040
K_K27383  L_L202  L_L222  0.0038
K_K27384  L_L202  L_L223  0.0036
K_K27385  L_L202  L_L224  0.0034
K_K27386  L_L202  L_L225  0.0033
K_K27387  L_L202  L_L226  0.0032
K_K27388  L_L202  L_L227  0.0030
K_K27389  L_L202  L_L228  0.0029
K_K27390  L_L202  L_L229  0.0028
K_K27391  L_L202  L_L230  0.0027
K_K27392  L_L202  L_L231  0.0026
K_K27393  L_L202  L_L232  0.0025
K_K27394  L_L202  L_L233  0.0024
K_K27395  L_L202  L_L234  0.0024
K_K27396  L_L202  L_L235  0.0023
K_K27397  L_L202  L_L236  0.0022
K_K27398  L_L202  L_L237  0.0022
K_K27399  L_L202  L_L238  0.0021
K_K27400  L_L202  L_L239  0.0020
K_K27401  L_L202  L_L240  0.0020
K_K27402  L_L202  L_L241  0.0019
K_K27403  L_L202  L_L242  0.0019
K_K27404  L_L202  L_L243  0.0019
K_K27405  L_L202  L_L244  0.0018
K_K27406  L_L202  L_L245  0.0018
K_K27407  L_L202  L_L246  0.0017
K_K27408  L_L202  L_L247  0.0017
K_K27409  L_L202  L_L248  0.0017
K_K27410  L_L202  L_L249  0.0016
K_K27411  L_L202  L_L250  0.0016
K_K27412  L_L202  L_L251  0.0015
K_K27413  L_L202  L_L252  0.0015
K_K27414  L_L202  L_L253  0.0015
K_K27415  L_L202  L_L254  0.0015
K_K27416  L_L202  L_L255  0.0014
K_K27417  L_L202  L_L256  0.0014
K_K27418  L_L202  L_L257  0.0014
K_K27419  L_L202  L_L258  0.0014
K_K27420  L_L202  L_L259  0.0013
K_K27421  L_L202  L_L260  0.0013
K_K27422  L_L202  L_L261  0.0013
K_K27423  L_L202  L_L262  0.0013
K_K27424  L_L202  L_L263  0.0013
K_K27425  L_L202  L_L264  0.0012
K_K27426  L_L202  L_L265  0.0012
K_K27427  L_L202  L_L266  0.0012
K_K27428  L_L202  L_L267  0.0012
K_K27429  L_L202  L_L268  0.0011
K_K27430  L_L202  L_L269  0.0011
K_K27431  L_L202  L_L270  0.0011
K_K27432  L_L202  L_L271  0.0011
K_K27433  L_L202  L_L272  0.0011
K_K27434  L_L202  L_L273  0.0011
K_K27435  L_L202  L_L274  0.0011
K_K27436  L_L202  L_L275  0.0010
K_K27437  L_L202  L_L276  0.0010
* *  Branch  NTMP0000000202 - NTMP0000000203
R_R203  NTMP0000000202  nU_203  32.914993m  TC=0,0
V_Ui203  nU_203  nR_203  STIMULUS=U_IND_0000000203
R_V405  nR_203  nV_405  23.280268m  TC=0,0
L_V405  nR_203  nV_405  0.014646uH
R_V406  nV_405  nV_406  7.852787m  TC=0,0
L_V406  nV_405  nV_406  0.073723uH
L_L203  nV_406  NTMP0000000203  6.519695uH
K_K27438  L_L203  L_L204  0.1050
K_K27439  L_L203  L_L205  0.0397
K_K27440  L_L203  L_L206  0.0258
K_K27441  L_L203  L_L207  0.0192
K_K27442  L_L203  L_L208  0.0153
K_K27443  L_L203  L_L209  0.0127
K_K27444  L_L203  L_L210  0.0109
K_K27445  L_L203  L_L211  0.0095
K_K27446  L_L203  L_L212  0.0084
K_K27447  L_L203  L_L213  0.0076
K_K27448  L_L203  L_L214  0.0069
K_K27449  L_L203  L_L215  0.0063
K_K27450  L_L203  L_L216  0.0058
K_K27451  L_L203  L_L217  0.0054
K_K27452  L_L203  L_L218  0.0051
K_K27453  L_L203  L_L219  0.0047
K_K27454  L_L203  L_L220  0.0045
K_K27455  L_L203  L_L221  0.0042
K_K27456  L_L203  L_L222  0.0040
K_K27457  L_L203  L_L223  0.0038
K_K27458  L_L203  L_L224  0.0036
K_K27459  L_L203  L_L225  0.0034
K_K27460  L_L203  L_L226  0.0033
K_K27461  L_L203  L_L227  0.0032
K_K27462  L_L203  L_L228  0.0030
K_K27463  L_L203  L_L229  0.0029
K_K27464  L_L203  L_L230  0.0028
K_K27465  L_L203  L_L231  0.0027
K_K27466  L_L203  L_L232  0.0026
K_K27467  L_L203  L_L233  0.0025
K_K27468  L_L203  L_L234  0.0024
K_K27469  L_L203  L_L235  0.0024
K_K27470  L_L203  L_L236  0.0023
K_K27471  L_L203  L_L237  0.0022
K_K27472  L_L203  L_L238  0.0022
K_K27473  L_L203  L_L239  0.0021
K_K27474  L_L203  L_L240  0.0020
K_K27475  L_L203  L_L241  0.0020
K_K27476  L_L203  L_L242  0.0019
K_K27477  L_L203  L_L243  0.0019
K_K27478  L_L203  L_L244  0.0019
K_K27479  L_L203  L_L245  0.0018
K_K27480  L_L203  L_L246  0.0018
K_K27481  L_L203  L_L247  0.0017
K_K27482  L_L203  L_L248  0.0017
K_K27483  L_L203  L_L249  0.0017
K_K27484  L_L203  L_L250  0.0016
K_K27485  L_L203  L_L251  0.0016
K_K27486  L_L203  L_L252  0.0015
K_K27487  L_L203  L_L253  0.0015
K_K27488  L_L203  L_L254  0.0015
K_K27489  L_L203  L_L255  0.0015
K_K27490  L_L203  L_L256  0.0014
K_K27491  L_L203  L_L257  0.0014
K_K27492  L_L203  L_L258  0.0014
K_K27493  L_L203  L_L259  0.0014
K_K27494  L_L203  L_L260  0.0013
K_K27495  L_L203  L_L261  0.0013
K_K27496  L_L203  L_L262  0.0013
K_K27497  L_L203  L_L263  0.0013
K_K27498  L_L203  L_L264  0.0013
K_K27499  L_L203  L_L265  0.0012
K_K27500  L_L203  L_L266  0.0012
K_K27501  L_L203  L_L267  0.0012
K_K27502  L_L203  L_L268  0.0012
K_K27503  L_L203  L_L269  0.0011
K_K27504  L_L203  L_L270  0.0011
K_K27505  L_L203  L_L271  0.0011
K_K27506  L_L203  L_L272  0.0011
K_K27507  L_L203  L_L273  0.0011
K_K27508  L_L203  L_L274  0.0011
K_K27509  L_L203  L_L275  0.0011
K_K27510  L_L203  L_L276  0.0010
* *  Branch  NTMP0000000203 - NTMP0000000204
R_R204  NTMP0000000203  nU_204  32.914993m  TC=0,0
V_Ui204  nU_204  nR_204  STIMULUS=U_IND_0000000204
R_V407  nR_204  nV_407  23.280268m  TC=0,0
L_V407  nR_204  nV_407  0.014646uH
R_V408  nV_407  nV_408  7.852787m  TC=0,0
L_V408  nV_407  nV_408  0.073723uH
L_L204  nV_408  NTMP0000000204  6.519695uH
K_K27511  L_L204  L_L205  0.1050
K_K27512  L_L204  L_L206  0.0397
K_K27513  L_L204  L_L207  0.0258
K_K27514  L_L204  L_L208  0.0192
K_K27515  L_L204  L_L209  0.0153
K_K27516  L_L204  L_L210  0.0127
K_K27517  L_L204  L_L211  0.0109
K_K27518  L_L204  L_L212  0.0095
K_K27519  L_L204  L_L213  0.0084
K_K27520  L_L204  L_L214  0.0076
K_K27521  L_L204  L_L215  0.0069
K_K27522  L_L204  L_L216  0.0063
K_K27523  L_L204  L_L217  0.0058
K_K27524  L_L204  L_L218  0.0054
K_K27525  L_L204  L_L219  0.0051
K_K27526  L_L204  L_L220  0.0047
K_K27527  L_L204  L_L221  0.0045
K_K27528  L_L204  L_L222  0.0042
K_K27529  L_L204  L_L223  0.0040
K_K27530  L_L204  L_L224  0.0038
K_K27531  L_L204  L_L225  0.0036
K_K27532  L_L204  L_L226  0.0034
K_K27533  L_L204  L_L227  0.0033
K_K27534  L_L204  L_L228  0.0032
K_K27535  L_L204  L_L229  0.0030
K_K27536  L_L204  L_L230  0.0029
K_K27537  L_L204  L_L231  0.0028
K_K27538  L_L204  L_L232  0.0027
K_K27539  L_L204  L_L233  0.0026
K_K27540  L_L204  L_L234  0.0025
K_K27541  L_L204  L_L235  0.0024
K_K27542  L_L204  L_L236  0.0024
K_K27543  L_L204  L_L237  0.0023
K_K27544  L_L204  L_L238  0.0022
K_K27545  L_L204  L_L239  0.0022
K_K27546  L_L204  L_L240  0.0021
K_K27547  L_L204  L_L241  0.0020
K_K27548  L_L204  L_L242  0.0020
K_K27549  L_L204  L_L243  0.0019
K_K27550  L_L204  L_L244  0.0019
K_K27551  L_L204  L_L245  0.0019
K_K27552  L_L204  L_L246  0.0018
K_K27553  L_L204  L_L247  0.0018
K_K27554  L_L204  L_L248  0.0017
K_K27555  L_L204  L_L249  0.0017
K_K27556  L_L204  L_L250  0.0017
K_K27557  L_L204  L_L251  0.0016
K_K27558  L_L204  L_L252  0.0016
K_K27559  L_L204  L_L253  0.0015
K_K27560  L_L204  L_L254  0.0015
K_K27561  L_L204  L_L255  0.0015
K_K27562  L_L204  L_L256  0.0015
K_K27563  L_L204  L_L257  0.0014
K_K27564  L_L204  L_L258  0.0014
K_K27565  L_L204  L_L259  0.0014
K_K27566  L_L204  L_L260  0.0014
K_K27567  L_L204  L_L261  0.0013
K_K27568  L_L204  L_L262  0.0013
K_K27569  L_L204  L_L263  0.0013
K_K27570  L_L204  L_L264  0.0013
K_K27571  L_L204  L_L265  0.0013
K_K27572  L_L204  L_L266  0.0012
K_K27573  L_L204  L_L267  0.0012
K_K27574  L_L204  L_L268  0.0012
K_K27575  L_L204  L_L269  0.0012
K_K27576  L_L204  L_L270  0.0011
K_K27577  L_L204  L_L271  0.0011
K_K27578  L_L204  L_L272  0.0011
K_K27579  L_L204  L_L273  0.0011
K_K27580  L_L204  L_L274  0.0011
K_K27581  L_L204  L_L275  0.0011
K_K27582  L_L204  L_L276  0.0011
* *  Branch  NTMP0000000204 - NTMP0000000205
R_R205  NTMP0000000204  nU_205  32.914993m  TC=0,0
V_Ui205  nU_205  nR_205  STIMULUS=U_IND_0000000205
R_V409  nR_205  nV_409  23.280268m  TC=0,0
L_V409  nR_205  nV_409  0.014646uH
R_V410  nV_409  nV_410  7.852787m  TC=0,0
L_V410  nV_409  nV_410  0.073723uH
L_L205  nV_410  NTMP0000000205  6.519695uH
K_K27583  L_L205  L_L206  0.1050
K_K27584  L_L205  L_L207  0.0397
K_K27585  L_L205  L_L208  0.0258
K_K27586  L_L205  L_L209  0.0192
K_K27587  L_L205  L_L210  0.0153
K_K27588  L_L205  L_L211  0.0127
K_K27589  L_L205  L_L212  0.0109
K_K27590  L_L205  L_L213  0.0095
K_K27591  L_L205  L_L214  0.0084
K_K27592  L_L205  L_L215  0.0076
K_K27593  L_L205  L_L216  0.0069
K_K27594  L_L205  L_L217  0.0063
K_K27595  L_L205  L_L218  0.0058
K_K27596  L_L205  L_L219  0.0054
K_K27597  L_L205  L_L220  0.0051
K_K27598  L_L205  L_L221  0.0047
K_K27599  L_L205  L_L222  0.0045
K_K27600  L_L205  L_L223  0.0042
K_K27601  L_L205  L_L224  0.0040
K_K27602  L_L205  L_L225  0.0038
K_K27603  L_L205  L_L226  0.0036
K_K27604  L_L205  L_L227  0.0034
K_K27605  L_L205  L_L228  0.0033
K_K27606  L_L205  L_L229  0.0032
K_K27607  L_L205  L_L230  0.0030
K_K27608  L_L205  L_L231  0.0029
K_K27609  L_L205  L_L232  0.0028
K_K27610  L_L205  L_L233  0.0027
K_K27611  L_L205  L_L234  0.0026
K_K27612  L_L205  L_L235  0.0025
K_K27613  L_L205  L_L236  0.0024
K_K27614  L_L205  L_L237  0.0024
K_K27615  L_L205  L_L238  0.0023
K_K27616  L_L205  L_L239  0.0022
K_K27617  L_L205  L_L240  0.0022
K_K27618  L_L205  L_L241  0.0021
K_K27619  L_L205  L_L242  0.0020
K_K27620  L_L205  L_L243  0.0020
K_K27621  L_L205  L_L244  0.0019
K_K27622  L_L205  L_L245  0.0019
K_K27623  L_L205  L_L246  0.0019
K_K27624  L_L205  L_L247  0.0018
K_K27625  L_L205  L_L248  0.0018
K_K27626  L_L205  L_L249  0.0017
K_K27627  L_L205  L_L250  0.0017
K_K27628  L_L205  L_L251  0.0016
K_K27629  L_L205  L_L252  0.0016
K_K27630  L_L205  L_L253  0.0016
K_K27631  L_L205  L_L254  0.0015
K_K27632  L_L205  L_L255  0.0015
K_K27633  L_L205  L_L256  0.0015
K_K27634  L_L205  L_L257  0.0015
K_K27635  L_L205  L_L258  0.0014
K_K27636  L_L205  L_L259  0.0014
K_K27637  L_L205  L_L260  0.0014
K_K27638  L_L205  L_L261  0.0014
K_K27639  L_L205  L_L262  0.0013
K_K27640  L_L205  L_L263  0.0013
K_K27641  L_L205  L_L264  0.0013
K_K27642  L_L205  L_L265  0.0013
K_K27643  L_L205  L_L266  0.0013
K_K27644  L_L205  L_L267  0.0012
K_K27645  L_L205  L_L268  0.0012
K_K27646  L_L205  L_L269  0.0012
K_K27647  L_L205  L_L270  0.0012
K_K27648  L_L205  L_L271  0.0011
K_K27649  L_L205  L_L272  0.0011
K_K27650  L_L205  L_L273  0.0011
K_K27651  L_L205  L_L274  0.0011
K_K27652  L_L205  L_L275  0.0011
K_K27653  L_L205  L_L276  0.0011
* *  Branch  NTMP0000000205 - NTMP0000000206
R_R206  NTMP0000000205  nU_206  32.914993m  TC=0,0
V_Ui206  nU_206  nR_206  STIMULUS=U_IND_0000000206
R_V411  nR_206  nV_411  23.280268m  TC=0,0
L_V411  nR_206  nV_411  0.014646uH
R_V412  nV_411  nV_412  7.852787m  TC=0,0
L_V412  nV_411  nV_412  0.073723uH
L_L206  nV_412  NTMP0000000206  6.519695uH
K_K27654  L_L206  L_L207  0.1050
K_K27655  L_L206  L_L208  0.0397
K_K27656  L_L206  L_L209  0.0258
K_K27657  L_L206  L_L210  0.0192
K_K27658  L_L206  L_L211  0.0153
K_K27659  L_L206  L_L212  0.0127
K_K27660  L_L206  L_L213  0.0109
K_K27661  L_L206  L_L214  0.0095
K_K27662  L_L206  L_L215  0.0084
K_K27663  L_L206  L_L216  0.0076
K_K27664  L_L206  L_L217  0.0069
K_K27665  L_L206  L_L218  0.0063
K_K27666  L_L206  L_L219  0.0058
K_K27667  L_L206  L_L220  0.0054
K_K27668  L_L206  L_L221  0.0051
K_K27669  L_L206  L_L222  0.0047
K_K27670  L_L206  L_L223  0.0045
K_K27671  L_L206  L_L224  0.0042
K_K27672  L_L206  L_L225  0.0040
K_K27673  L_L206  L_L226  0.0038
K_K27674  L_L206  L_L227  0.0036
K_K27675  L_L206  L_L228  0.0034
K_K27676  L_L206  L_L229  0.0033
K_K27677  L_L206  L_L230  0.0032
K_K27678  L_L206  L_L231  0.0030
K_K27679  L_L206  L_L232  0.0029
K_K27680  L_L206  L_L233  0.0028
K_K27681  L_L206  L_L234  0.0027
K_K27682  L_L206  L_L235  0.0026
K_K27683  L_L206  L_L236  0.0025
K_K27684  L_L206  L_L237  0.0024
K_K27685  L_L206  L_L238  0.0024
K_K27686  L_L206  L_L239  0.0023
K_K27687  L_L206  L_L240  0.0022
K_K27688  L_L206  L_L241  0.0022
K_K27689  L_L206  L_L242  0.0021
K_K27690  L_L206  L_L243  0.0020
K_K27691  L_L206  L_L244  0.0020
K_K27692  L_L206  L_L245  0.0019
K_K27693  L_L206  L_L246  0.0019
K_K27694  L_L206  L_L247  0.0019
K_K27695  L_L206  L_L248  0.0018
K_K27696  L_L206  L_L249  0.0018
K_K27697  L_L206  L_L250  0.0017
K_K27698  L_L206  L_L251  0.0017
K_K27699  L_L206  L_L252  0.0016
K_K27700  L_L206  L_L253  0.0016
K_K27701  L_L206  L_L254  0.0016
K_K27702  L_L206  L_L255  0.0015
K_K27703  L_L206  L_L256  0.0015
K_K27704  L_L206  L_L257  0.0015
K_K27705  L_L206  L_L258  0.0015
K_K27706  L_L206  L_L259  0.0014
K_K27707  L_L206  L_L260  0.0014
K_K27708  L_L206  L_L261  0.0014
K_K27709  L_L206  L_L262  0.0014
K_K27710  L_L206  L_L263  0.0013
K_K27711  L_L206  L_L264  0.0013
K_K27712  L_L206  L_L265  0.0013
K_K27713  L_L206  L_L266  0.0013
K_K27714  L_L206  L_L267  0.0013
K_K27715  L_L206  L_L268  0.0012
K_K27716  L_L206  L_L269  0.0012
K_K27717  L_L206  L_L270  0.0012
K_K27718  L_L206  L_L271  0.0012
K_K27719  L_L206  L_L272  0.0011
K_K27720  L_L206  L_L273  0.0011
K_K27721  L_L206  L_L274  0.0011
K_K27722  L_L206  L_L275  0.0011
K_K27723  L_L206  L_L276  0.0011
* *  Branch  NTMP0000000206 - NN09
R_R207  NTMP0000000206  nU_207  32.914993m  TC=0,0
V_Ui207  nU_207  nR_207  STIMULUS=U_IND_0000000207
R_V413  nR_207  nV_413  23.280268m  TC=0,0
L_V413  nR_207  nV_413  0.014646uH
R_V414  nV_413  nV_414  7.852787m  TC=0,0
L_V414  nV_413  nV_414  0.073723uH
L_L207  nV_414  NN09  6.519695uH
K_K27724  L_L207  L_L208  0.1050
K_K27725  L_L207  L_L209  0.0397
K_K27726  L_L207  L_L210  0.0258
K_K27727  L_L207  L_L211  0.0192
K_K27728  L_L207  L_L212  0.0153
K_K27729  L_L207  L_L213  0.0127
K_K27730  L_L207  L_L214  0.0109
K_K27731  L_L207  L_L215  0.0095
K_K27732  L_L207  L_L216  0.0084
K_K27733  L_L207  L_L217  0.0076
K_K27734  L_L207  L_L218  0.0069
K_K27735  L_L207  L_L219  0.0063
K_K27736  L_L207  L_L220  0.0058
K_K27737  L_L207  L_L221  0.0054
K_K27738  L_L207  L_L222  0.0051
K_K27739  L_L207  L_L223  0.0047
K_K27740  L_L207  L_L224  0.0045
K_K27741  L_L207  L_L225  0.0042
K_K27742  L_L207  L_L226  0.0040
K_K27743  L_L207  L_L227  0.0038
K_K27744  L_L207  L_L228  0.0036
K_K27745  L_L207  L_L229  0.0034
K_K27746  L_L207  L_L230  0.0033
K_K27747  L_L207  L_L231  0.0032
K_K27748  L_L207  L_L232  0.0030
K_K27749  L_L207  L_L233  0.0029
K_K27750  L_L207  L_L234  0.0028
K_K27751  L_L207  L_L235  0.0027
K_K27752  L_L207  L_L236  0.0026
K_K27753  L_L207  L_L237  0.0025
K_K27754  L_L207  L_L238  0.0024
K_K27755  L_L207  L_L239  0.0024
K_K27756  L_L207  L_L240  0.0023
K_K27757  L_L207  L_L241  0.0022
K_K27758  L_L207  L_L242  0.0022
K_K27759  L_L207  L_L243  0.0021
K_K27760  L_L207  L_L244  0.0020
K_K27761  L_L207  L_L245  0.0020
K_K27762  L_L207  L_L246  0.0019
K_K27763  L_L207  L_L247  0.0019
K_K27764  L_L207  L_L248  0.0019
K_K27765  L_L207  L_L249  0.0018
K_K27766  L_L207  L_L250  0.0018
K_K27767  L_L207  L_L251  0.0017
K_K27768  L_L207  L_L252  0.0017
K_K27769  L_L207  L_L253  0.0016
K_K27770  L_L207  L_L254  0.0016
K_K27771  L_L207  L_L255  0.0016
K_K27772  L_L207  L_L256  0.0015
K_K27773  L_L207  L_L257  0.0015
K_K27774  L_L207  L_L258  0.0015
K_K27775  L_L207  L_L259  0.0015
K_K27776  L_L207  L_L260  0.0014
K_K27777  L_L207  L_L261  0.0014
K_K27778  L_L207  L_L262  0.0014
K_K27779  L_L207  L_L263  0.0014
K_K27780  L_L207  L_L264  0.0013
K_K27781  L_L207  L_L265  0.0013
K_K27782  L_L207  L_L266  0.0013
K_K27783  L_L207  L_L267  0.0013
K_K27784  L_L207  L_L268  0.0013
K_K27785  L_L207  L_L269  0.0012
K_K27786  L_L207  L_L270  0.0012
K_K27787  L_L207  L_L271  0.0012
K_K27788  L_L207  L_L272  0.0012
K_K27789  L_L207  L_L273  0.0011
K_K27790  L_L207  L_L274  0.0011
K_K27791  L_L207  L_L275  0.0011
K_K27792  L_L207  L_L276  0.0011
* *  Branch  NN09 - NTMP0000000208
R_R208  NN09  nU_208  32.914993m  TC=0,0
V_Ui208  nU_208  nR_208  STIMULUS=U_IND_0000000208
R_V415  nR_208  nV_415  23.280268m  TC=0,0
L_V415  nR_208  nV_415  0.014646uH
R_V416  nV_415  nV_416  7.852787m  TC=0,0
L_V416  nV_415  nV_416  0.073723uH
L_L208  nV_416  NTMP0000000208  6.519695uH
K_K27793  L_L208  L_L209  0.1050
K_K27794  L_L208  L_L210  0.0397
K_K27795  L_L208  L_L211  0.0258
K_K27796  L_L208  L_L212  0.0192
K_K27797  L_L208  L_L213  0.0153
K_K27798  L_L208  L_L214  0.0127
K_K27799  L_L208  L_L215  0.0109
K_K27800  L_L208  L_L216  0.0095
K_K27801  L_L208  L_L217  0.0084
K_K27802  L_L208  L_L218  0.0076
K_K27803  L_L208  L_L219  0.0069
K_K27804  L_L208  L_L220  0.0063
K_K27805  L_L208  L_L221  0.0058
K_K27806  L_L208  L_L222  0.0054
K_K27807  L_L208  L_L223  0.0051
K_K27808  L_L208  L_L224  0.0047
K_K27809  L_L208  L_L225  0.0045
K_K27810  L_L208  L_L226  0.0042
K_K27811  L_L208  L_L227  0.0040
K_K27812  L_L208  L_L228  0.0038
K_K27813  L_L208  L_L229  0.0036
K_K27814  L_L208  L_L230  0.0034
K_K27815  L_L208  L_L231  0.0033
K_K27816  L_L208  L_L232  0.0032
K_K27817  L_L208  L_L233  0.0030
K_K27818  L_L208  L_L234  0.0029
K_K27819  L_L208  L_L235  0.0028
K_K27820  L_L208  L_L236  0.0027
K_K27821  L_L208  L_L237  0.0026
K_K27822  L_L208  L_L238  0.0025
K_K27823  L_L208  L_L239  0.0024
K_K27824  L_L208  L_L240  0.0024
K_K27825  L_L208  L_L241  0.0023
K_K27826  L_L208  L_L242  0.0022
K_K27827  L_L208  L_L243  0.0022
K_K27828  L_L208  L_L244  0.0021
K_K27829  L_L208  L_L245  0.0020
K_K27830  L_L208  L_L246  0.0020
K_K27831  L_L208  L_L247  0.0019
K_K27832  L_L208  L_L248  0.0019
K_K27833  L_L208  L_L249  0.0019
K_K27834  L_L208  L_L250  0.0018
K_K27835  L_L208  L_L251  0.0018
K_K27836  L_L208  L_L252  0.0017
K_K27837  L_L208  L_L253  0.0017
K_K27838  L_L208  L_L254  0.0016
K_K27839  L_L208  L_L255  0.0016
K_K27840  L_L208  L_L256  0.0016
K_K27841  L_L208  L_L257  0.0015
K_K27842  L_L208  L_L258  0.0015
K_K27843  L_L208  L_L259  0.0015
K_K27844  L_L208  L_L260  0.0015
K_K27845  L_L208  L_L261  0.0014
K_K27846  L_L208  L_L262  0.0014
K_K27847  L_L208  L_L263  0.0014
K_K27848  L_L208  L_L264  0.0014
K_K27849  L_L208  L_L265  0.0013
K_K27850  L_L208  L_L266  0.0013
K_K27851  L_L208  L_L267  0.0013
K_K27852  L_L208  L_L268  0.0013
K_K27853  L_L208  L_L269  0.0013
K_K27854  L_L208  L_L270  0.0012
K_K27855  L_L208  L_L271  0.0012
K_K27856  L_L208  L_L272  0.0012
K_K27857  L_L208  L_L273  0.0012
K_K27858  L_L208  L_L274  0.0011
K_K27859  L_L208  L_L275  0.0011
K_K27860  L_L208  L_L276  0.0011
* *  Branch  NTMP0000000208 - NTMP0000000209
R_R209  NTMP0000000208  nU_209  32.914993m  TC=0,0
V_Ui209  nU_209  nR_209  STIMULUS=U_IND_0000000209
R_V417  nR_209  nV_417  23.280268m  TC=0,0
L_V417  nR_209  nV_417  0.014646uH
R_V418  nV_417  nV_418  7.852787m  TC=0,0
L_V418  nV_417  nV_418  0.073723uH
L_L209  nV_418  NTMP0000000209  6.519695uH
K_K27861  L_L209  L_L210  0.1050
K_K27862  L_L209  L_L211  0.0397
K_K27863  L_L209  L_L212  0.0258
K_K27864  L_L209  L_L213  0.0192
K_K27865  L_L209  L_L214  0.0153
K_K27866  L_L209  L_L215  0.0127
K_K27867  L_L209  L_L216  0.0109
K_K27868  L_L209  L_L217  0.0095
K_K27869  L_L209  L_L218  0.0084
K_K27870  L_L209  L_L219  0.0076
K_K27871  L_L209  L_L220  0.0069
K_K27872  L_L209  L_L221  0.0063
K_K27873  L_L209  L_L222  0.0058
K_K27874  L_L209  L_L223  0.0054
K_K27875  L_L209  L_L224  0.0051
K_K27876  L_L209  L_L225  0.0047
K_K27877  L_L209  L_L226  0.0045
K_K27878  L_L209  L_L227  0.0042
K_K27879  L_L209  L_L228  0.0040
K_K27880  L_L209  L_L229  0.0038
K_K27881  L_L209  L_L230  0.0036
K_K27882  L_L209  L_L231  0.0034
K_K27883  L_L209  L_L232  0.0033
K_K27884  L_L209  L_L233  0.0032
K_K27885  L_L209  L_L234  0.0030
K_K27886  L_L209  L_L235  0.0029
K_K27887  L_L209  L_L236  0.0028
K_K27888  L_L209  L_L237  0.0027
K_K27889  L_L209  L_L238  0.0026
K_K27890  L_L209  L_L239  0.0025
K_K27891  L_L209  L_L240  0.0024
K_K27892  L_L209  L_L241  0.0024
K_K27893  L_L209  L_L242  0.0023
K_K27894  L_L209  L_L243  0.0022
K_K27895  L_L209  L_L244  0.0022
K_K27896  L_L209  L_L245  0.0021
K_K27897  L_L209  L_L246  0.0020
K_K27898  L_L209  L_L247  0.0020
K_K27899  L_L209  L_L248  0.0019
K_K27900  L_L209  L_L249  0.0019
K_K27901  L_L209  L_L250  0.0019
K_K27902  L_L209  L_L251  0.0018
K_K27903  L_L209  L_L252  0.0018
K_K27904  L_L209  L_L253  0.0017
K_K27905  L_L209  L_L254  0.0017
K_K27906  L_L209  L_L255  0.0016
K_K27907  L_L209  L_L256  0.0016
K_K27908  L_L209  L_L257  0.0016
K_K27909  L_L209  L_L258  0.0015
K_K27910  L_L209  L_L259  0.0015
K_K27911  L_L209  L_L260  0.0015
K_K27912  L_L209  L_L261  0.0015
K_K27913  L_L209  L_L262  0.0014
K_K27914  L_L209  L_L263  0.0014
K_K27915  L_L209  L_L264  0.0014
K_K27916  L_L209  L_L265  0.0014
K_K27917  L_L209  L_L266  0.0013
K_K27918  L_L209  L_L267  0.0013
K_K27919  L_L209  L_L268  0.0013
K_K27920  L_L209  L_L269  0.0013
K_K27921  L_L209  L_L270  0.0013
K_K27922  L_L209  L_L271  0.0012
K_K27923  L_L209  L_L272  0.0012
K_K27924  L_L209  L_L273  0.0012
K_K27925  L_L209  L_L274  0.0012
K_K27926  L_L209  L_L275  0.0011
K_K27927  L_L209  L_L276  0.0011
* *  Branch  NTMP0000000209 - NTMP0000000210
R_R210  NTMP0000000209  nU_210  32.914993m  TC=0,0
V_Ui210  nU_210  nR_210  STIMULUS=U_IND_0000000210
R_V419  nR_210  nV_419  23.280268m  TC=0,0
L_V419  nR_210  nV_419  0.014646uH
R_V420  nV_419  nV_420  7.852787m  TC=0,0
L_V420  nV_419  nV_420  0.073723uH
L_L210  nV_420  NTMP0000000210  6.519695uH
K_K27928  L_L210  L_L211  0.1050
K_K27929  L_L210  L_L212  0.0397
K_K27930  L_L210  L_L213  0.0258
K_K27931  L_L210  L_L214  0.0192
K_K27932  L_L210  L_L215  0.0153
K_K27933  L_L210  L_L216  0.0127
K_K27934  L_L210  L_L217  0.0109
K_K27935  L_L210  L_L218  0.0095
K_K27936  L_L210  L_L219  0.0084
K_K27937  L_L210  L_L220  0.0076
K_K27938  L_L210  L_L221  0.0069
K_K27939  L_L210  L_L222  0.0063
K_K27940  L_L210  L_L223  0.0058
K_K27941  L_L210  L_L224  0.0054
K_K27942  L_L210  L_L225  0.0051
K_K27943  L_L210  L_L226  0.0047
K_K27944  L_L210  L_L227  0.0045
K_K27945  L_L210  L_L228  0.0042
K_K27946  L_L210  L_L229  0.0040
K_K27947  L_L210  L_L230  0.0038
K_K27948  L_L210  L_L231  0.0036
K_K27949  L_L210  L_L232  0.0034
K_K27950  L_L210  L_L233  0.0033
K_K27951  L_L210  L_L234  0.0032
K_K27952  L_L210  L_L235  0.0030
K_K27953  L_L210  L_L236  0.0029
K_K27954  L_L210  L_L237  0.0028
K_K27955  L_L210  L_L238  0.0027
K_K27956  L_L210  L_L239  0.0026
K_K27957  L_L210  L_L240  0.0025
K_K27958  L_L210  L_L241  0.0024
K_K27959  L_L210  L_L242  0.0024
K_K27960  L_L210  L_L243  0.0023
K_K27961  L_L210  L_L244  0.0022
K_K27962  L_L210  L_L245  0.0022
K_K27963  L_L210  L_L246  0.0021
K_K27964  L_L210  L_L247  0.0020
K_K27965  L_L210  L_L248  0.0020
K_K27966  L_L210  L_L249  0.0019
K_K27967  L_L210  L_L250  0.0019
K_K27968  L_L210  L_L251  0.0019
K_K27969  L_L210  L_L252  0.0018
K_K27970  L_L210  L_L253  0.0018
K_K27971  L_L210  L_L254  0.0017
K_K27972  L_L210  L_L255  0.0017
K_K27973  L_L210  L_L256  0.0016
K_K27974  L_L210  L_L257  0.0016
K_K27975  L_L210  L_L258  0.0016
K_K27976  L_L210  L_L259  0.0015
K_K27977  L_L210  L_L260  0.0015
K_K27978  L_L210  L_L261  0.0015
K_K27979  L_L210  L_L262  0.0015
K_K27980  L_L210  L_L263  0.0014
K_K27981  L_L210  L_L264  0.0014
K_K27982  L_L210  L_L265  0.0014
K_K27983  L_L210  L_L266  0.0014
K_K27984  L_L210  L_L267  0.0013
K_K27985  L_L210  L_L268  0.0013
K_K27986  L_L210  L_L269  0.0013
K_K27987  L_L210  L_L270  0.0013
K_K27988  L_L210  L_L271  0.0013
K_K27989  L_L210  L_L272  0.0012
K_K27990  L_L210  L_L273  0.0012
K_K27991  L_L210  L_L274  0.0012
K_K27992  L_L210  L_L275  0.0012
K_K27993  L_L210  L_L276  0.0011
* *  Branch  NTMP0000000210 - NTMP0000000211
R_R211  NTMP0000000210  nU_211  32.914993m  TC=0,0
V_Ui211  nU_211  nR_211  STIMULUS=U_IND_0000000211
R_V421  nR_211  nV_421  23.280268m  TC=0,0
L_V421  nR_211  nV_421  0.014646uH
R_V422  nV_421  nV_422  7.852787m  TC=0,0
L_V422  nV_421  nV_422  0.073723uH
L_L211  nV_422  NTMP0000000211  6.519695uH
K_K27994  L_L211  L_L212  0.1050
K_K27995  L_L211  L_L213  0.0397
K_K27996  L_L211  L_L214  0.0258
K_K27997  L_L211  L_L215  0.0192
K_K27998  L_L211  L_L216  0.0153
K_K27999  L_L211  L_L217  0.0127
K_K28000  L_L211  L_L218  0.0109
K_K28001  L_L211  L_L219  0.0095
K_K28002  L_L211  L_L220  0.0084
K_K28003  L_L211  L_L221  0.0076
K_K28004  L_L211  L_L222  0.0069
K_K28005  L_L211  L_L223  0.0063
K_K28006  L_L211  L_L224  0.0058
K_K28007  L_L211  L_L225  0.0054
K_K28008  L_L211  L_L226  0.0051
K_K28009  L_L211  L_L227  0.0047
K_K28010  L_L211  L_L228  0.0045
K_K28011  L_L211  L_L229  0.0042
K_K28012  L_L211  L_L230  0.0040
K_K28013  L_L211  L_L231  0.0038
K_K28014  L_L211  L_L232  0.0036
K_K28015  L_L211  L_L233  0.0034
K_K28016  L_L211  L_L234  0.0033
K_K28017  L_L211  L_L235  0.0032
K_K28018  L_L211  L_L236  0.0030
K_K28019  L_L211  L_L237  0.0029
K_K28020  L_L211  L_L238  0.0028
K_K28021  L_L211  L_L239  0.0027
K_K28022  L_L211  L_L240  0.0026
K_K28023  L_L211  L_L241  0.0025
K_K28024  L_L211  L_L242  0.0024
K_K28025  L_L211  L_L243  0.0024
K_K28026  L_L211  L_L244  0.0023
K_K28027  L_L211  L_L245  0.0022
K_K28028  L_L211  L_L246  0.0022
K_K28029  L_L211  L_L247  0.0021
K_K28030  L_L211  L_L248  0.0020
K_K28031  L_L211  L_L249  0.0020
K_K28032  L_L211  L_L250  0.0019
K_K28033  L_L211  L_L251  0.0019
K_K28034  L_L211  L_L252  0.0019
K_K28035  L_L211  L_L253  0.0018
K_K28036  L_L211  L_L254  0.0018
K_K28037  L_L211  L_L255  0.0017
K_K28038  L_L211  L_L256  0.0017
K_K28039  L_L211  L_L257  0.0016
K_K28040  L_L211  L_L258  0.0016
K_K28041  L_L211  L_L259  0.0016
K_K28042  L_L211  L_L260  0.0015
K_K28043  L_L211  L_L261  0.0015
K_K28044  L_L211  L_L262  0.0015
K_K28045  L_L211  L_L263  0.0015
K_K28046  L_L211  L_L264  0.0014
K_K28047  L_L211  L_L265  0.0014
K_K28048  L_L211  L_L266  0.0014
K_K28049  L_L211  L_L267  0.0014
K_K28050  L_L211  L_L268  0.0013
K_K28051  L_L211  L_L269  0.0013
K_K28052  L_L211  L_L270  0.0013
K_K28053  L_L211  L_L271  0.0013
K_K28054  L_L211  L_L272  0.0013
K_K28055  L_L211  L_L273  0.0012
K_K28056  L_L211  L_L274  0.0012
K_K28057  L_L211  L_L275  0.0012
K_K28058  L_L211  L_L276  0.0012
* *  Branch  NTMP0000000211 - NTMP0000000212
R_R212  NTMP0000000211  nU_212  32.914993m  TC=0,0
V_Ui212  nU_212  nR_212  STIMULUS=U_IND_0000000212
R_V423  nR_212  nV_423  23.280268m  TC=0,0
L_V423  nR_212  nV_423  0.014646uH
R_V424  nV_423  nV_424  7.852787m  TC=0,0
L_V424  nV_423  nV_424  0.073723uH
L_L212  nV_424  NTMP0000000212  6.519695uH
K_K28059  L_L212  L_L213  0.1050
K_K28060  L_L212  L_L214  0.0397
K_K28061  L_L212  L_L215  0.0258
K_K28062  L_L212  L_L216  0.0192
K_K28063  L_L212  L_L217  0.0153
K_K28064  L_L212  L_L218  0.0127
K_K28065  L_L212  L_L219  0.0109
K_K28066  L_L212  L_L220  0.0095
K_K28067  L_L212  L_L221  0.0084
K_K28068  L_L212  L_L222  0.0076
K_K28069  L_L212  L_L223  0.0069
K_K28070  L_L212  L_L224  0.0063
K_K28071  L_L212  L_L225  0.0058
K_K28072  L_L212  L_L226  0.0054
K_K28073  L_L212  L_L227  0.0051
K_K28074  L_L212  L_L228  0.0047
K_K28075  L_L212  L_L229  0.0045
K_K28076  L_L212  L_L230  0.0042
K_K28077  L_L212  L_L231  0.0040
K_K28078  L_L212  L_L232  0.0038
K_K28079  L_L212  L_L233  0.0036
K_K28080  L_L212  L_L234  0.0034
K_K28081  L_L212  L_L235  0.0033
K_K28082  L_L212  L_L236  0.0032
K_K28083  L_L212  L_L237  0.0030
K_K28084  L_L212  L_L238  0.0029
K_K28085  L_L212  L_L239  0.0028
K_K28086  L_L212  L_L240  0.0027
K_K28087  L_L212  L_L241  0.0026
K_K28088  L_L212  L_L242  0.0025
K_K28089  L_L212  L_L243  0.0024
K_K28090  L_L212  L_L244  0.0024
K_K28091  L_L212  L_L245  0.0023
K_K28092  L_L212  L_L246  0.0022
K_K28093  L_L212  L_L247  0.0022
K_K28094  L_L212  L_L248  0.0021
K_K28095  L_L212  L_L249  0.0020
K_K28096  L_L212  L_L250  0.0020
K_K28097  L_L212  L_L251  0.0019
K_K28098  L_L212  L_L252  0.0019
K_K28099  L_L212  L_L253  0.0019
K_K28100  L_L212  L_L254  0.0018
K_K28101  L_L212  L_L255  0.0018
K_K28102  L_L212  L_L256  0.0017
K_K28103  L_L212  L_L257  0.0017
K_K28104  L_L212  L_L258  0.0016
K_K28105  L_L212  L_L259  0.0016
K_K28106  L_L212  L_L260  0.0016
K_K28107  L_L212  L_L261  0.0015
K_K28108  L_L212  L_L262  0.0015
K_K28109  L_L212  L_L263  0.0015
K_K28110  L_L212  L_L264  0.0015
K_K28111  L_L212  L_L265  0.0014
K_K28112  L_L212  L_L266  0.0014
K_K28113  L_L212  L_L267  0.0014
K_K28114  L_L212  L_L268  0.0014
K_K28115  L_L212  L_L269  0.0013
K_K28116  L_L212  L_L270  0.0013
K_K28117  L_L212  L_L271  0.0013
K_K28118  L_L212  L_L272  0.0013
K_K28119  L_L212  L_L273  0.0013
K_K28120  L_L212  L_L274  0.0012
K_K28121  L_L212  L_L275  0.0012
K_K28122  L_L212  L_L276  0.0012
* *  Branch  NTMP0000000212 - NTMP0000000213
R_R213  NTMP0000000212  nU_213  32.914993m  TC=0,0
V_Ui213  nU_213  nR_213  STIMULUS=U_IND_0000000213
R_V425  nR_213  nV_425  23.280268m  TC=0,0
L_V425  nR_213  nV_425  0.014646uH
R_V426  nV_425  nV_426  7.852787m  TC=0,0
L_V426  nV_425  nV_426  0.073723uH
L_L213  nV_426  NTMP0000000213  6.519695uH
K_K28123  L_L213  L_L214  0.1050
K_K28124  L_L213  L_L215  0.0397
K_K28125  L_L213  L_L216  0.0258
K_K28126  L_L213  L_L217  0.0192
K_K28127  L_L213  L_L218  0.0153
K_K28128  L_L213  L_L219  0.0127
K_K28129  L_L213  L_L220  0.0109
K_K28130  L_L213  L_L221  0.0095
K_K28131  L_L213  L_L222  0.0084
K_K28132  L_L213  L_L223  0.0076
K_K28133  L_L213  L_L224  0.0069
K_K28134  L_L213  L_L225  0.0063
K_K28135  L_L213  L_L226  0.0058
K_K28136  L_L213  L_L227  0.0054
K_K28137  L_L213  L_L228  0.0051
K_K28138  L_L213  L_L229  0.0047
K_K28139  L_L213  L_L230  0.0045
K_K28140  L_L213  L_L231  0.0042
K_K28141  L_L213  L_L232  0.0040
K_K28142  L_L213  L_L233  0.0038
K_K28143  L_L213  L_L234  0.0036
K_K28144  L_L213  L_L235  0.0034
K_K28145  L_L213  L_L236  0.0033
K_K28146  L_L213  L_L237  0.0032
K_K28147  L_L213  L_L238  0.0030
K_K28148  L_L213  L_L239  0.0029
K_K28149  L_L213  L_L240  0.0028
K_K28150  L_L213  L_L241  0.0027
K_K28151  L_L213  L_L242  0.0026
K_K28152  L_L213  L_L243  0.0025
K_K28153  L_L213  L_L244  0.0024
K_K28154  L_L213  L_L245  0.0024
K_K28155  L_L213  L_L246  0.0023
K_K28156  L_L213  L_L247  0.0022
K_K28157  L_L213  L_L248  0.0022
K_K28158  L_L213  L_L249  0.0021
K_K28159  L_L213  L_L250  0.0020
K_K28160  L_L213  L_L251  0.0020
K_K28161  L_L213  L_L252  0.0019
K_K28162  L_L213  L_L253  0.0019
K_K28163  L_L213  L_L254  0.0019
K_K28164  L_L213  L_L255  0.0018
K_K28165  L_L213  L_L256  0.0018
K_K28166  L_L213  L_L257  0.0017
K_K28167  L_L213  L_L258  0.0017
K_K28168  L_L213  L_L259  0.0016
K_K28169  L_L213  L_L260  0.0016
K_K28170  L_L213  L_L261  0.0016
K_K28171  L_L213  L_L262  0.0015
K_K28172  L_L213  L_L263  0.0015
K_K28173  L_L213  L_L264  0.0015
K_K28174  L_L213  L_L265  0.0015
K_K28175  L_L213  L_L266  0.0014
K_K28176  L_L213  L_L267  0.0014
K_K28177  L_L213  L_L268  0.0014
K_K28178  L_L213  L_L269  0.0014
K_K28179  L_L213  L_L270  0.0013
K_K28180  L_L213  L_L271  0.0013
K_K28181  L_L213  L_L272  0.0013
K_K28182  L_L213  L_L273  0.0013
K_K28183  L_L213  L_L274  0.0013
K_K28184  L_L213  L_L275  0.0012
K_K28185  L_L213  L_L276  0.0012
* *  Branch  NTMP0000000213 - NTMP0000000214
R_R214  NTMP0000000213  nU_214  32.914993m  TC=0,0
V_Ui214  nU_214  nR_214  STIMULUS=U_IND_0000000214
R_V427  nR_214  nV_427  23.280268m  TC=0,0
L_V427  nR_214  nV_427  0.014646uH
R_V428  nV_427  nV_428  7.852787m  TC=0,0
L_V428  nV_427  nV_428  0.073723uH
L_L214  nV_428  NTMP0000000214  6.519695uH
K_K28186  L_L214  L_L215  0.1050
K_K28187  L_L214  L_L216  0.0397
K_K28188  L_L214  L_L217  0.0258
K_K28189  L_L214  L_L218  0.0192
K_K28190  L_L214  L_L219  0.0153
K_K28191  L_L214  L_L220  0.0127
K_K28192  L_L214  L_L221  0.0109
K_K28193  L_L214  L_L222  0.0095
K_K28194  L_L214  L_L223  0.0084
K_K28195  L_L214  L_L224  0.0076
K_K28196  L_L214  L_L225  0.0069
K_K28197  L_L214  L_L226  0.0063
K_K28198  L_L214  L_L227  0.0058
K_K28199  L_L214  L_L228  0.0054
K_K28200  L_L214  L_L229  0.0051
K_K28201  L_L214  L_L230  0.0047
K_K28202  L_L214  L_L231  0.0045
K_K28203  L_L214  L_L232  0.0042
K_K28204  L_L214  L_L233  0.0040
K_K28205  L_L214  L_L234  0.0038
K_K28206  L_L214  L_L235  0.0036
K_K28207  L_L214  L_L236  0.0034
K_K28208  L_L214  L_L237  0.0033
K_K28209  L_L214  L_L238  0.0032
K_K28210  L_L214  L_L239  0.0030
K_K28211  L_L214  L_L240  0.0029
K_K28212  L_L214  L_L241  0.0028
K_K28213  L_L214  L_L242  0.0027
K_K28214  L_L214  L_L243  0.0026
K_K28215  L_L214  L_L244  0.0025
K_K28216  L_L214  L_L245  0.0024
K_K28217  L_L214  L_L246  0.0024
K_K28218  L_L214  L_L247  0.0023
K_K28219  L_L214  L_L248  0.0022
K_K28220  L_L214  L_L249  0.0022
K_K28221  L_L214  L_L250  0.0021
K_K28222  L_L214  L_L251  0.0020
K_K28223  L_L214  L_L252  0.0020
K_K28224  L_L214  L_L253  0.0019
K_K28225  L_L214  L_L254  0.0019
K_K28226  L_L214  L_L255  0.0019
K_K28227  L_L214  L_L256  0.0018
K_K28228  L_L214  L_L257  0.0018
K_K28229  L_L214  L_L258  0.0017
K_K28230  L_L214  L_L259  0.0017
K_K28231  L_L214  L_L260  0.0016
K_K28232  L_L214  L_L261  0.0016
K_K28233  L_L214  L_L262  0.0016
K_K28234  L_L214  L_L263  0.0015
K_K28235  L_L214  L_L264  0.0015
K_K28236  L_L214  L_L265  0.0015
K_K28237  L_L214  L_L266  0.0015
K_K28238  L_L214  L_L267  0.0014
K_K28239  L_L214  L_L268  0.0014
K_K28240  L_L214  L_L269  0.0014
K_K28241  L_L214  L_L270  0.0014
K_K28242  L_L214  L_L271  0.0013
K_K28243  L_L214  L_L272  0.0013
K_K28244  L_L214  L_L273  0.0013
K_K28245  L_L214  L_L274  0.0013
K_K28246  L_L214  L_L275  0.0013
K_K28247  L_L214  L_L276  0.0012
* *  Branch  NTMP0000000214 - NTMP0000000215
R_R215  NTMP0000000214  nU_215  32.914993m  TC=0,0
V_Ui215  nU_215  nR_215  STIMULUS=U_IND_0000000215
R_V429  nR_215  nV_429  23.280268m  TC=0,0
L_V429  nR_215  nV_429  0.014646uH
R_V430  nV_429  nV_430  7.852787m  TC=0,0
L_V430  nV_429  nV_430  0.073723uH
L_L215  nV_430  NTMP0000000215  6.519695uH
K_K28248  L_L215  L_L216  0.1050
K_K28249  L_L215  L_L217  0.0397
K_K28250  L_L215  L_L218  0.0258
K_K28251  L_L215  L_L219  0.0192
K_K28252  L_L215  L_L220  0.0153
K_K28253  L_L215  L_L221  0.0127
K_K28254  L_L215  L_L222  0.0109
K_K28255  L_L215  L_L223  0.0095
K_K28256  L_L215  L_L224  0.0084
K_K28257  L_L215  L_L225  0.0076
K_K28258  L_L215  L_L226  0.0069
K_K28259  L_L215  L_L227  0.0063
K_K28260  L_L215  L_L228  0.0058
K_K28261  L_L215  L_L229  0.0054
K_K28262  L_L215  L_L230  0.0051
K_K28263  L_L215  L_L231  0.0047
K_K28264  L_L215  L_L232  0.0045
K_K28265  L_L215  L_L233  0.0042
K_K28266  L_L215  L_L234  0.0040
K_K28267  L_L215  L_L235  0.0038
K_K28268  L_L215  L_L236  0.0036
K_K28269  L_L215  L_L237  0.0034
K_K28270  L_L215  L_L238  0.0033
K_K28271  L_L215  L_L239  0.0032
K_K28272  L_L215  L_L240  0.0030
K_K28273  L_L215  L_L241  0.0029
K_K28274  L_L215  L_L242  0.0028
K_K28275  L_L215  L_L243  0.0027
K_K28276  L_L215  L_L244  0.0026
K_K28277  L_L215  L_L245  0.0025
K_K28278  L_L215  L_L246  0.0024
K_K28279  L_L215  L_L247  0.0024
K_K28280  L_L215  L_L248  0.0023
K_K28281  L_L215  L_L249  0.0022
K_K28282  L_L215  L_L250  0.0022
K_K28283  L_L215  L_L251  0.0021
K_K28284  L_L215  L_L252  0.0020
K_K28285  L_L215  L_L253  0.0020
K_K28286  L_L215  L_L254  0.0019
K_K28287  L_L215  L_L255  0.0019
K_K28288  L_L215  L_L256  0.0019
K_K28289  L_L215  L_L257  0.0018
K_K28290  L_L215  L_L258  0.0018
K_K28291  L_L215  L_L259  0.0017
K_K28292  L_L215  L_L260  0.0017
K_K28293  L_L215  L_L261  0.0016
K_K28294  L_L215  L_L262  0.0016
K_K28295  L_L215  L_L263  0.0016
K_K28296  L_L215  L_L264  0.0015
K_K28297  L_L215  L_L265  0.0015
K_K28298  L_L215  L_L266  0.0015
K_K28299  L_L215  L_L267  0.0015
K_K28300  L_L215  L_L268  0.0014
K_K28301  L_L215  L_L269  0.0014
K_K28302  L_L215  L_L270  0.0014
K_K28303  L_L215  L_L271  0.0014
K_K28304  L_L215  L_L272  0.0013
K_K28305  L_L215  L_L273  0.0013
K_K28306  L_L215  L_L274  0.0013
K_K28307  L_L215  L_L275  0.0013
K_K28308  L_L215  L_L276  0.0013
* *  Branch  NTMP0000000215 - NTMP0000000216
R_R216  NTMP0000000215  nU_216  32.914993m  TC=0,0
V_Ui216  nU_216  nR_216  STIMULUS=U_IND_0000000216
R_V431  nR_216  nV_431  23.280268m  TC=0,0
L_V431  nR_216  nV_431  0.014646uH
R_V432  nV_431  nV_432  7.852787m  TC=0,0
L_V432  nV_431  nV_432  0.073723uH
L_L216  nV_432  NTMP0000000216  6.519695uH
K_K28309  L_L216  L_L217  0.1050
K_K28310  L_L216  L_L218  0.0397
K_K28311  L_L216  L_L219  0.0258
K_K28312  L_L216  L_L220  0.0192
K_K28313  L_L216  L_L221  0.0153
K_K28314  L_L216  L_L222  0.0127
K_K28315  L_L216  L_L223  0.0109
K_K28316  L_L216  L_L224  0.0095
K_K28317  L_L216  L_L225  0.0084
K_K28318  L_L216  L_L226  0.0076
K_K28319  L_L216  L_L227  0.0069
K_K28320  L_L216  L_L228  0.0063
K_K28321  L_L216  L_L229  0.0058
K_K28322  L_L216  L_L230  0.0054
K_K28323  L_L216  L_L231  0.0051
K_K28324  L_L216  L_L232  0.0047
K_K28325  L_L216  L_L233  0.0045
K_K28326  L_L216  L_L234  0.0042
K_K28327  L_L216  L_L235  0.0040
K_K28328  L_L216  L_L236  0.0038
K_K28329  L_L216  L_L237  0.0036
K_K28330  L_L216  L_L238  0.0034
K_K28331  L_L216  L_L239  0.0033
K_K28332  L_L216  L_L240  0.0032
K_K28333  L_L216  L_L241  0.0030
K_K28334  L_L216  L_L242  0.0029
K_K28335  L_L216  L_L243  0.0028
K_K28336  L_L216  L_L244  0.0027
K_K28337  L_L216  L_L245  0.0026
K_K28338  L_L216  L_L246  0.0025
K_K28339  L_L216  L_L247  0.0024
K_K28340  L_L216  L_L248  0.0024
K_K28341  L_L216  L_L249  0.0023
K_K28342  L_L216  L_L250  0.0022
K_K28343  L_L216  L_L251  0.0022
K_K28344  L_L216  L_L252  0.0021
K_K28345  L_L216  L_L253  0.0020
K_K28346  L_L216  L_L254  0.0020
K_K28347  L_L216  L_L255  0.0019
K_K28348  L_L216  L_L256  0.0019
K_K28349  L_L216  L_L257  0.0019
K_K28350  L_L216  L_L258  0.0018
K_K28351  L_L216  L_L259  0.0018
K_K28352  L_L216  L_L260  0.0017
K_K28353  L_L216  L_L261  0.0017
K_K28354  L_L216  L_L262  0.0016
K_K28355  L_L216  L_L263  0.0016
K_K28356  L_L216  L_L264  0.0016
K_K28357  L_L216  L_L265  0.0015
K_K28358  L_L216  L_L266  0.0015
K_K28359  L_L216  L_L267  0.0015
K_K28360  L_L216  L_L268  0.0015
K_K28361  L_L216  L_L269  0.0014
K_K28362  L_L216  L_L270  0.0014
K_K28363  L_L216  L_L271  0.0014
K_K28364  L_L216  L_L272  0.0014
K_K28365  L_L216  L_L273  0.0013
K_K28366  L_L216  L_L274  0.0013
K_K28367  L_L216  L_L275  0.0013
K_K28368  L_L216  L_L276  0.0013
* *  Branch  NTMP0000000216 - NTMP0000000217
R_R217  NTMP0000000216  nU_217  32.914993m  TC=0,0
V_Ui217  nU_217  nR_217  STIMULUS=U_IND_0000000217
R_V433  nR_217  nV_433  23.280268m  TC=0,0
L_V433  nR_217  nV_433  0.014646uH
R_V434  nV_433  nV_434  7.852787m  TC=0,0
L_V434  nV_433  nV_434  0.073723uH
L_L217  nV_434  NTMP0000000217  6.519695uH
K_K28369  L_L217  L_L218  0.1050
K_K28370  L_L217  L_L219  0.0397
K_K28371  L_L217  L_L220  0.0258
K_K28372  L_L217  L_L221  0.0192
K_K28373  L_L217  L_L222  0.0153
K_K28374  L_L217  L_L223  0.0127
K_K28375  L_L217  L_L224  0.0109
K_K28376  L_L217  L_L225  0.0095
K_K28377  L_L217  L_L226  0.0084
K_K28378  L_L217  L_L227  0.0076
K_K28379  L_L217  L_L228  0.0069
K_K28380  L_L217  L_L229  0.0063
K_K28381  L_L217  L_L230  0.0058
K_K28382  L_L217  L_L231  0.0054
K_K28383  L_L217  L_L232  0.0051
K_K28384  L_L217  L_L233  0.0047
K_K28385  L_L217  L_L234  0.0045
K_K28386  L_L217  L_L235  0.0042
K_K28387  L_L217  L_L236  0.0040
K_K28388  L_L217  L_L237  0.0038
K_K28389  L_L217  L_L238  0.0036
K_K28390  L_L217  L_L239  0.0034
K_K28391  L_L217  L_L240  0.0033
K_K28392  L_L217  L_L241  0.0032
K_K28393  L_L217  L_L242  0.0030
K_K28394  L_L217  L_L243  0.0029
K_K28395  L_L217  L_L244  0.0028
K_K28396  L_L217  L_L245  0.0027
K_K28397  L_L217  L_L246  0.0026
K_K28398  L_L217  L_L247  0.0025
K_K28399  L_L217  L_L248  0.0024
K_K28400  L_L217  L_L249  0.0024
K_K28401  L_L217  L_L250  0.0023
K_K28402  L_L217  L_L251  0.0022
K_K28403  L_L217  L_L252  0.0022
K_K28404  L_L217  L_L253  0.0021
K_K28405  L_L217  L_L254  0.0020
K_K28406  L_L217  L_L255  0.0020
K_K28407  L_L217  L_L256  0.0019
K_K28408  L_L217  L_L257  0.0019
K_K28409  L_L217  L_L258  0.0019
K_K28410  L_L217  L_L259  0.0018
K_K28411  L_L217  L_L260  0.0018
K_K28412  L_L217  L_L261  0.0017
K_K28413  L_L217  L_L262  0.0017
K_K28414  L_L217  L_L263  0.0016
K_K28415  L_L217  L_L264  0.0016
K_K28416  L_L217  L_L265  0.0016
K_K28417  L_L217  L_L266  0.0015
K_K28418  L_L217  L_L267  0.0015
K_K28419  L_L217  L_L268  0.0015
K_K28420  L_L217  L_L269  0.0015
K_K28421  L_L217  L_L270  0.0014
K_K28422  L_L217  L_L271  0.0014
K_K28423  L_L217  L_L272  0.0014
K_K28424  L_L217  L_L273  0.0014
K_K28425  L_L217  L_L274  0.0013
K_K28426  L_L217  L_L275  0.0013
K_K28427  L_L217  L_L276  0.0013
* *  Branch  NTMP0000000217 - NTMP0000000218
R_R218  NTMP0000000217  nU_218  32.914993m  TC=0,0
V_Ui218  nU_218  nR_218  STIMULUS=U_IND_0000000218
R_V435  nR_218  nV_435  23.280268m  TC=0,0
L_V435  nR_218  nV_435  0.014646uH
R_V436  nV_435  nV_436  7.852787m  TC=0,0
L_V436  nV_435  nV_436  0.073723uH
L_L218  nV_436  NTMP0000000218  6.519695uH
K_K28428  L_L218  L_L219  0.1050
K_K28429  L_L218  L_L220  0.0397
K_K28430  L_L218  L_L221  0.0258
K_K28431  L_L218  L_L222  0.0192
K_K28432  L_L218  L_L223  0.0153
K_K28433  L_L218  L_L224  0.0127
K_K28434  L_L218  L_L225  0.0109
K_K28435  L_L218  L_L226  0.0095
K_K28436  L_L218  L_L227  0.0084
K_K28437  L_L218  L_L228  0.0076
K_K28438  L_L218  L_L229  0.0069
K_K28439  L_L218  L_L230  0.0063
K_K28440  L_L218  L_L231  0.0058
K_K28441  L_L218  L_L232  0.0054
K_K28442  L_L218  L_L233  0.0051
K_K28443  L_L218  L_L234  0.0047
K_K28444  L_L218  L_L235  0.0045
K_K28445  L_L218  L_L236  0.0042
K_K28446  L_L218  L_L237  0.0040
K_K28447  L_L218  L_L238  0.0038
K_K28448  L_L218  L_L239  0.0036
K_K28449  L_L218  L_L240  0.0034
K_K28450  L_L218  L_L241  0.0033
K_K28451  L_L218  L_L242  0.0032
K_K28452  L_L218  L_L243  0.0030
K_K28453  L_L218  L_L244  0.0029
K_K28454  L_L218  L_L245  0.0028
K_K28455  L_L218  L_L246  0.0027
K_K28456  L_L218  L_L247  0.0026
K_K28457  L_L218  L_L248  0.0025
K_K28458  L_L218  L_L249  0.0024
K_K28459  L_L218  L_L250  0.0024
K_K28460  L_L218  L_L251  0.0023
K_K28461  L_L218  L_L252  0.0022
K_K28462  L_L218  L_L253  0.0022
K_K28463  L_L218  L_L254  0.0021
K_K28464  L_L218  L_L255  0.0020
K_K28465  L_L218  L_L256  0.0020
K_K28466  L_L218  L_L257  0.0019
K_K28467  L_L218  L_L258  0.0019
K_K28468  L_L218  L_L259  0.0019
K_K28469  L_L218  L_L260  0.0018
K_K28470  L_L218  L_L261  0.0018
K_K28471  L_L218  L_L262  0.0017
K_K28472  L_L218  L_L263  0.0017
K_K28473  L_L218  L_L264  0.0017
K_K28474  L_L218  L_L265  0.0016
K_K28475  L_L218  L_L266  0.0016
K_K28476  L_L218  L_L267  0.0015
K_K28477  L_L218  L_L268  0.0015
K_K28478  L_L218  L_L269  0.0015
K_K28479  L_L218  L_L270  0.0015
K_K28480  L_L218  L_L271  0.0014
K_K28481  L_L218  L_L272  0.0014
K_K28482  L_L218  L_L273  0.0014
K_K28483  L_L218  L_L274  0.0014
K_K28484  L_L218  L_L275  0.0013
K_K28485  L_L218  L_L276  0.0013
* *  Branch  NTMP0000000218 - NTMP0000000219
R_R219  NTMP0000000218  nU_219  32.914993m  TC=0,0
V_Ui219  nU_219  nR_219  STIMULUS=U_IND_0000000219
R_V437  nR_219  nV_437  23.280268m  TC=0,0
L_V437  nR_219  nV_437  0.014646uH
R_V438  nV_437  nV_438  7.852787m  TC=0,0
L_V438  nV_437  nV_438  0.073723uH
L_L219  nV_438  NTMP0000000219  6.519695uH
K_K28486  L_L219  L_L220  0.1050
K_K28487  L_L219  L_L221  0.0397
K_K28488  L_L219  L_L222  0.0258
K_K28489  L_L219  L_L223  0.0192
K_K28490  L_L219  L_L224  0.0153
K_K28491  L_L219  L_L225  0.0127
K_K28492  L_L219  L_L226  0.0109
K_K28493  L_L219  L_L227  0.0095
K_K28494  L_L219  L_L228  0.0084
K_K28495  L_L219  L_L229  0.0076
K_K28496  L_L219  L_L230  0.0069
K_K28497  L_L219  L_L231  0.0063
K_K28498  L_L219  L_L232  0.0058
K_K28499  L_L219  L_L233  0.0054
K_K28500  L_L219  L_L234  0.0051
K_K28501  L_L219  L_L235  0.0047
K_K28502  L_L219  L_L236  0.0045
K_K28503  L_L219  L_L237  0.0042
K_K28504  L_L219  L_L238  0.0040
K_K28505  L_L219  L_L239  0.0038
K_K28506  L_L219  L_L240  0.0036
K_K28507  L_L219  L_L241  0.0034
K_K28508  L_L219  L_L242  0.0033
K_K28509  L_L219  L_L243  0.0032
K_K28510  L_L219  L_L244  0.0030
K_K28511  L_L219  L_L245  0.0029
K_K28512  L_L219  L_L246  0.0028
K_K28513  L_L219  L_L247  0.0027
K_K28514  L_L219  L_L248  0.0026
K_K28515  L_L219  L_L249  0.0025
K_K28516  L_L219  L_L250  0.0024
K_K28517  L_L219  L_L251  0.0024
K_K28518  L_L219  L_L252  0.0023
K_K28519  L_L219  L_L253  0.0022
K_K28520  L_L219  L_L254  0.0022
K_K28521  L_L219  L_L255  0.0021
K_K28522  L_L219  L_L256  0.0020
K_K28523  L_L219  L_L257  0.0020
K_K28524  L_L219  L_L258  0.0019
K_K28525  L_L219  L_L259  0.0019
K_K28526  L_L219  L_L260  0.0019
K_K28527  L_L219  L_L261  0.0018
K_K28528  L_L219  L_L262  0.0018
K_K28529  L_L219  L_L263  0.0017
K_K28530  L_L219  L_L264  0.0017
K_K28531  L_L219  L_L265  0.0017
K_K28532  L_L219  L_L266  0.0016
K_K28533  L_L219  L_L267  0.0016
K_K28534  L_L219  L_L268  0.0015
K_K28535  L_L219  L_L269  0.0015
K_K28536  L_L219  L_L270  0.0015
K_K28537  L_L219  L_L271  0.0015
K_K28538  L_L219  L_L272  0.0014
K_K28539  L_L219  L_L273  0.0014
K_K28540  L_L219  L_L274  0.0014
K_K28541  L_L219  L_L275  0.0014
K_K28542  L_L219  L_L276  0.0013
* *  Branch  NTMP0000000219 - NTMP0000000220
R_R220  NTMP0000000219  nU_220  32.914993m  TC=0,0
V_Ui220  nU_220  nR_220  STIMULUS=U_IND_0000000220
R_V439  nR_220  nV_439  23.280268m  TC=0,0
L_V439  nR_220  nV_439  0.014646uH
R_V440  nV_439  nV_440  7.852787m  TC=0,0
L_V440  nV_439  nV_440  0.073723uH
L_L220  nV_440  NTMP0000000220  6.519695uH
K_K28543  L_L220  L_L221  0.1050
K_K28544  L_L220  L_L222  0.0397
K_K28545  L_L220  L_L223  0.0258
K_K28546  L_L220  L_L224  0.0192
K_K28547  L_L220  L_L225  0.0153
K_K28548  L_L220  L_L226  0.0127
K_K28549  L_L220  L_L227  0.0109
K_K28550  L_L220  L_L228  0.0095
K_K28551  L_L220  L_L229  0.0084
K_K28552  L_L220  L_L230  0.0076
K_K28553  L_L220  L_L231  0.0069
K_K28554  L_L220  L_L232  0.0063
K_K28555  L_L220  L_L233  0.0058
K_K28556  L_L220  L_L234  0.0054
K_K28557  L_L220  L_L235  0.0051
K_K28558  L_L220  L_L236  0.0047
K_K28559  L_L220  L_L237  0.0045
K_K28560  L_L220  L_L238  0.0042
K_K28561  L_L220  L_L239  0.0040
K_K28562  L_L220  L_L240  0.0038
K_K28563  L_L220  L_L241  0.0036
K_K28564  L_L220  L_L242  0.0034
K_K28565  L_L220  L_L243  0.0033
K_K28566  L_L220  L_L244  0.0032
K_K28567  L_L220  L_L245  0.0030
K_K28568  L_L220  L_L246  0.0029
K_K28569  L_L220  L_L247  0.0028
K_K28570  L_L220  L_L248  0.0027
K_K28571  L_L220  L_L249  0.0026
K_K28572  L_L220  L_L250  0.0025
K_K28573  L_L220  L_L251  0.0024
K_K28574  L_L220  L_L252  0.0024
K_K28575  L_L220  L_L253  0.0023
K_K28576  L_L220  L_L254  0.0022
K_K28577  L_L220  L_L255  0.0022
K_K28578  L_L220  L_L256  0.0021
K_K28579  L_L220  L_L257  0.0020
K_K28580  L_L220  L_L258  0.0020
K_K28581  L_L220  L_L259  0.0019
K_K28582  L_L220  L_L260  0.0019
K_K28583  L_L220  L_L261  0.0019
K_K28584  L_L220  L_L262  0.0018
K_K28585  L_L220  L_L263  0.0018
K_K28586  L_L220  L_L264  0.0017
K_K28587  L_L220  L_L265  0.0017
K_K28588  L_L220  L_L266  0.0017
K_K28589  L_L220  L_L267  0.0016
K_K28590  L_L220  L_L268  0.0016
K_K28591  L_L220  L_L269  0.0015
K_K28592  L_L220  L_L270  0.0015
K_K28593  L_L220  L_L271  0.0015
K_K28594  L_L220  L_L272  0.0015
K_K28595  L_L220  L_L273  0.0014
K_K28596  L_L220  L_L274  0.0014
K_K28597  L_L220  L_L275  0.0014
K_K28598  L_L220  L_L276  0.0014
* *  Branch  NTMP0000000220 - NTMP0000000221
R_R221  NTMP0000000220  nU_221  32.914993m  TC=0,0
V_Ui221  nU_221  nR_221  STIMULUS=U_IND_0000000221
R_V441  nR_221  nV_441  23.280268m  TC=0,0
L_V441  nR_221  nV_441  0.014646uH
R_V442  nV_441  nV_442  7.852787m  TC=0,0
L_V442  nV_441  nV_442  0.073723uH
L_L221  nV_442  NTMP0000000221  6.519695uH
K_K28599  L_L221  L_L222  0.1050
K_K28600  L_L221  L_L223  0.0397
K_K28601  L_L221  L_L224  0.0258
K_K28602  L_L221  L_L225  0.0192
K_K28603  L_L221  L_L226  0.0153
K_K28604  L_L221  L_L227  0.0127
K_K28605  L_L221  L_L228  0.0109
K_K28606  L_L221  L_L229  0.0095
K_K28607  L_L221  L_L230  0.0084
K_K28608  L_L221  L_L231  0.0076
K_K28609  L_L221  L_L232  0.0069
K_K28610  L_L221  L_L233  0.0063
K_K28611  L_L221  L_L234  0.0058
K_K28612  L_L221  L_L235  0.0054
K_K28613  L_L221  L_L236  0.0051
K_K28614  L_L221  L_L237  0.0047
K_K28615  L_L221  L_L238  0.0045
K_K28616  L_L221  L_L239  0.0042
K_K28617  L_L221  L_L240  0.0040
K_K28618  L_L221  L_L241  0.0038
K_K28619  L_L221  L_L242  0.0036
K_K28620  L_L221  L_L243  0.0034
K_K28621  L_L221  L_L244  0.0033
K_K28622  L_L221  L_L245  0.0032
K_K28623  L_L221  L_L246  0.0030
K_K28624  L_L221  L_L247  0.0029
K_K28625  L_L221  L_L248  0.0028
K_K28626  L_L221  L_L249  0.0027
K_K28627  L_L221  L_L250  0.0026
K_K28628  L_L221  L_L251  0.0025
K_K28629  L_L221  L_L252  0.0024
K_K28630  L_L221  L_L253  0.0024
K_K28631  L_L221  L_L254  0.0023
K_K28632  L_L221  L_L255  0.0022
K_K28633  L_L221  L_L256  0.0022
K_K28634  L_L221  L_L257  0.0021
K_K28635  L_L221  L_L258  0.0020
K_K28636  L_L221  L_L259  0.0020
K_K28637  L_L221  L_L260  0.0019
K_K28638  L_L221  L_L261  0.0019
K_K28639  L_L221  L_L262  0.0019
K_K28640  L_L221  L_L263  0.0018
K_K28641  L_L221  L_L264  0.0018
K_K28642  L_L221  L_L265  0.0017
K_K28643  L_L221  L_L266  0.0017
K_K28644  L_L221  L_L267  0.0017
K_K28645  L_L221  L_L268  0.0016
K_K28646  L_L221  L_L269  0.0016
K_K28647  L_L221  L_L270  0.0015
K_K28648  L_L221  L_L271  0.0015
K_K28649  L_L221  L_L272  0.0015
K_K28650  L_L221  L_L273  0.0015
K_K28651  L_L221  L_L274  0.0014
K_K28652  L_L221  L_L275  0.0014
K_K28653  L_L221  L_L276  0.0014
* *  Branch  NTMP0000000221 - NTMP0000000222
R_R222  NTMP0000000221  nU_222  32.914993m  TC=0,0
V_Ui222  nU_222  nR_222  STIMULUS=U_IND_0000000222
R_V443  nR_222  nV_443  23.280268m  TC=0,0
L_V443  nR_222  nV_443  0.014646uH
R_V444  nV_443  nV_444  7.852787m  TC=0,0
L_V444  nV_443  nV_444  0.073723uH
L_L222  nV_444  NTMP0000000222  6.519695uH
K_K28654  L_L222  L_L223  0.1050
K_K28655  L_L222  L_L224  0.0397
K_K28656  L_L222  L_L225  0.0258
K_K28657  L_L222  L_L226  0.0192
K_K28658  L_L222  L_L227  0.0153
K_K28659  L_L222  L_L228  0.0127
K_K28660  L_L222  L_L229  0.0109
K_K28661  L_L222  L_L230  0.0095
K_K28662  L_L222  L_L231  0.0084
K_K28663  L_L222  L_L232  0.0076
K_K28664  L_L222  L_L233  0.0069
K_K28665  L_L222  L_L234  0.0063
K_K28666  L_L222  L_L235  0.0058
K_K28667  L_L222  L_L236  0.0054
K_K28668  L_L222  L_L237  0.0051
K_K28669  L_L222  L_L238  0.0047
K_K28670  L_L222  L_L239  0.0045
K_K28671  L_L222  L_L240  0.0042
K_K28672  L_L222  L_L241  0.0040
K_K28673  L_L222  L_L242  0.0038
K_K28674  L_L222  L_L243  0.0036
K_K28675  L_L222  L_L244  0.0034
K_K28676  L_L222  L_L245  0.0033
K_K28677  L_L222  L_L246  0.0032
K_K28678  L_L222  L_L247  0.0030
K_K28679  L_L222  L_L248  0.0029
K_K28680  L_L222  L_L249  0.0028
K_K28681  L_L222  L_L250  0.0027
K_K28682  L_L222  L_L251  0.0026
K_K28683  L_L222  L_L252  0.0025
K_K28684  L_L222  L_L253  0.0024
K_K28685  L_L222  L_L254  0.0024
K_K28686  L_L222  L_L255  0.0023
K_K28687  L_L222  L_L256  0.0022
K_K28688  L_L222  L_L257  0.0022
K_K28689  L_L222  L_L258  0.0021
K_K28690  L_L222  L_L259  0.0020
K_K28691  L_L222  L_L260  0.0020
K_K28692  L_L222  L_L261  0.0019
K_K28693  L_L222  L_L262  0.0019
K_K28694  L_L222  L_L263  0.0019
K_K28695  L_L222  L_L264  0.0018
K_K28696  L_L222  L_L265  0.0018
K_K28697  L_L222  L_L266  0.0017
K_K28698  L_L222  L_L267  0.0017
K_K28699  L_L222  L_L268  0.0017
K_K28700  L_L222  L_L269  0.0016
K_K28701  L_L222  L_L270  0.0016
K_K28702  L_L222  L_L271  0.0015
K_K28703  L_L222  L_L272  0.0015
K_K28704  L_L222  L_L273  0.0015
K_K28705  L_L222  L_L274  0.0015
K_K28706  L_L222  L_L275  0.0014
K_K28707  L_L222  L_L276  0.0014
* *  Branch  NTMP0000000222 - NTMP0000000223
R_R223  NTMP0000000222  nU_223  32.914993m  TC=0,0
V_Ui223  nU_223  nR_223  STIMULUS=U_IND_0000000223
R_V445  nR_223  nV_445  23.280268m  TC=0,0
L_V445  nR_223  nV_445  0.014646uH
R_V446  nV_445  nV_446  7.852787m  TC=0,0
L_V446  nV_445  nV_446  0.073723uH
L_L223  nV_446  NTMP0000000223  6.519695uH
K_K28708  L_L223  L_L224  0.1050
K_K28709  L_L223  L_L225  0.0397
K_K28710  L_L223  L_L226  0.0258
K_K28711  L_L223  L_L227  0.0192
K_K28712  L_L223  L_L228  0.0153
K_K28713  L_L223  L_L229  0.0127
K_K28714  L_L223  L_L230  0.0109
K_K28715  L_L223  L_L231  0.0095
K_K28716  L_L223  L_L232  0.0084
K_K28717  L_L223  L_L233  0.0076
K_K28718  L_L223  L_L234  0.0069
K_K28719  L_L223  L_L235  0.0063
K_K28720  L_L223  L_L236  0.0058
K_K28721  L_L223  L_L237  0.0054
K_K28722  L_L223  L_L238  0.0051
K_K28723  L_L223  L_L239  0.0047
K_K28724  L_L223  L_L240  0.0045
K_K28725  L_L223  L_L241  0.0042
K_K28726  L_L223  L_L242  0.0040
K_K28727  L_L223  L_L243  0.0038
K_K28728  L_L223  L_L244  0.0036
K_K28729  L_L223  L_L245  0.0034
K_K28730  L_L223  L_L246  0.0033
K_K28731  L_L223  L_L247  0.0032
K_K28732  L_L223  L_L248  0.0030
K_K28733  L_L223  L_L249  0.0029
K_K28734  L_L223  L_L250  0.0028
K_K28735  L_L223  L_L251  0.0027
K_K28736  L_L223  L_L252  0.0026
K_K28737  L_L223  L_L253  0.0025
K_K28738  L_L223  L_L254  0.0024
K_K28739  L_L223  L_L255  0.0024
K_K28740  L_L223  L_L256  0.0023
K_K28741  L_L223  L_L257  0.0022
K_K28742  L_L223  L_L258  0.0022
K_K28743  L_L223  L_L259  0.0021
K_K28744  L_L223  L_L260  0.0020
K_K28745  L_L223  L_L261  0.0020
K_K28746  L_L223  L_L262  0.0019
K_K28747  L_L223  L_L263  0.0019
K_K28748  L_L223  L_L264  0.0019
K_K28749  L_L223  L_L265  0.0018
K_K28750  L_L223  L_L266  0.0018
K_K28751  L_L223  L_L267  0.0017
K_K28752  L_L223  L_L268  0.0017
K_K28753  L_L223  L_L269  0.0017
K_K28754  L_L223  L_L270  0.0016
K_K28755  L_L223  L_L271  0.0016
K_K28756  L_L223  L_L272  0.0015
K_K28757  L_L223  L_L273  0.0015
K_K28758  L_L223  L_L274  0.0015
K_K28759  L_L223  L_L275  0.0015
K_K28760  L_L223  L_L276  0.0014
* *  Branch  NTMP0000000223 - NTMP0000000224
R_R224  NTMP0000000223  nU_224  32.914993m  TC=0,0
V_Ui224  nU_224  nR_224  STIMULUS=U_IND_0000000224
R_V447  nR_224  nV_447  23.280268m  TC=0,0
L_V447  nR_224  nV_447  0.014646uH
R_V448  nV_447  nV_448  7.852787m  TC=0,0
L_V448  nV_447  nV_448  0.073723uH
L_L224  nV_448  NTMP0000000224  6.519695uH
K_K28761  L_L224  L_L225  0.1050
K_K28762  L_L224  L_L226  0.0397
K_K28763  L_L224  L_L227  0.0258
K_K28764  L_L224  L_L228  0.0192
K_K28765  L_L224  L_L229  0.0153
K_K28766  L_L224  L_L230  0.0127
K_K28767  L_L224  L_L231  0.0109
K_K28768  L_L224  L_L232  0.0095
K_K28769  L_L224  L_L233  0.0084
K_K28770  L_L224  L_L234  0.0076
K_K28771  L_L224  L_L235  0.0069
K_K28772  L_L224  L_L236  0.0063
K_K28773  L_L224  L_L237  0.0058
K_K28774  L_L224  L_L238  0.0054
K_K28775  L_L224  L_L239  0.0051
K_K28776  L_L224  L_L240  0.0047
K_K28777  L_L224  L_L241  0.0045
K_K28778  L_L224  L_L242  0.0042
K_K28779  L_L224  L_L243  0.0040
K_K28780  L_L224  L_L244  0.0038
K_K28781  L_L224  L_L245  0.0036
K_K28782  L_L224  L_L246  0.0034
K_K28783  L_L224  L_L247  0.0033
K_K28784  L_L224  L_L248  0.0032
K_K28785  L_L224  L_L249  0.0030
K_K28786  L_L224  L_L250  0.0029
K_K28787  L_L224  L_L251  0.0028
K_K28788  L_L224  L_L252  0.0027
K_K28789  L_L224  L_L253  0.0026
K_K28790  L_L224  L_L254  0.0025
K_K28791  L_L224  L_L255  0.0024
K_K28792  L_L224  L_L256  0.0024
K_K28793  L_L224  L_L257  0.0023
K_K28794  L_L224  L_L258  0.0022
K_K28795  L_L224  L_L259  0.0022
K_K28796  L_L224  L_L260  0.0021
K_K28797  L_L224  L_L261  0.0020
K_K28798  L_L224  L_L262  0.0020
K_K28799  L_L224  L_L263  0.0019
K_K28800  L_L224  L_L264  0.0019
K_K28801  L_L224  L_L265  0.0019
K_K28802  L_L224  L_L266  0.0018
K_K28803  L_L224  L_L267  0.0018
K_K28804  L_L224  L_L268  0.0017
K_K28805  L_L224  L_L269  0.0017
K_K28806  L_L224  L_L270  0.0017
K_K28807  L_L224  L_L271  0.0016
K_K28808  L_L224  L_L272  0.0016
K_K28809  L_L224  L_L273  0.0015
K_K28810  L_L224  L_L274  0.0015
K_K28811  L_L224  L_L275  0.0015
K_K28812  L_L224  L_L276  0.0015
* *  Branch  NTMP0000000224 - NTMP0000000225
R_R225  NTMP0000000224  nU_225  32.914993m  TC=0,0
V_Ui225  nU_225  nR_225  STIMULUS=U_IND_0000000225
R_V449  nR_225  nV_449  23.280268m  TC=0,0
L_V449  nR_225  nV_449  0.014646uH
R_V450  nV_449  nV_450  7.852787m  TC=0,0
L_V450  nV_449  nV_450  0.073723uH
L_L225  nV_450  NTMP0000000225  6.519695uH
K_K28813  L_L225  L_L226  0.1050
K_K28814  L_L225  L_L227  0.0397
K_K28815  L_L225  L_L228  0.0258
K_K28816  L_L225  L_L229  0.0192
K_K28817  L_L225  L_L230  0.0153
K_K28818  L_L225  L_L231  0.0127
K_K28819  L_L225  L_L232  0.0109
K_K28820  L_L225  L_L233  0.0095
K_K28821  L_L225  L_L234  0.0084
K_K28822  L_L225  L_L235  0.0076
K_K28823  L_L225  L_L236  0.0069
K_K28824  L_L225  L_L237  0.0063
K_K28825  L_L225  L_L238  0.0058
K_K28826  L_L225  L_L239  0.0054
K_K28827  L_L225  L_L240  0.0051
K_K28828  L_L225  L_L241  0.0047
K_K28829  L_L225  L_L242  0.0045
K_K28830  L_L225  L_L243  0.0042
K_K28831  L_L225  L_L244  0.0040
K_K28832  L_L225  L_L245  0.0038
K_K28833  L_L225  L_L246  0.0036
K_K28834  L_L225  L_L247  0.0034
K_K28835  L_L225  L_L248  0.0033
K_K28836  L_L225  L_L249  0.0032
K_K28837  L_L225  L_L250  0.0030
K_K28838  L_L225  L_L251  0.0029
K_K28839  L_L225  L_L252  0.0028
K_K28840  L_L225  L_L253  0.0027
K_K28841  L_L225  L_L254  0.0026
K_K28842  L_L225  L_L255  0.0025
K_K28843  L_L225  L_L256  0.0024
K_K28844  L_L225  L_L257  0.0024
K_K28845  L_L225  L_L258  0.0023
K_K28846  L_L225  L_L259  0.0022
K_K28847  L_L225  L_L260  0.0022
K_K28848  L_L225  L_L261  0.0021
K_K28849  L_L225  L_L262  0.0020
K_K28850  L_L225  L_L263  0.0020
K_K28851  L_L225  L_L264  0.0019
K_K28852  L_L225  L_L265  0.0019
K_K28853  L_L225  L_L266  0.0019
K_K28854  L_L225  L_L267  0.0018
K_K28855  L_L225  L_L268  0.0018
K_K28856  L_L225  L_L269  0.0017
K_K28857  L_L225  L_L270  0.0017
K_K28858  L_L225  L_L271  0.0017
K_K28859  L_L225  L_L272  0.0016
K_K28860  L_L225  L_L273  0.0016
K_K28861  L_L225  L_L274  0.0015
K_K28862  L_L225  L_L275  0.0015
K_K28863  L_L225  L_L276  0.0015
* *  Branch  NTMP0000000225 - NTMP0000000226
R_R226  NTMP0000000225  nU_226  32.914993m  TC=0,0
V_Ui226  nU_226  nR_226  STIMULUS=U_IND_0000000226
R_V451  nR_226  nV_451  23.280268m  TC=0,0
L_V451  nR_226  nV_451  0.014646uH
R_V452  nV_451  nV_452  7.852787m  TC=0,0
L_V452  nV_451  nV_452  0.073723uH
L_L226  nV_452  NTMP0000000226  6.519695uH
K_K28864  L_L226  L_L227  0.1050
K_K28865  L_L226  L_L228  0.0397
K_K28866  L_L226  L_L229  0.0258
K_K28867  L_L226  L_L230  0.0192
K_K28868  L_L226  L_L231  0.0153
K_K28869  L_L226  L_L232  0.0127
K_K28870  L_L226  L_L233  0.0109
K_K28871  L_L226  L_L234  0.0095
K_K28872  L_L226  L_L235  0.0084
K_K28873  L_L226  L_L236  0.0076
K_K28874  L_L226  L_L237  0.0069
K_K28875  L_L226  L_L238  0.0063
K_K28876  L_L226  L_L239  0.0058
K_K28877  L_L226  L_L240  0.0054
K_K28878  L_L226  L_L241  0.0051
K_K28879  L_L226  L_L242  0.0047
K_K28880  L_L226  L_L243  0.0045
K_K28881  L_L226  L_L244  0.0042
K_K28882  L_L226  L_L245  0.0040
K_K28883  L_L226  L_L246  0.0038
K_K28884  L_L226  L_L247  0.0036
K_K28885  L_L226  L_L248  0.0034
K_K28886  L_L226  L_L249  0.0033
K_K28887  L_L226  L_L250  0.0032
K_K28888  L_L226  L_L251  0.0030
K_K28889  L_L226  L_L252  0.0029
K_K28890  L_L226  L_L253  0.0028
K_K28891  L_L226  L_L254  0.0027
K_K28892  L_L226  L_L255  0.0026
K_K28893  L_L226  L_L256  0.0025
K_K28894  L_L226  L_L257  0.0024
K_K28895  L_L226  L_L258  0.0024
K_K28896  L_L226  L_L259  0.0023
K_K28897  L_L226  L_L260  0.0022
K_K28898  L_L226  L_L261  0.0022
K_K28899  L_L226  L_L262  0.0021
K_K28900  L_L226  L_L263  0.0020
K_K28901  L_L226  L_L264  0.0020
K_K28902  L_L226  L_L265  0.0019
K_K28903  L_L226  L_L266  0.0019
K_K28904  L_L226  L_L267  0.0019
K_K28905  L_L226  L_L268  0.0018
K_K28906  L_L226  L_L269  0.0018
K_K28907  L_L226  L_L270  0.0017
K_K28908  L_L226  L_L271  0.0017
K_K28909  L_L226  L_L272  0.0017
K_K28910  L_L226  L_L273  0.0016
K_K28911  L_L226  L_L274  0.0016
K_K28912  L_L226  L_L275  0.0015
K_K28913  L_L226  L_L276  0.0015
* *  Branch  NTMP0000000226 - NTMP0000000227
R_R227  NTMP0000000226  nU_227  32.914993m  TC=0,0
V_Ui227  nU_227  nR_227  STIMULUS=U_IND_0000000227
R_V453  nR_227  nV_453  23.280268m  TC=0,0
L_V453  nR_227  nV_453  0.014646uH
R_V454  nV_453  nV_454  7.852787m  TC=0,0
L_V454  nV_453  nV_454  0.073723uH
L_L227  nV_454  NTMP0000000227  6.519695uH
K_K28914  L_L227  L_L228  0.1050
K_K28915  L_L227  L_L229  0.0397
K_K28916  L_L227  L_L230  0.0258
K_K28917  L_L227  L_L231  0.0192
K_K28918  L_L227  L_L232  0.0153
K_K28919  L_L227  L_L233  0.0127
K_K28920  L_L227  L_L234  0.0109
K_K28921  L_L227  L_L235  0.0095
K_K28922  L_L227  L_L236  0.0084
K_K28923  L_L227  L_L237  0.0076
K_K28924  L_L227  L_L238  0.0069
K_K28925  L_L227  L_L239  0.0063
K_K28926  L_L227  L_L240  0.0058
K_K28927  L_L227  L_L241  0.0054
K_K28928  L_L227  L_L242  0.0051
K_K28929  L_L227  L_L243  0.0047
K_K28930  L_L227  L_L244  0.0045
K_K28931  L_L227  L_L245  0.0042
K_K28932  L_L227  L_L246  0.0040
K_K28933  L_L227  L_L247  0.0038
K_K28934  L_L227  L_L248  0.0036
K_K28935  L_L227  L_L249  0.0034
K_K28936  L_L227  L_L250  0.0033
K_K28937  L_L227  L_L251  0.0032
K_K28938  L_L227  L_L252  0.0030
K_K28939  L_L227  L_L253  0.0029
K_K28940  L_L227  L_L254  0.0028
K_K28941  L_L227  L_L255  0.0027
K_K28942  L_L227  L_L256  0.0026
K_K28943  L_L227  L_L257  0.0025
K_K28944  L_L227  L_L258  0.0024
K_K28945  L_L227  L_L259  0.0024
K_K28946  L_L227  L_L260  0.0023
K_K28947  L_L227  L_L261  0.0022
K_K28948  L_L227  L_L262  0.0022
K_K28949  L_L227  L_L263  0.0021
K_K28950  L_L227  L_L264  0.0020
K_K28951  L_L227  L_L265  0.0020
K_K28952  L_L227  L_L266  0.0019
K_K28953  L_L227  L_L267  0.0019
K_K28954  L_L227  L_L268  0.0019
K_K28955  L_L227  L_L269  0.0018
K_K28956  L_L227  L_L270  0.0018
K_K28957  L_L227  L_L271  0.0017
K_K28958  L_L227  L_L272  0.0017
K_K28959  L_L227  L_L273  0.0017
K_K28960  L_L227  L_L274  0.0016
K_K28961  L_L227  L_L275  0.0016
K_K28962  L_L227  L_L276  0.0015
* *  Branch  NTMP0000000227 - NTMP0000000228
R_R228  NTMP0000000227  nU_228  32.914993m  TC=0,0
V_Ui228  nU_228  nR_228  STIMULUS=U_IND_0000000228
R_V455  nR_228  nV_455  23.280268m  TC=0,0
L_V455  nR_228  nV_455  0.014646uH
R_V456  nV_455  nV_456  7.852787m  TC=0,0
L_V456  nV_455  nV_456  0.073723uH
L_L228  nV_456  NTMP0000000228  6.519695uH
K_K28963  L_L228  L_L229  0.1050
K_K28964  L_L228  L_L230  0.0397
K_K28965  L_L228  L_L231  0.0258
K_K28966  L_L228  L_L232  0.0192
K_K28967  L_L228  L_L233  0.0153
K_K28968  L_L228  L_L234  0.0127
K_K28969  L_L228  L_L235  0.0109
K_K28970  L_L228  L_L236  0.0095
K_K28971  L_L228  L_L237  0.0084
K_K28972  L_L228  L_L238  0.0076
K_K28973  L_L228  L_L239  0.0069
K_K28974  L_L228  L_L240  0.0063
K_K28975  L_L228  L_L241  0.0058
K_K28976  L_L228  L_L242  0.0054
K_K28977  L_L228  L_L243  0.0051
K_K28978  L_L228  L_L244  0.0047
K_K28979  L_L228  L_L245  0.0045
K_K28980  L_L228  L_L246  0.0042
K_K28981  L_L228  L_L247  0.0040
K_K28982  L_L228  L_L248  0.0038
K_K28983  L_L228  L_L249  0.0036
K_K28984  L_L228  L_L250  0.0034
K_K28985  L_L228  L_L251  0.0033
K_K28986  L_L228  L_L252  0.0032
K_K28987  L_L228  L_L253  0.0030
K_K28988  L_L228  L_L254  0.0029
K_K28989  L_L228  L_L255  0.0028
K_K28990  L_L228  L_L256  0.0027
K_K28991  L_L228  L_L257  0.0026
K_K28992  L_L228  L_L258  0.0025
K_K28993  L_L228  L_L259  0.0024
K_K28994  L_L228  L_L260  0.0024
K_K28995  L_L228  L_L261  0.0023
K_K28996  L_L228  L_L262  0.0022
K_K28997  L_L228  L_L263  0.0022
K_K28998  L_L228  L_L264  0.0021
K_K28999  L_L228  L_L265  0.0020
K_K29000  L_L228  L_L266  0.0020
K_K29001  L_L228  L_L267  0.0019
K_K29002  L_L228  L_L268  0.0019
K_K29003  L_L228  L_L269  0.0019
K_K29004  L_L228  L_L270  0.0018
K_K29005  L_L228  L_L271  0.0018
K_K29006  L_L228  L_L272  0.0017
K_K29007  L_L228  L_L273  0.0017
K_K29008  L_L228  L_L274  0.0017
K_K29009  L_L228  L_L275  0.0016
K_K29010  L_L228  L_L276  0.0016
* *  Branch  NTMP0000000228 - NTMP0000000229
R_R229  NTMP0000000228  nU_229  32.914993m  TC=0,0
V_Ui229  nU_229  nR_229  STIMULUS=U_IND_0000000229
R_V457  nR_229  nV_457  23.280268m  TC=0,0
L_V457  nR_229  nV_457  0.014646uH
R_V458  nV_457  nV_458  7.852787m  TC=0,0
L_V458  nV_457  nV_458  0.073723uH
L_L229  nV_458  NTMP0000000229  6.519695uH
K_K29011  L_L229  L_L230  0.1050
K_K29012  L_L229  L_L231  0.0397
K_K29013  L_L229  L_L232  0.0258
K_K29014  L_L229  L_L233  0.0192
K_K29015  L_L229  L_L234  0.0153
K_K29016  L_L229  L_L235  0.0127
K_K29017  L_L229  L_L236  0.0109
K_K29018  L_L229  L_L237  0.0095
K_K29019  L_L229  L_L238  0.0084
K_K29020  L_L229  L_L239  0.0076
K_K29021  L_L229  L_L240  0.0069
K_K29022  L_L229  L_L241  0.0063
K_K29023  L_L229  L_L242  0.0058
K_K29024  L_L229  L_L243  0.0054
K_K29025  L_L229  L_L244  0.0051
K_K29026  L_L229  L_L245  0.0047
K_K29027  L_L229  L_L246  0.0045
K_K29028  L_L229  L_L247  0.0042
K_K29029  L_L229  L_L248  0.0040
K_K29030  L_L229  L_L249  0.0038
K_K29031  L_L229  L_L250  0.0036
K_K29032  L_L229  L_L251  0.0034
K_K29033  L_L229  L_L252  0.0033
K_K29034  L_L229  L_L253  0.0032
K_K29035  L_L229  L_L254  0.0030
K_K29036  L_L229  L_L255  0.0029
K_K29037  L_L229  L_L256  0.0028
K_K29038  L_L229  L_L257  0.0027
K_K29039  L_L229  L_L258  0.0026
K_K29040  L_L229  L_L259  0.0025
K_K29041  L_L229  L_L260  0.0024
K_K29042  L_L229  L_L261  0.0024
K_K29043  L_L229  L_L262  0.0023
K_K29044  L_L229  L_L263  0.0022
K_K29045  L_L229  L_L264  0.0022
K_K29046  L_L229  L_L265  0.0021
K_K29047  L_L229  L_L266  0.0020
K_K29048  L_L229  L_L267  0.0020
K_K29049  L_L229  L_L268  0.0019
K_K29050  L_L229  L_L269  0.0019
K_K29051  L_L229  L_L270  0.0019
K_K29052  L_L229  L_L271  0.0018
K_K29053  L_L229  L_L272  0.0018
K_K29054  L_L229  L_L273  0.0017
K_K29055  L_L229  L_L274  0.0017
K_K29056  L_L229  L_L275  0.0017
K_K29057  L_L229  L_L276  0.0016
* *  Branch  NTMP0000000229 - NTMP0000000230
R_R230  NTMP0000000229  nU_230  32.914993m  TC=0,0
V_Ui230  nU_230  nR_230  STIMULUS=U_IND_0000000230
R_V459  nR_230  nV_459  23.280268m  TC=0,0
L_V459  nR_230  nV_459  0.014646uH
R_V460  nV_459  nV_460  7.852787m  TC=0,0
L_V460  nV_459  nV_460  0.073723uH
L_L230  nV_460  NTMP0000000230  6.519695uH
K_K29058  L_L230  L_L231  0.1050
K_K29059  L_L230  L_L232  0.0397
K_K29060  L_L230  L_L233  0.0258
K_K29061  L_L230  L_L234  0.0192
K_K29062  L_L230  L_L235  0.0153
K_K29063  L_L230  L_L236  0.0127
K_K29064  L_L230  L_L237  0.0109
K_K29065  L_L230  L_L238  0.0095
K_K29066  L_L230  L_L239  0.0084
K_K29067  L_L230  L_L240  0.0076
K_K29068  L_L230  L_L241  0.0069
K_K29069  L_L230  L_L242  0.0063
K_K29070  L_L230  L_L243  0.0058
K_K29071  L_L230  L_L244  0.0054
K_K29072  L_L230  L_L245  0.0051
K_K29073  L_L230  L_L246  0.0047
K_K29074  L_L230  L_L247  0.0045
K_K29075  L_L230  L_L248  0.0042
K_K29076  L_L230  L_L249  0.0040
K_K29077  L_L230  L_L250  0.0038
K_K29078  L_L230  L_L251  0.0036
K_K29079  L_L230  L_L252  0.0034
K_K29080  L_L230  L_L253  0.0033
K_K29081  L_L230  L_L254  0.0032
K_K29082  L_L230  L_L255  0.0030
K_K29083  L_L230  L_L256  0.0029
K_K29084  L_L230  L_L257  0.0028
K_K29085  L_L230  L_L258  0.0027
K_K29086  L_L230  L_L259  0.0026
K_K29087  L_L230  L_L260  0.0025
K_K29088  L_L230  L_L261  0.0024
K_K29089  L_L230  L_L262  0.0024
K_K29090  L_L230  L_L263  0.0023
K_K29091  L_L230  L_L264  0.0022
K_K29092  L_L230  L_L265  0.0022
K_K29093  L_L230  L_L266  0.0021
K_K29094  L_L230  L_L267  0.0020
K_K29095  L_L230  L_L268  0.0020
K_K29096  L_L230  L_L269  0.0019
K_K29097  L_L230  L_L270  0.0019
K_K29098  L_L230  L_L271  0.0019
K_K29099  L_L230  L_L272  0.0018
K_K29100  L_L230  L_L273  0.0018
K_K29101  L_L230  L_L274  0.0017
K_K29102  L_L230  L_L275  0.0017
K_K29103  L_L230  L_L276  0.0017
* *  Branch  NTMP0000000230 - NTMP0000000231
R_R231  NTMP0000000230  nU_231  32.914993m  TC=0,0
V_Ui231  nU_231  nR_231  STIMULUS=U_IND_0000000231
R_V461  nR_231  nV_461  23.280268m  TC=0,0
L_V461  nR_231  nV_461  0.014646uH
R_V462  nV_461  nV_462  7.852787m  TC=0,0
L_V462  nV_461  nV_462  0.073723uH
L_L231  nV_462  NTMP0000000231  6.519695uH
K_K29104  L_L231  L_L232  0.1050
K_K29105  L_L231  L_L233  0.0397
K_K29106  L_L231  L_L234  0.0258
K_K29107  L_L231  L_L235  0.0192
K_K29108  L_L231  L_L236  0.0153
K_K29109  L_L231  L_L237  0.0127
K_K29110  L_L231  L_L238  0.0109
K_K29111  L_L231  L_L239  0.0095
K_K29112  L_L231  L_L240  0.0084
K_K29113  L_L231  L_L241  0.0076
K_K29114  L_L231  L_L242  0.0069
K_K29115  L_L231  L_L243  0.0063
K_K29116  L_L231  L_L244  0.0058
K_K29117  L_L231  L_L245  0.0054
K_K29118  L_L231  L_L246  0.0051
K_K29119  L_L231  L_L247  0.0047
K_K29120  L_L231  L_L248  0.0045
K_K29121  L_L231  L_L249  0.0042
K_K29122  L_L231  L_L250  0.0040
K_K29123  L_L231  L_L251  0.0038
K_K29124  L_L231  L_L252  0.0036
K_K29125  L_L231  L_L253  0.0034
K_K29126  L_L231  L_L254  0.0033
K_K29127  L_L231  L_L255  0.0032
K_K29128  L_L231  L_L256  0.0030
K_K29129  L_L231  L_L257  0.0029
K_K29130  L_L231  L_L258  0.0028
K_K29131  L_L231  L_L259  0.0027
K_K29132  L_L231  L_L260  0.0026
K_K29133  L_L231  L_L261  0.0025
K_K29134  L_L231  L_L262  0.0024
K_K29135  L_L231  L_L263  0.0024
K_K29136  L_L231  L_L264  0.0023
K_K29137  L_L231  L_L265  0.0022
K_K29138  L_L231  L_L266  0.0022
K_K29139  L_L231  L_L267  0.0021
K_K29140  L_L231  L_L268  0.0020
K_K29141  L_L231  L_L269  0.0020
K_K29142  L_L231  L_L270  0.0019
K_K29143  L_L231  L_L271  0.0019
K_K29144  L_L231  L_L272  0.0019
K_K29145  L_L231  L_L273  0.0018
K_K29146  L_L231  L_L274  0.0018
K_K29147  L_L231  L_L275  0.0017
K_K29148  L_L231  L_L276  0.0017
* *  Branch  NTMP0000000231 - NTMP0000000232
R_R232  NTMP0000000231  nU_232  32.914993m  TC=0,0
V_Ui232  nU_232  nR_232  STIMULUS=U_IND_0000000232
R_V463  nR_232  nV_463  23.280268m  TC=0,0
L_V463  nR_232  nV_463  0.014646uH
R_V464  nV_463  nV_464  7.852787m  TC=0,0
L_V464  nV_463  nV_464  0.073723uH
L_L232  nV_464  NTMP0000000232  6.519695uH
K_K29149  L_L232  L_L233  0.1050
K_K29150  L_L232  L_L234  0.0397
K_K29151  L_L232  L_L235  0.0258
K_K29152  L_L232  L_L236  0.0192
K_K29153  L_L232  L_L237  0.0153
K_K29154  L_L232  L_L238  0.0127
K_K29155  L_L232  L_L239  0.0109
K_K29156  L_L232  L_L240  0.0095
K_K29157  L_L232  L_L241  0.0084
K_K29158  L_L232  L_L242  0.0076
K_K29159  L_L232  L_L243  0.0069
K_K29160  L_L232  L_L244  0.0063
K_K29161  L_L232  L_L245  0.0058
K_K29162  L_L232  L_L246  0.0054
K_K29163  L_L232  L_L247  0.0051
K_K29164  L_L232  L_L248  0.0047
K_K29165  L_L232  L_L249  0.0045
K_K29166  L_L232  L_L250  0.0042
K_K29167  L_L232  L_L251  0.0040
K_K29168  L_L232  L_L252  0.0038
K_K29169  L_L232  L_L253  0.0036
K_K29170  L_L232  L_L254  0.0034
K_K29171  L_L232  L_L255  0.0033
K_K29172  L_L232  L_L256  0.0032
K_K29173  L_L232  L_L257  0.0030
K_K29174  L_L232  L_L258  0.0029
K_K29175  L_L232  L_L259  0.0028
K_K29176  L_L232  L_L260  0.0027
K_K29177  L_L232  L_L261  0.0026
K_K29178  L_L232  L_L262  0.0025
K_K29179  L_L232  L_L263  0.0024
K_K29180  L_L232  L_L264  0.0024
K_K29181  L_L232  L_L265  0.0023
K_K29182  L_L232  L_L266  0.0022
K_K29183  L_L232  L_L267  0.0022
K_K29184  L_L232  L_L268  0.0021
K_K29185  L_L232  L_L269  0.0020
K_K29186  L_L232  L_L270  0.0020
K_K29187  L_L232  L_L271  0.0019
K_K29188  L_L232  L_L272  0.0019
K_K29189  L_L232  L_L273  0.0019
K_K29190  L_L232  L_L274  0.0018
K_K29191  L_L232  L_L275  0.0018
K_K29192  L_L232  L_L276  0.0017
* *  Branch  NTMP0000000232 - NTMP0000000233
R_R233  NTMP0000000232  nU_233  32.914993m  TC=0,0
V_Ui233  nU_233  nR_233  STIMULUS=U_IND_0000000233
R_V465  nR_233  nV_465  23.280268m  TC=0,0
L_V465  nR_233  nV_465  0.014646uH
R_V466  nV_465  nV_466  7.852787m  TC=0,0
L_V466  nV_465  nV_466  0.073723uH
L_L233  nV_466  NTMP0000000233  6.519695uH
K_K29193  L_L233  L_L234  0.1050
K_K29194  L_L233  L_L235  0.0397
K_K29195  L_L233  L_L236  0.0258
K_K29196  L_L233  L_L237  0.0192
K_K29197  L_L233  L_L238  0.0153
K_K29198  L_L233  L_L239  0.0127
K_K29199  L_L233  L_L240  0.0109
K_K29200  L_L233  L_L241  0.0095
K_K29201  L_L233  L_L242  0.0084
K_K29202  L_L233  L_L243  0.0076
K_K29203  L_L233  L_L244  0.0069
K_K29204  L_L233  L_L245  0.0063
K_K29205  L_L233  L_L246  0.0058
K_K29206  L_L233  L_L247  0.0054
K_K29207  L_L233  L_L248  0.0051
K_K29208  L_L233  L_L249  0.0047
K_K29209  L_L233  L_L250  0.0045
K_K29210  L_L233  L_L251  0.0042
K_K29211  L_L233  L_L252  0.0040
K_K29212  L_L233  L_L253  0.0038
K_K29213  L_L233  L_L254  0.0036
K_K29214  L_L233  L_L255  0.0034
K_K29215  L_L233  L_L256  0.0033
K_K29216  L_L233  L_L257  0.0032
K_K29217  L_L233  L_L258  0.0030
K_K29218  L_L233  L_L259  0.0029
K_K29219  L_L233  L_L260  0.0028
K_K29220  L_L233  L_L261  0.0027
K_K29221  L_L233  L_L262  0.0026
K_K29222  L_L233  L_L263  0.0025
K_K29223  L_L233  L_L264  0.0024
K_K29224  L_L233  L_L265  0.0024
K_K29225  L_L233  L_L266  0.0023
K_K29226  L_L233  L_L267  0.0022
K_K29227  L_L233  L_L268  0.0022
K_K29228  L_L233  L_L269  0.0021
K_K29229  L_L233  L_L270  0.0020
K_K29230  L_L233  L_L271  0.0020
K_K29231  L_L233  L_L272  0.0019
K_K29232  L_L233  L_L273  0.0019
K_K29233  L_L233  L_L274  0.0019
K_K29234  L_L233  L_L275  0.0018
K_K29235  L_L233  L_L276  0.0018
* *  Branch  NTMP0000000233 - NTMP0000000234
R_R234  NTMP0000000233  nU_234  32.914993m  TC=0,0
V_Ui234  nU_234  nR_234  STIMULUS=U_IND_0000000234
R_V467  nR_234  nV_467  23.280268m  TC=0,0
L_V467  nR_234  nV_467  0.014646uH
R_V468  nV_467  nV_468  7.852787m  TC=0,0
L_V468  nV_467  nV_468  0.073723uH
L_L234  nV_468  NTMP0000000234  6.519695uH
K_K29236  L_L234  L_L235  0.1050
K_K29237  L_L234  L_L236  0.0397
K_K29238  L_L234  L_L237  0.0258
K_K29239  L_L234  L_L238  0.0192
K_K29240  L_L234  L_L239  0.0153
K_K29241  L_L234  L_L240  0.0127
K_K29242  L_L234  L_L241  0.0109
K_K29243  L_L234  L_L242  0.0095
K_K29244  L_L234  L_L243  0.0084
K_K29245  L_L234  L_L244  0.0076
K_K29246  L_L234  L_L245  0.0069
K_K29247  L_L234  L_L246  0.0063
K_K29248  L_L234  L_L247  0.0058
K_K29249  L_L234  L_L248  0.0054
K_K29250  L_L234  L_L249  0.0051
K_K29251  L_L234  L_L250  0.0047
K_K29252  L_L234  L_L251  0.0045
K_K29253  L_L234  L_L252  0.0042
K_K29254  L_L234  L_L253  0.0040
K_K29255  L_L234  L_L254  0.0038
K_K29256  L_L234  L_L255  0.0036
K_K29257  L_L234  L_L256  0.0034
K_K29258  L_L234  L_L257  0.0033
K_K29259  L_L234  L_L258  0.0032
K_K29260  L_L234  L_L259  0.0030
K_K29261  L_L234  L_L260  0.0029
K_K29262  L_L234  L_L261  0.0028
K_K29263  L_L234  L_L262  0.0027
K_K29264  L_L234  L_L263  0.0026
K_K29265  L_L234  L_L264  0.0025
K_K29266  L_L234  L_L265  0.0024
K_K29267  L_L234  L_L266  0.0024
K_K29268  L_L234  L_L267  0.0023
K_K29269  L_L234  L_L268  0.0022
K_K29270  L_L234  L_L269  0.0022
K_K29271  L_L234  L_L270  0.0021
K_K29272  L_L234  L_L271  0.0020
K_K29273  L_L234  L_L272  0.0020
K_K29274  L_L234  L_L273  0.0019
K_K29275  L_L234  L_L274  0.0019
K_K29276  L_L234  L_L275  0.0019
K_K29277  L_L234  L_L276  0.0018
* *  Branch  NTMP0000000234 - NTMP0000000235
R_R235  NTMP0000000234  nU_235  32.914993m  TC=0,0
V_Ui235  nU_235  nR_235  STIMULUS=U_IND_0000000235
R_V469  nR_235  nV_469  23.280268m  TC=0,0
L_V469  nR_235  nV_469  0.014646uH
R_V470  nV_469  nV_470  7.852787m  TC=0,0
L_V470  nV_469  nV_470  0.073723uH
L_L235  nV_470  NTMP0000000235  6.519695uH
K_K29278  L_L235  L_L236  0.1050
K_K29279  L_L235  L_L237  0.0397
K_K29280  L_L235  L_L238  0.0258
K_K29281  L_L235  L_L239  0.0192
K_K29282  L_L235  L_L240  0.0153
K_K29283  L_L235  L_L241  0.0127
K_K29284  L_L235  L_L242  0.0109
K_K29285  L_L235  L_L243  0.0095
K_K29286  L_L235  L_L244  0.0084
K_K29287  L_L235  L_L245  0.0076
K_K29288  L_L235  L_L246  0.0069
K_K29289  L_L235  L_L247  0.0063
K_K29290  L_L235  L_L248  0.0058
K_K29291  L_L235  L_L249  0.0054
K_K29292  L_L235  L_L250  0.0051
K_K29293  L_L235  L_L251  0.0047
K_K29294  L_L235  L_L252  0.0045
K_K29295  L_L235  L_L253  0.0042
K_K29296  L_L235  L_L254  0.0040
K_K29297  L_L235  L_L255  0.0038
K_K29298  L_L235  L_L256  0.0036
K_K29299  L_L235  L_L257  0.0034
K_K29300  L_L235  L_L258  0.0033
K_K29301  L_L235  L_L259  0.0032
K_K29302  L_L235  L_L260  0.0030
K_K29303  L_L235  L_L261  0.0029
K_K29304  L_L235  L_L262  0.0028
K_K29305  L_L235  L_L263  0.0027
K_K29306  L_L235  L_L264  0.0026
K_K29307  L_L235  L_L265  0.0025
K_K29308  L_L235  L_L266  0.0024
K_K29309  L_L235  L_L267  0.0024
K_K29310  L_L235  L_L268  0.0023
K_K29311  L_L235  L_L269  0.0022
K_K29312  L_L235  L_L270  0.0022
K_K29313  L_L235  L_L271  0.0021
K_K29314  L_L235  L_L272  0.0020
K_K29315  L_L235  L_L273  0.0020
K_K29316  L_L235  L_L274  0.0019
K_K29317  L_L235  L_L275  0.0019
K_K29318  L_L235  L_L276  0.0019
* *  Branch  NTMP0000000235 - NTMP0000000236
R_R236  NTMP0000000235  nU_236  32.914993m  TC=0,0
V_Ui236  nU_236  nR_236  STIMULUS=U_IND_0000000236
R_V471  nR_236  nV_471  23.280268m  TC=0,0
L_V471  nR_236  nV_471  0.014646uH
R_V472  nV_471  nV_472  7.852787m  TC=0,0
L_V472  nV_471  nV_472  0.073723uH
L_L236  nV_472  NTMP0000000236  6.519695uH
K_K29319  L_L236  L_L237  0.1050
K_K29320  L_L236  L_L238  0.0397
K_K29321  L_L236  L_L239  0.0258
K_K29322  L_L236  L_L240  0.0192
K_K29323  L_L236  L_L241  0.0153
K_K29324  L_L236  L_L242  0.0127
K_K29325  L_L236  L_L243  0.0109
K_K29326  L_L236  L_L244  0.0095
K_K29327  L_L236  L_L245  0.0084
K_K29328  L_L236  L_L246  0.0076
K_K29329  L_L236  L_L247  0.0069
K_K29330  L_L236  L_L248  0.0063
K_K29331  L_L236  L_L249  0.0058
K_K29332  L_L236  L_L250  0.0054
K_K29333  L_L236  L_L251  0.0051
K_K29334  L_L236  L_L252  0.0047
K_K29335  L_L236  L_L253  0.0045
K_K29336  L_L236  L_L254  0.0042
K_K29337  L_L236  L_L255  0.0040
K_K29338  L_L236  L_L256  0.0038
K_K29339  L_L236  L_L257  0.0036
K_K29340  L_L236  L_L258  0.0034
K_K29341  L_L236  L_L259  0.0033
K_K29342  L_L236  L_L260  0.0032
K_K29343  L_L236  L_L261  0.0030
K_K29344  L_L236  L_L262  0.0029
K_K29345  L_L236  L_L263  0.0028
K_K29346  L_L236  L_L264  0.0027
K_K29347  L_L236  L_L265  0.0026
K_K29348  L_L236  L_L266  0.0025
K_K29349  L_L236  L_L267  0.0024
K_K29350  L_L236  L_L268  0.0024
K_K29351  L_L236  L_L269  0.0023
K_K29352  L_L236  L_L270  0.0022
K_K29353  L_L236  L_L271  0.0022
K_K29354  L_L236  L_L272  0.0021
K_K29355  L_L236  L_L273  0.0020
K_K29356  L_L236  L_L274  0.0020
K_K29357  L_L236  L_L275  0.0019
K_K29358  L_L236  L_L276  0.0019
* *  Branch  NTMP0000000236 - NTMP0000000237
R_R237  NTMP0000000236  nU_237  32.914993m  TC=0,0
V_Ui237  nU_237  nR_237  STIMULUS=U_IND_0000000237
R_V473  nR_237  nV_473  23.280268m  TC=0,0
L_V473  nR_237  nV_473  0.014646uH
R_V474  nV_473  nV_474  7.852787m  TC=0,0
L_V474  nV_473  nV_474  0.073723uH
L_L237  nV_474  NTMP0000000237  6.519695uH
K_K29359  L_L237  L_L238  0.1050
K_K29360  L_L237  L_L239  0.0397
K_K29361  L_L237  L_L240  0.0258
K_K29362  L_L237  L_L241  0.0192
K_K29363  L_L237  L_L242  0.0153
K_K29364  L_L237  L_L243  0.0127
K_K29365  L_L237  L_L244  0.0109
K_K29366  L_L237  L_L245  0.0095
K_K29367  L_L237  L_L246  0.0084
K_K29368  L_L237  L_L247  0.0076
K_K29369  L_L237  L_L248  0.0069
K_K29370  L_L237  L_L249  0.0063
K_K29371  L_L237  L_L250  0.0058
K_K29372  L_L237  L_L251  0.0054
K_K29373  L_L237  L_L252  0.0051
K_K29374  L_L237  L_L253  0.0047
K_K29375  L_L237  L_L254  0.0045
K_K29376  L_L237  L_L255  0.0042
K_K29377  L_L237  L_L256  0.0040
K_K29378  L_L237  L_L257  0.0038
K_K29379  L_L237  L_L258  0.0036
K_K29380  L_L237  L_L259  0.0034
K_K29381  L_L237  L_L260  0.0033
K_K29382  L_L237  L_L261  0.0032
K_K29383  L_L237  L_L262  0.0030
K_K29384  L_L237  L_L263  0.0029
K_K29385  L_L237  L_L264  0.0028
K_K29386  L_L237  L_L265  0.0027
K_K29387  L_L237  L_L266  0.0026
K_K29388  L_L237  L_L267  0.0025
K_K29389  L_L237  L_L268  0.0024
K_K29390  L_L237  L_L269  0.0024
K_K29391  L_L237  L_L270  0.0023
K_K29392  L_L237  L_L271  0.0022
K_K29393  L_L237  L_L272  0.0022
K_K29394  L_L237  L_L273  0.0021
K_K29395  L_L237  L_L274  0.0020
K_K29396  L_L237  L_L275  0.0020
K_K29397  L_L237  L_L276  0.0019
* *  Branch  NTMP0000000237 - NTMP0000000238
R_R238  NTMP0000000237  nU_238  32.914993m  TC=0,0
V_Ui238  nU_238  nR_238  STIMULUS=U_IND_0000000238
R_V475  nR_238  nV_475  23.280268m  TC=0,0
L_V475  nR_238  nV_475  0.014646uH
R_V476  nV_475  nV_476  7.852787m  TC=0,0
L_V476  nV_475  nV_476  0.073723uH
L_L238  nV_476  NTMP0000000238  6.519695uH
K_K29398  L_L238  L_L239  0.1050
K_K29399  L_L238  L_L240  0.0397
K_K29400  L_L238  L_L241  0.0258
K_K29401  L_L238  L_L242  0.0192
K_K29402  L_L238  L_L243  0.0153
K_K29403  L_L238  L_L244  0.0127
K_K29404  L_L238  L_L245  0.0109
K_K29405  L_L238  L_L246  0.0095
K_K29406  L_L238  L_L247  0.0084
K_K29407  L_L238  L_L248  0.0076
K_K29408  L_L238  L_L249  0.0069
K_K29409  L_L238  L_L250  0.0063
K_K29410  L_L238  L_L251  0.0058
K_K29411  L_L238  L_L252  0.0054
K_K29412  L_L238  L_L253  0.0051
K_K29413  L_L238  L_L254  0.0047
K_K29414  L_L238  L_L255  0.0045
K_K29415  L_L238  L_L256  0.0042
K_K29416  L_L238  L_L257  0.0040
K_K29417  L_L238  L_L258  0.0038
K_K29418  L_L238  L_L259  0.0036
K_K29419  L_L238  L_L260  0.0034
K_K29420  L_L238  L_L261  0.0033
K_K29421  L_L238  L_L262  0.0032
K_K29422  L_L238  L_L263  0.0030
K_K29423  L_L238  L_L264  0.0029
K_K29424  L_L238  L_L265  0.0028
K_K29425  L_L238  L_L266  0.0027
K_K29426  L_L238  L_L267  0.0026
K_K29427  L_L238  L_L268  0.0025
K_K29428  L_L238  L_L269  0.0024
K_K29429  L_L238  L_L270  0.0024
K_K29430  L_L238  L_L271  0.0023
K_K29431  L_L238  L_L272  0.0022
K_K29432  L_L238  L_L273  0.0022
K_K29433  L_L238  L_L274  0.0021
K_K29434  L_L238  L_L275  0.0020
K_K29435  L_L238  L_L276  0.0020
* *  Branch  NTMP0000000238 - NTMP0000000239
R_R239  NTMP0000000238  nU_239  32.914993m  TC=0,0
V_Ui239  nU_239  nR_239  STIMULUS=U_IND_0000000239
R_V477  nR_239  nV_477  23.280268m  TC=0,0
L_V477  nR_239  nV_477  0.014646uH
R_V478  nV_477  nV_478  7.852787m  TC=0,0
L_V478  nV_477  nV_478  0.073723uH
L_L239  nV_478  NTMP0000000239  6.519695uH
K_K29436  L_L239  L_L240  0.1050
K_K29437  L_L239  L_L241  0.0397
K_K29438  L_L239  L_L242  0.0258
K_K29439  L_L239  L_L243  0.0192
K_K29440  L_L239  L_L244  0.0153
K_K29441  L_L239  L_L245  0.0127
K_K29442  L_L239  L_L246  0.0109
K_K29443  L_L239  L_L247  0.0095
K_K29444  L_L239  L_L248  0.0084
K_K29445  L_L239  L_L249  0.0076
K_K29446  L_L239  L_L250  0.0069
K_K29447  L_L239  L_L251  0.0063
K_K29448  L_L239  L_L252  0.0058
K_K29449  L_L239  L_L253  0.0054
K_K29450  L_L239  L_L254  0.0051
K_K29451  L_L239  L_L255  0.0047
K_K29452  L_L239  L_L256  0.0045
K_K29453  L_L239  L_L257  0.0042
K_K29454  L_L239  L_L258  0.0040
K_K29455  L_L239  L_L259  0.0038
K_K29456  L_L239  L_L260  0.0036
K_K29457  L_L239  L_L261  0.0034
K_K29458  L_L239  L_L262  0.0033
K_K29459  L_L239  L_L263  0.0032
K_K29460  L_L239  L_L264  0.0030
K_K29461  L_L239  L_L265  0.0029
K_K29462  L_L239  L_L266  0.0028
K_K29463  L_L239  L_L267  0.0027
K_K29464  L_L239  L_L268  0.0026
K_K29465  L_L239  L_L269  0.0025
K_K29466  L_L239  L_L270  0.0024
K_K29467  L_L239  L_L271  0.0024
K_K29468  L_L239  L_L272  0.0023
K_K29469  L_L239  L_L273  0.0022
K_K29470  L_L239  L_L274  0.0022
K_K29471  L_L239  L_L275  0.0021
K_K29472  L_L239  L_L276  0.0020
* *  Branch  NTMP0000000239 - NTMP0000000240
R_R240  NTMP0000000239  nU_240  32.914993m  TC=0,0
V_Ui240  nU_240  nR_240  STIMULUS=U_IND_0000000240
R_V479  nR_240  nV_479  23.280268m  TC=0,0
L_V479  nR_240  nV_479  0.014646uH
R_V480  nV_479  nV_480  7.852787m  TC=0,0
L_V480  nV_479  nV_480  0.073723uH
L_L240  nV_480  NTMP0000000240  6.519695uH
K_K29473  L_L240  L_L241  0.1050
K_K29474  L_L240  L_L242  0.0397
K_K29475  L_L240  L_L243  0.0258
K_K29476  L_L240  L_L244  0.0192
K_K29477  L_L240  L_L245  0.0153
K_K29478  L_L240  L_L246  0.0127
K_K29479  L_L240  L_L247  0.0109
K_K29480  L_L240  L_L248  0.0095
K_K29481  L_L240  L_L249  0.0084
K_K29482  L_L240  L_L250  0.0076
K_K29483  L_L240  L_L251  0.0069
K_K29484  L_L240  L_L252  0.0063
K_K29485  L_L240  L_L253  0.0058
K_K29486  L_L240  L_L254  0.0054
K_K29487  L_L240  L_L255  0.0051
K_K29488  L_L240  L_L256  0.0047
K_K29489  L_L240  L_L257  0.0045
K_K29490  L_L240  L_L258  0.0042
K_K29491  L_L240  L_L259  0.0040
K_K29492  L_L240  L_L260  0.0038
K_K29493  L_L240  L_L261  0.0036
K_K29494  L_L240  L_L262  0.0034
K_K29495  L_L240  L_L263  0.0033
K_K29496  L_L240  L_L264  0.0032
K_K29497  L_L240  L_L265  0.0030
K_K29498  L_L240  L_L266  0.0029
K_K29499  L_L240  L_L267  0.0028
K_K29500  L_L240  L_L268  0.0027
K_K29501  L_L240  L_L269  0.0026
K_K29502  L_L240  L_L270  0.0025
K_K29503  L_L240  L_L271  0.0024
K_K29504  L_L240  L_L272  0.0024
K_K29505  L_L240  L_L273  0.0023
K_K29506  L_L240  L_L274  0.0022
K_K29507  L_L240  L_L275  0.0022
K_K29508  L_L240  L_L276  0.0021
* *  Branch  NTMP0000000240 - NTMP0000000241
R_R241  NTMP0000000240  nU_241  32.914993m  TC=0,0
V_Ui241  nU_241  nR_241  STIMULUS=U_IND_0000000241
R_V481  nR_241  nV_481  23.280268m  TC=0,0
L_V481  nR_241  nV_481  0.014646uH
R_V482  nV_481  nV_482  7.852787m  TC=0,0
L_V482  nV_481  nV_482  0.073723uH
L_L241  nV_482  NTMP0000000241  6.519695uH
K_K29509  L_L241  L_L242  0.1050
K_K29510  L_L241  L_L243  0.0397
K_K29511  L_L241  L_L244  0.0258
K_K29512  L_L241  L_L245  0.0192
K_K29513  L_L241  L_L246  0.0153
K_K29514  L_L241  L_L247  0.0127
K_K29515  L_L241  L_L248  0.0109
K_K29516  L_L241  L_L249  0.0095
K_K29517  L_L241  L_L250  0.0084
K_K29518  L_L241  L_L251  0.0076
K_K29519  L_L241  L_L252  0.0069
K_K29520  L_L241  L_L253  0.0063
K_K29521  L_L241  L_L254  0.0058
K_K29522  L_L241  L_L255  0.0054
K_K29523  L_L241  L_L256  0.0051
K_K29524  L_L241  L_L257  0.0047
K_K29525  L_L241  L_L258  0.0045
K_K29526  L_L241  L_L259  0.0042
K_K29527  L_L241  L_L260  0.0040
K_K29528  L_L241  L_L261  0.0038
K_K29529  L_L241  L_L262  0.0036
K_K29530  L_L241  L_L263  0.0034
K_K29531  L_L241  L_L264  0.0033
K_K29532  L_L241  L_L265  0.0032
K_K29533  L_L241  L_L266  0.0030
K_K29534  L_L241  L_L267  0.0029
K_K29535  L_L241  L_L268  0.0028
K_K29536  L_L241  L_L269  0.0027
K_K29537  L_L241  L_L270  0.0026
K_K29538  L_L241  L_L271  0.0025
K_K29539  L_L241  L_L272  0.0024
K_K29540  L_L241  L_L273  0.0024
K_K29541  L_L241  L_L274  0.0023
K_K29542  L_L241  L_L275  0.0022
K_K29543  L_L241  L_L276  0.0022
* *  Branch  NTMP0000000241 - NTMP0000000242
R_R242  NTMP0000000241  nU_242  32.914993m  TC=0,0
V_Ui242  nU_242  nR_242  STIMULUS=U_IND_0000000242
R_V483  nR_242  nV_483  23.280268m  TC=0,0
L_V483  nR_242  nV_483  0.014646uH
R_V484  nV_483  nV_484  7.852787m  TC=0,0
L_V484  nV_483  nV_484  0.073723uH
L_L242  nV_484  NTMP0000000242  6.519695uH
K_K29544  L_L242  L_L243  0.1050
K_K29545  L_L242  L_L244  0.0397
K_K29546  L_L242  L_L245  0.0258
K_K29547  L_L242  L_L246  0.0192
K_K29548  L_L242  L_L247  0.0153
K_K29549  L_L242  L_L248  0.0127
K_K29550  L_L242  L_L249  0.0109
K_K29551  L_L242  L_L250  0.0095
K_K29552  L_L242  L_L251  0.0084
K_K29553  L_L242  L_L252  0.0076
K_K29554  L_L242  L_L253  0.0069
K_K29555  L_L242  L_L254  0.0063
K_K29556  L_L242  L_L255  0.0058
K_K29557  L_L242  L_L256  0.0054
K_K29558  L_L242  L_L257  0.0051
K_K29559  L_L242  L_L258  0.0047
K_K29560  L_L242  L_L259  0.0045
K_K29561  L_L242  L_L260  0.0042
K_K29562  L_L242  L_L261  0.0040
K_K29563  L_L242  L_L262  0.0038
K_K29564  L_L242  L_L263  0.0036
K_K29565  L_L242  L_L264  0.0034
K_K29566  L_L242  L_L265  0.0033
K_K29567  L_L242  L_L266  0.0032
K_K29568  L_L242  L_L267  0.0030
K_K29569  L_L242  L_L268  0.0029
K_K29570  L_L242  L_L269  0.0028
K_K29571  L_L242  L_L270  0.0027
K_K29572  L_L242  L_L271  0.0026
K_K29573  L_L242  L_L272  0.0025
K_K29574  L_L242  L_L273  0.0024
K_K29575  L_L242  L_L274  0.0024
K_K29576  L_L242  L_L275  0.0023
K_K29577  L_L242  L_L276  0.0022
* *  Branch  NTMP0000000242 - NTMP0000000243
R_R243  NTMP0000000242  nU_243  32.914993m  TC=0,0
V_Ui243  nU_243  nR_243  STIMULUS=U_IND_0000000243
R_V485  nR_243  nV_485  23.280268m  TC=0,0
L_V485  nR_243  nV_485  0.014646uH
R_V486  nV_485  nV_486  7.852787m  TC=0,0
L_V486  nV_485  nV_486  0.073723uH
L_L243  nV_486  NTMP0000000243  6.519695uH
K_K29578  L_L243  L_L244  0.1050
K_K29579  L_L243  L_L245  0.0397
K_K29580  L_L243  L_L246  0.0258
K_K29581  L_L243  L_L247  0.0192
K_K29582  L_L243  L_L248  0.0153
K_K29583  L_L243  L_L249  0.0127
K_K29584  L_L243  L_L250  0.0109
K_K29585  L_L243  L_L251  0.0095
K_K29586  L_L243  L_L252  0.0084
K_K29587  L_L243  L_L253  0.0076
K_K29588  L_L243  L_L254  0.0069
K_K29589  L_L243  L_L255  0.0063
K_K29590  L_L243  L_L256  0.0058
K_K29591  L_L243  L_L257  0.0054
K_K29592  L_L243  L_L258  0.0051
K_K29593  L_L243  L_L259  0.0047
K_K29594  L_L243  L_L260  0.0045
K_K29595  L_L243  L_L261  0.0042
K_K29596  L_L243  L_L262  0.0040
K_K29597  L_L243  L_L263  0.0038
K_K29598  L_L243  L_L264  0.0036
K_K29599  L_L243  L_L265  0.0034
K_K29600  L_L243  L_L266  0.0033
K_K29601  L_L243  L_L267  0.0032
K_K29602  L_L243  L_L268  0.0030
K_K29603  L_L243  L_L269  0.0029
K_K29604  L_L243  L_L270  0.0028
K_K29605  L_L243  L_L271  0.0027
K_K29606  L_L243  L_L272  0.0026
K_K29607  L_L243  L_L273  0.0025
K_K29608  L_L243  L_L274  0.0024
K_K29609  L_L243  L_L275  0.0024
K_K29610  L_L243  L_L276  0.0023
* *  Branch  NTMP0000000243 - NTMP0000000244
R_R244  NTMP0000000243  nU_244  32.914993m  TC=0,0
V_Ui244  nU_244  nR_244  STIMULUS=U_IND_0000000244
R_V487  nR_244  nV_487  23.280268m  TC=0,0
L_V487  nR_244  nV_487  0.014646uH
R_V488  nV_487  nV_488  7.852787m  TC=0,0
L_V488  nV_487  nV_488  0.073723uH
L_L244  nV_488  NTMP0000000244  6.519695uH
K_K29611  L_L244  L_L245  0.1050
K_K29612  L_L244  L_L246  0.0397
K_K29613  L_L244  L_L247  0.0258
K_K29614  L_L244  L_L248  0.0192
K_K29615  L_L244  L_L249  0.0153
K_K29616  L_L244  L_L250  0.0127
K_K29617  L_L244  L_L251  0.0109
K_K29618  L_L244  L_L252  0.0095
K_K29619  L_L244  L_L253  0.0084
K_K29620  L_L244  L_L254  0.0076
K_K29621  L_L244  L_L255  0.0069
K_K29622  L_L244  L_L256  0.0063
K_K29623  L_L244  L_L257  0.0058
K_K29624  L_L244  L_L258  0.0054
K_K29625  L_L244  L_L259  0.0051
K_K29626  L_L244  L_L260  0.0047
K_K29627  L_L244  L_L261  0.0045
K_K29628  L_L244  L_L262  0.0042
K_K29629  L_L244  L_L263  0.0040
K_K29630  L_L244  L_L264  0.0038
K_K29631  L_L244  L_L265  0.0036
K_K29632  L_L244  L_L266  0.0034
K_K29633  L_L244  L_L267  0.0033
K_K29634  L_L244  L_L268  0.0032
K_K29635  L_L244  L_L269  0.0030
K_K29636  L_L244  L_L270  0.0029
K_K29637  L_L244  L_L271  0.0028
K_K29638  L_L244  L_L272  0.0027
K_K29639  L_L244  L_L273  0.0026
K_K29640  L_L244  L_L274  0.0025
K_K29641  L_L244  L_L275  0.0024
K_K29642  L_L244  L_L276  0.0024
* *  Branch  NTMP0000000244 - NTMP0000000245
R_R245  NTMP0000000244  nU_245  32.914993m  TC=0,0
V_Ui245  nU_245  nR_245  STIMULUS=U_IND_0000000245
R_V489  nR_245  nV_489  23.280268m  TC=0,0
L_V489  nR_245  nV_489  0.014646uH
R_V490  nV_489  nV_490  7.852787m  TC=0,0
L_V490  nV_489  nV_490  0.073723uH
L_L245  nV_490  NTMP0000000245  6.519695uH
K_K29643  L_L245  L_L246  0.1050
K_K29644  L_L245  L_L247  0.0397
K_K29645  L_L245  L_L248  0.0258
K_K29646  L_L245  L_L249  0.0192
K_K29647  L_L245  L_L250  0.0153
K_K29648  L_L245  L_L251  0.0127
K_K29649  L_L245  L_L252  0.0109
K_K29650  L_L245  L_L253  0.0095
K_K29651  L_L245  L_L254  0.0084
K_K29652  L_L245  L_L255  0.0076
K_K29653  L_L245  L_L256  0.0069
K_K29654  L_L245  L_L257  0.0063
K_K29655  L_L245  L_L258  0.0058
K_K29656  L_L245  L_L259  0.0054
K_K29657  L_L245  L_L260  0.0051
K_K29658  L_L245  L_L261  0.0047
K_K29659  L_L245  L_L262  0.0045
K_K29660  L_L245  L_L263  0.0042
K_K29661  L_L245  L_L264  0.0040
K_K29662  L_L245  L_L265  0.0038
K_K29663  L_L245  L_L266  0.0036
K_K29664  L_L245  L_L267  0.0034
K_K29665  L_L245  L_L268  0.0033
K_K29666  L_L245  L_L269  0.0032
K_K29667  L_L245  L_L270  0.0030
K_K29668  L_L245  L_L271  0.0029
K_K29669  L_L245  L_L272  0.0028
K_K29670  L_L245  L_L273  0.0027
K_K29671  L_L245  L_L274  0.0026
K_K29672  L_L245  L_L275  0.0025
K_K29673  L_L245  L_L276  0.0024
* *  Branch  NTMP0000000245 - NTMP0000000246
R_R246  NTMP0000000245  nU_246  32.914993m  TC=0,0
V_Ui246  nU_246  nR_246  STIMULUS=U_IND_0000000246
R_V491  nR_246  nV_491  23.280268m  TC=0,0
L_V491  nR_246  nV_491  0.014646uH
R_V492  nV_491  nV_492  7.852787m  TC=0,0
L_V492  nV_491  nV_492  0.073723uH
L_L246  nV_492  NTMP0000000246  6.519695uH
K_K29674  L_L246  L_L247  0.1050
K_K29675  L_L246  L_L248  0.0397
K_K29676  L_L246  L_L249  0.0258
K_K29677  L_L246  L_L250  0.0192
K_K29678  L_L246  L_L251  0.0153
K_K29679  L_L246  L_L252  0.0127
K_K29680  L_L246  L_L253  0.0109
K_K29681  L_L246  L_L254  0.0095
K_K29682  L_L246  L_L255  0.0084
K_K29683  L_L246  L_L256  0.0076
K_K29684  L_L246  L_L257  0.0069
K_K29685  L_L246  L_L258  0.0063
K_K29686  L_L246  L_L259  0.0058
K_K29687  L_L246  L_L260  0.0054
K_K29688  L_L246  L_L261  0.0051
K_K29689  L_L246  L_L262  0.0047
K_K29690  L_L246  L_L263  0.0045
K_K29691  L_L246  L_L264  0.0042
K_K29692  L_L246  L_L265  0.0040
K_K29693  L_L246  L_L266  0.0038
K_K29694  L_L246  L_L267  0.0036
K_K29695  L_L246  L_L268  0.0034
K_K29696  L_L246  L_L269  0.0033
K_K29697  L_L246  L_L270  0.0032
K_K29698  L_L246  L_L271  0.0030
K_K29699  L_L246  L_L272  0.0029
K_K29700  L_L246  L_L273  0.0028
K_K29701  L_L246  L_L274  0.0027
K_K29702  L_L246  L_L275  0.0026
K_K29703  L_L246  L_L276  0.0025
* *  Branch  NTMP0000000246 - NTMP0000000247
R_R247  NTMP0000000246  nU_247  32.914993m  TC=0,0
V_Ui247  nU_247  nR_247  STIMULUS=U_IND_0000000247
R_V493  nR_247  nV_493  23.280268m  TC=0,0
L_V493  nR_247  nV_493  0.014646uH
R_V494  nV_493  nV_494  7.852787m  TC=0,0
L_V494  nV_493  nV_494  0.073723uH
L_L247  nV_494  NTMP0000000247  6.519695uH
K_K29704  L_L247  L_L248  0.1050
K_K29705  L_L247  L_L249  0.0397
K_K29706  L_L247  L_L250  0.0258
K_K29707  L_L247  L_L251  0.0192
K_K29708  L_L247  L_L252  0.0153
K_K29709  L_L247  L_L253  0.0127
K_K29710  L_L247  L_L254  0.0109
K_K29711  L_L247  L_L255  0.0095
K_K29712  L_L247  L_L256  0.0084
K_K29713  L_L247  L_L257  0.0076
K_K29714  L_L247  L_L258  0.0069
K_K29715  L_L247  L_L259  0.0063
K_K29716  L_L247  L_L260  0.0058
K_K29717  L_L247  L_L261  0.0054
K_K29718  L_L247  L_L262  0.0051
K_K29719  L_L247  L_L263  0.0047
K_K29720  L_L247  L_L264  0.0045
K_K29721  L_L247  L_L265  0.0042
K_K29722  L_L247  L_L266  0.0040
K_K29723  L_L247  L_L267  0.0038
K_K29724  L_L247  L_L268  0.0036
K_K29725  L_L247  L_L269  0.0034
K_K29726  L_L247  L_L270  0.0033
K_K29727  L_L247  L_L271  0.0032
K_K29728  L_L247  L_L272  0.0030
K_K29729  L_L247  L_L273  0.0029
K_K29730  L_L247  L_L274  0.0028
K_K29731  L_L247  L_L275  0.0027
K_K29732  L_L247  L_L276  0.0026
* *  Branch  NTMP0000000247 - NTMP0000000248
R_R248  NTMP0000000247  nU_248  32.914993m  TC=0,0
V_Ui248  nU_248  nR_248  STIMULUS=U_IND_0000000248
R_V495  nR_248  nV_495  23.280268m  TC=0,0
L_V495  nR_248  nV_495  0.014646uH
R_V496  nV_495  nV_496  7.852787m  TC=0,0
L_V496  nV_495  nV_496  0.073723uH
L_L248  nV_496  NTMP0000000248  6.519695uH
K_K29733  L_L248  L_L249  0.1050
K_K29734  L_L248  L_L250  0.0397
K_K29735  L_L248  L_L251  0.0258
K_K29736  L_L248  L_L252  0.0192
K_K29737  L_L248  L_L253  0.0153
K_K29738  L_L248  L_L254  0.0127
K_K29739  L_L248  L_L255  0.0109
K_K29740  L_L248  L_L256  0.0095
K_K29741  L_L248  L_L257  0.0084
K_K29742  L_L248  L_L258  0.0076
K_K29743  L_L248  L_L259  0.0069
K_K29744  L_L248  L_L260  0.0063
K_K29745  L_L248  L_L261  0.0058
K_K29746  L_L248  L_L262  0.0054
K_K29747  L_L248  L_L263  0.0051
K_K29748  L_L248  L_L264  0.0047
K_K29749  L_L248  L_L265  0.0045
K_K29750  L_L248  L_L266  0.0042
K_K29751  L_L248  L_L267  0.0040
K_K29752  L_L248  L_L268  0.0038
K_K29753  L_L248  L_L269  0.0036
K_K29754  L_L248  L_L270  0.0034
K_K29755  L_L248  L_L271  0.0033
K_K29756  L_L248  L_L272  0.0032
K_K29757  L_L248  L_L273  0.0030
K_K29758  L_L248  L_L274  0.0029
K_K29759  L_L248  L_L275  0.0028
K_K29760  L_L248  L_L276  0.0027
* *  Branch  NTMP0000000248 - NTMP0000000249
R_R249  NTMP0000000248  nU_249  32.914993m  TC=0,0
V_Ui249  nU_249  nR_249  STIMULUS=U_IND_0000000249
R_V497  nR_249  nV_497  23.280268m  TC=0,0
L_V497  nR_249  nV_497  0.014646uH
R_V498  nV_497  nV_498  7.852787m  TC=0,0
L_V498  nV_497  nV_498  0.073723uH
L_L249  nV_498  NTMP0000000249  6.519695uH
K_K29761  L_L249  L_L250  0.1050
K_K29762  L_L249  L_L251  0.0397
K_K29763  L_L249  L_L252  0.0258
K_K29764  L_L249  L_L253  0.0192
K_K29765  L_L249  L_L254  0.0153
K_K29766  L_L249  L_L255  0.0127
K_K29767  L_L249  L_L256  0.0109
K_K29768  L_L249  L_L257  0.0095
K_K29769  L_L249  L_L258  0.0084
K_K29770  L_L249  L_L259  0.0076
K_K29771  L_L249  L_L260  0.0069
K_K29772  L_L249  L_L261  0.0063
K_K29773  L_L249  L_L262  0.0058
K_K29774  L_L249  L_L263  0.0054
K_K29775  L_L249  L_L264  0.0051
K_K29776  L_L249  L_L265  0.0047
K_K29777  L_L249  L_L266  0.0045
K_K29778  L_L249  L_L267  0.0042
K_K29779  L_L249  L_L268  0.0040
K_K29780  L_L249  L_L269  0.0038
K_K29781  L_L249  L_L270  0.0036
K_K29782  L_L249  L_L271  0.0034
K_K29783  L_L249  L_L272  0.0033
K_K29784  L_L249  L_L273  0.0032
K_K29785  L_L249  L_L274  0.0030
K_K29786  L_L249  L_L275  0.0029
K_K29787  L_L249  L_L276  0.0028
* *  Branch  NTMP0000000249 - NTMP0000000250
R_R250  NTMP0000000249  nU_250  32.914993m  TC=0,0
V_Ui250  nU_250  nR_250  STIMULUS=U_IND_0000000250
R_V499  nR_250  nV_499  23.280268m  TC=0,0
L_V499  nR_250  nV_499  0.014646uH
R_V500  nV_499  nV_500  7.852787m  TC=0,0
L_V500  nV_499  nV_500  0.073723uH
L_L250  nV_500  NTMP0000000250  6.519695uH
K_K29788  L_L250  L_L251  0.1050
K_K29789  L_L250  L_L252  0.0397
K_K29790  L_L250  L_L253  0.0258
K_K29791  L_L250  L_L254  0.0192
K_K29792  L_L250  L_L255  0.0153
K_K29793  L_L250  L_L256  0.0127
K_K29794  L_L250  L_L257  0.0109
K_K29795  L_L250  L_L258  0.0095
K_K29796  L_L250  L_L259  0.0084
K_K29797  L_L250  L_L260  0.0076
K_K29798  L_L250  L_L261  0.0069
K_K29799  L_L250  L_L262  0.0063
K_K29800  L_L250  L_L263  0.0058
K_K29801  L_L250  L_L264  0.0054
K_K29802  L_L250  L_L265  0.0051
K_K29803  L_L250  L_L266  0.0047
K_K29804  L_L250  L_L267  0.0045
K_K29805  L_L250  L_L268  0.0042
K_K29806  L_L250  L_L269  0.0040
K_K29807  L_L250  L_L270  0.0038
K_K29808  L_L250  L_L271  0.0036
K_K29809  L_L250  L_L272  0.0034
K_K29810  L_L250  L_L273  0.0033
K_K29811  L_L250  L_L274  0.0032
K_K29812  L_L250  L_L275  0.0030
K_K29813  L_L250  L_L276  0.0029
* *  Branch  NTMP0000000250 - NTMP0000000251
R_R251  NTMP0000000250  nU_251  32.914993m  TC=0,0
V_Ui251  nU_251  nR_251  STIMULUS=U_IND_0000000251
R_V501  nR_251  nV_501  23.280268m  TC=0,0
L_V501  nR_251  nV_501  0.014646uH
R_V502  nV_501  nV_502  7.852787m  TC=0,0
L_V502  nV_501  nV_502  0.073723uH
L_L251  nV_502  NTMP0000000251  6.519695uH
K_K29814  L_L251  L_L252  0.1050
K_K29815  L_L251  L_L253  0.0397
K_K29816  L_L251  L_L254  0.0258
K_K29817  L_L251  L_L255  0.0192
K_K29818  L_L251  L_L256  0.0153
K_K29819  L_L251  L_L257  0.0127
K_K29820  L_L251  L_L258  0.0109
K_K29821  L_L251  L_L259  0.0095
K_K29822  L_L251  L_L260  0.0084
K_K29823  L_L251  L_L261  0.0076
K_K29824  L_L251  L_L262  0.0069
K_K29825  L_L251  L_L263  0.0063
K_K29826  L_L251  L_L264  0.0058
K_K29827  L_L251  L_L265  0.0054
K_K29828  L_L251  L_L266  0.0051
K_K29829  L_L251  L_L267  0.0047
K_K29830  L_L251  L_L268  0.0045
K_K29831  L_L251  L_L269  0.0042
K_K29832  L_L251  L_L270  0.0040
K_K29833  L_L251  L_L271  0.0038
K_K29834  L_L251  L_L272  0.0036
K_K29835  L_L251  L_L273  0.0034
K_K29836  L_L251  L_L274  0.0033
K_K29837  L_L251  L_L275  0.0032
K_K29838  L_L251  L_L276  0.0030
* *  Branch  NTMP0000000251 - NTMP0000000252
R_R252  NTMP0000000251  nU_252  32.914993m  TC=0,0
V_Ui252  nU_252  nR_252  STIMULUS=U_IND_0000000252
R_V503  nR_252  nV_503  23.280268m  TC=0,0
L_V503  nR_252  nV_503  0.014646uH
R_V504  nV_503  nV_504  7.852787m  TC=0,0
L_V504  nV_503  nV_504  0.073723uH
L_L252  nV_504  NTMP0000000252  6.519695uH
K_K29839  L_L252  L_L253  0.1050
K_K29840  L_L252  L_L254  0.0397
K_K29841  L_L252  L_L255  0.0258
K_K29842  L_L252  L_L256  0.0192
K_K29843  L_L252  L_L257  0.0153
K_K29844  L_L252  L_L258  0.0127
K_K29845  L_L252  L_L259  0.0109
K_K29846  L_L252  L_L260  0.0095
K_K29847  L_L252  L_L261  0.0084
K_K29848  L_L252  L_L262  0.0076
K_K29849  L_L252  L_L263  0.0069
K_K29850  L_L252  L_L264  0.0063
K_K29851  L_L252  L_L265  0.0058
K_K29852  L_L252  L_L266  0.0054
K_K29853  L_L252  L_L267  0.0051
K_K29854  L_L252  L_L268  0.0047
K_K29855  L_L252  L_L269  0.0045
K_K29856  L_L252  L_L270  0.0042
K_K29857  L_L252  L_L271  0.0040
K_K29858  L_L252  L_L272  0.0038
K_K29859  L_L252  L_L273  0.0036
K_K29860  L_L252  L_L274  0.0034
K_K29861  L_L252  L_L275  0.0033
K_K29862  L_L252  L_L276  0.0032
* *  Branch  NTMP0000000252 - NTMP0000000253
R_R253  NTMP0000000252  nU_253  32.914993m  TC=0,0
V_Ui253  nU_253  nR_253  STIMULUS=U_IND_0000000253
R_V505  nR_253  nV_505  23.280268m  TC=0,0
L_V505  nR_253  nV_505  0.014646uH
R_V506  nV_505  nV_506  7.852787m  TC=0,0
L_V506  nV_505  nV_506  0.073723uH
L_L253  nV_506  NTMP0000000253  6.519695uH
K_K29863  L_L253  L_L254  0.1050
K_K29864  L_L253  L_L255  0.0397
K_K29865  L_L253  L_L256  0.0258
K_K29866  L_L253  L_L257  0.0192
K_K29867  L_L253  L_L258  0.0153
K_K29868  L_L253  L_L259  0.0127
K_K29869  L_L253  L_L260  0.0109
K_K29870  L_L253  L_L261  0.0095
K_K29871  L_L253  L_L262  0.0084
K_K29872  L_L253  L_L263  0.0076
K_K29873  L_L253  L_L264  0.0069
K_K29874  L_L253  L_L265  0.0063
K_K29875  L_L253  L_L266  0.0058
K_K29876  L_L253  L_L267  0.0054
K_K29877  L_L253  L_L268  0.0051
K_K29878  L_L253  L_L269  0.0047
K_K29879  L_L253  L_L270  0.0045
K_K29880  L_L253  L_L271  0.0042
K_K29881  L_L253  L_L272  0.0040
K_K29882  L_L253  L_L273  0.0038
K_K29883  L_L253  L_L274  0.0036
K_K29884  L_L253  L_L275  0.0034
K_K29885  L_L253  L_L276  0.0033
* *  Branch  NTMP0000000253 - NTMP0000000254
R_R254  NTMP0000000253  nU_254  32.914993m  TC=0,0
V_Ui254  nU_254  nR_254  STIMULUS=U_IND_0000000254
R_V507  nR_254  nV_507  23.280268m  TC=0,0
L_V507  nR_254  nV_507  0.014646uH
R_V508  nV_507  nV_508  7.852787m  TC=0,0
L_V508  nV_507  nV_508  0.073723uH
L_L254  nV_508  NTMP0000000254  6.519695uH
K_K29886  L_L254  L_L255  0.1050
K_K29887  L_L254  L_L256  0.0397
K_K29888  L_L254  L_L257  0.0258
K_K29889  L_L254  L_L258  0.0192
K_K29890  L_L254  L_L259  0.0153
K_K29891  L_L254  L_L260  0.0127
K_K29892  L_L254  L_L261  0.0109
K_K29893  L_L254  L_L262  0.0095
K_K29894  L_L254  L_L263  0.0084
K_K29895  L_L254  L_L264  0.0076
K_K29896  L_L254  L_L265  0.0069
K_K29897  L_L254  L_L266  0.0063
K_K29898  L_L254  L_L267  0.0058
K_K29899  L_L254  L_L268  0.0054
K_K29900  L_L254  L_L269  0.0051
K_K29901  L_L254  L_L270  0.0047
K_K29902  L_L254  L_L271  0.0045
K_K29903  L_L254  L_L272  0.0042
K_K29904  L_L254  L_L273  0.0040
K_K29905  L_L254  L_L274  0.0038
K_K29906  L_L254  L_L275  0.0036
K_K29907  L_L254  L_L276  0.0034
* *  Branch  NTMP0000000254 - NTMP0000000255
R_R255  NTMP0000000254  nU_255  32.914993m  TC=0,0
V_Ui255  nU_255  nR_255  STIMULUS=U_IND_0000000255
R_V509  nR_255  nV_509  23.280268m  TC=0,0
L_V509  nR_255  nV_509  0.014646uH
R_V510  nV_509  nV_510  7.852787m  TC=0,0
L_V510  nV_509  nV_510  0.073723uH
L_L255  nV_510  NTMP0000000255  6.519695uH
K_K29908  L_L255  L_L256  0.1050
K_K29909  L_L255  L_L257  0.0397
K_K29910  L_L255  L_L258  0.0258
K_K29911  L_L255  L_L259  0.0192
K_K29912  L_L255  L_L260  0.0153
K_K29913  L_L255  L_L261  0.0127
K_K29914  L_L255  L_L262  0.0109
K_K29915  L_L255  L_L263  0.0095
K_K29916  L_L255  L_L264  0.0084
K_K29917  L_L255  L_L265  0.0076
K_K29918  L_L255  L_L266  0.0069
K_K29919  L_L255  L_L267  0.0063
K_K29920  L_L255  L_L268  0.0058
K_K29921  L_L255  L_L269  0.0054
K_K29922  L_L255  L_L270  0.0051
K_K29923  L_L255  L_L271  0.0047
K_K29924  L_L255  L_L272  0.0045
K_K29925  L_L255  L_L273  0.0042
K_K29926  L_L255  L_L274  0.0040
K_K29927  L_L255  L_L275  0.0038
K_K29928  L_L255  L_L276  0.0036
* *  Branch  NTMP0000000255 - NTMP0000000256
R_R256  NTMP0000000255  nU_256  32.914993m  TC=0,0
V_Ui256  nU_256  nR_256  STIMULUS=U_IND_0000000256
R_V511  nR_256  nV_511  23.280268m  TC=0,0
L_V511  nR_256  nV_511  0.014646uH
R_V512  nV_511  nV_512  7.852787m  TC=0,0
L_V512  nV_511  nV_512  0.073723uH
L_L256  nV_512  NTMP0000000256  6.519695uH
K_K29929  L_L256  L_L257  0.1050
K_K29930  L_L256  L_L258  0.0397
K_K29931  L_L256  L_L259  0.0258
K_K29932  L_L256  L_L260  0.0192
K_K29933  L_L256  L_L261  0.0153
K_K29934  L_L256  L_L262  0.0127
K_K29935  L_L256  L_L263  0.0109
K_K29936  L_L256  L_L264  0.0095
K_K29937  L_L256  L_L265  0.0084
K_K29938  L_L256  L_L266  0.0076
K_K29939  L_L256  L_L267  0.0069
K_K29940  L_L256  L_L268  0.0063
K_K29941  L_L256  L_L269  0.0058
K_K29942  L_L256  L_L270  0.0054
K_K29943  L_L256  L_L271  0.0051
K_K29944  L_L256  L_L272  0.0047
K_K29945  L_L256  L_L273  0.0045
K_K29946  L_L256  L_L274  0.0042
K_K29947  L_L256  L_L275  0.0040
K_K29948  L_L256  L_L276  0.0038
* *  Branch  NTMP0000000256 - NTMP0000000257
R_R257  NTMP0000000256  nU_257  32.914993m  TC=0,0
V_Ui257  nU_257  nR_257  STIMULUS=U_IND_0000000257
R_V513  nR_257  nV_513  23.280268m  TC=0,0
L_V513  nR_257  nV_513  0.014646uH
R_V514  nV_513  nV_514  7.852787m  TC=0,0
L_V514  nV_513  nV_514  0.073723uH
L_L257  nV_514  NTMP0000000257  6.519695uH
K_K29949  L_L257  L_L258  0.1050
K_K29950  L_L257  L_L259  0.0397
K_K29951  L_L257  L_L260  0.0258
K_K29952  L_L257  L_L261  0.0192
K_K29953  L_L257  L_L262  0.0153
K_K29954  L_L257  L_L263  0.0127
K_K29955  L_L257  L_L264  0.0109
K_K29956  L_L257  L_L265  0.0095
K_K29957  L_L257  L_L266  0.0084
K_K29958  L_L257  L_L267  0.0076
K_K29959  L_L257  L_L268  0.0069
K_K29960  L_L257  L_L269  0.0063
K_K29961  L_L257  L_L270  0.0058
K_K29962  L_L257  L_L271  0.0054
K_K29963  L_L257  L_L272  0.0051
K_K29964  L_L257  L_L273  0.0047
K_K29965  L_L257  L_L274  0.0045
K_K29966  L_L257  L_L275  0.0042
K_K29967  L_L257  L_L276  0.0040
* *  Branch  NTMP0000000257 - NTMP0000000258
R_R258  NTMP0000000257  nU_258  32.914993m  TC=0,0
V_Ui258  nU_258  nR_258  STIMULUS=U_IND_0000000258
R_V515  nR_258  nV_515  23.280268m  TC=0,0
L_V515  nR_258  nV_515  0.014646uH
R_V516  nV_515  nV_516  7.852787m  TC=0,0
L_V516  nV_515  nV_516  0.073723uH
L_L258  nV_516  NTMP0000000258  6.519695uH
K_K29968  L_L258  L_L259  0.1050
K_K29969  L_L258  L_L260  0.0397
K_K29970  L_L258  L_L261  0.0258
K_K29971  L_L258  L_L262  0.0192
K_K29972  L_L258  L_L263  0.0153
K_K29973  L_L258  L_L264  0.0127
K_K29974  L_L258  L_L265  0.0109
K_K29975  L_L258  L_L266  0.0095
K_K29976  L_L258  L_L267  0.0084
K_K29977  L_L258  L_L268  0.0076
K_K29978  L_L258  L_L269  0.0069
K_K29979  L_L258  L_L270  0.0063
K_K29980  L_L258  L_L271  0.0058
K_K29981  L_L258  L_L272  0.0054
K_K29982  L_L258  L_L273  0.0051
K_K29983  L_L258  L_L274  0.0047
K_K29984  L_L258  L_L275  0.0045
K_K29985  L_L258  L_L276  0.0042
* *  Branch  NTMP0000000258 - NTMP0000000259
R_R259  NTMP0000000258  nU_259  32.914993m  TC=0,0
V_Ui259  nU_259  nR_259  STIMULUS=U_IND_0000000259
R_V517  nR_259  nV_517  23.280268m  TC=0,0
L_V517  nR_259  nV_517  0.014646uH
R_V518  nV_517  nV_518  7.852787m  TC=0,0
L_V518  nV_517  nV_518  0.073723uH
L_L259  nV_518  NTMP0000000259  6.519695uH
K_K29986  L_L259  L_L260  0.1050
K_K29987  L_L259  L_L261  0.0397
K_K29988  L_L259  L_L262  0.0258
K_K29989  L_L259  L_L263  0.0192
K_K29990  L_L259  L_L264  0.0153
K_K29991  L_L259  L_L265  0.0127
K_K29992  L_L259  L_L266  0.0109
K_K29993  L_L259  L_L267  0.0095
K_K29994  L_L259  L_L268  0.0084
K_K29995  L_L259  L_L269  0.0076
K_K29996  L_L259  L_L270  0.0069
K_K29997  L_L259  L_L271  0.0063
K_K29998  L_L259  L_L272  0.0058
K_K29999  L_L259  L_L273  0.0054
K_K30000  L_L259  L_L274  0.0051
K_K30001  L_L259  L_L275  0.0047
K_K30002  L_L259  L_L276  0.0045
* *  Branch  NTMP0000000259 - NTMP0000000260
R_R260  NTMP0000000259  nU_260  32.914993m  TC=0,0
V_Ui260  nU_260  nR_260  STIMULUS=U_IND_0000000260
R_V519  nR_260  nV_519  23.280268m  TC=0,0
L_V519  nR_260  nV_519  0.014646uH
R_V520  nV_519  nV_520  7.852787m  TC=0,0
L_V520  nV_519  nV_520  0.073723uH
L_L260  nV_520  NTMP0000000260  6.519695uH
K_K30003  L_L260  L_L261  0.1050
K_K30004  L_L260  L_L262  0.0397
K_K30005  L_L260  L_L263  0.0258
K_K30006  L_L260  L_L264  0.0192
K_K30007  L_L260  L_L265  0.0153
K_K30008  L_L260  L_L266  0.0127
K_K30009  L_L260  L_L267  0.0109
K_K30010  L_L260  L_L268  0.0095
K_K30011  L_L260  L_L269  0.0084
K_K30012  L_L260  L_L270  0.0076
K_K30013  L_L260  L_L271  0.0069
K_K30014  L_L260  L_L272  0.0063
K_K30015  L_L260  L_L273  0.0058
K_K30016  L_L260  L_L274  0.0054
K_K30017  L_L260  L_L275  0.0051
K_K30018  L_L260  L_L276  0.0047
* *  Branch  NTMP0000000260 - NTMP0000000261
R_R261  NTMP0000000260  nU_261  32.914993m  TC=0,0
V_Ui261  nU_261  nR_261  STIMULUS=U_IND_0000000261
R_V521  nR_261  nV_521  23.280268m  TC=0,0
L_V521  nR_261  nV_521  0.014646uH
R_V522  nV_521  nV_522  7.852787m  TC=0,0
L_V522  nV_521  nV_522  0.073723uH
L_L261  nV_522  NTMP0000000261  6.519695uH
K_K30019  L_L261  L_L262  0.1050
K_K30020  L_L261  L_L263  0.0397
K_K30021  L_L261  L_L264  0.0258
K_K30022  L_L261  L_L265  0.0192
K_K30023  L_L261  L_L266  0.0153
K_K30024  L_L261  L_L267  0.0127
K_K30025  L_L261  L_L268  0.0109
K_K30026  L_L261  L_L269  0.0095
K_K30027  L_L261  L_L270  0.0084
K_K30028  L_L261  L_L271  0.0076
K_K30029  L_L261  L_L272  0.0069
K_K30030  L_L261  L_L273  0.0063
K_K30031  L_L261  L_L274  0.0058
K_K30032  L_L261  L_L275  0.0054
K_K30033  L_L261  L_L276  0.0051
* *  Branch  NTMP0000000261 - NTMP0000000262
R_R262  NTMP0000000261  nU_262  32.914993m  TC=0,0
V_Ui262  nU_262  nR_262  STIMULUS=U_IND_0000000262
R_V523  nR_262  nV_523  23.280268m  TC=0,0
L_V523  nR_262  nV_523  0.014646uH
R_V524  nV_523  nV_524  7.852787m  TC=0,0
L_V524  nV_523  nV_524  0.073723uH
L_L262  nV_524  NTMP0000000262  6.519695uH
K_K30034  L_L262  L_L263  0.1050
K_K30035  L_L262  L_L264  0.0397
K_K30036  L_L262  L_L265  0.0258
K_K30037  L_L262  L_L266  0.0192
K_K30038  L_L262  L_L267  0.0153
K_K30039  L_L262  L_L268  0.0127
K_K30040  L_L262  L_L269  0.0109
K_K30041  L_L262  L_L270  0.0095
K_K30042  L_L262  L_L271  0.0084
K_K30043  L_L262  L_L272  0.0076
K_K30044  L_L262  L_L273  0.0069
K_K30045  L_L262  L_L274  0.0063
K_K30046  L_L262  L_L275  0.0058
K_K30047  L_L262  L_L276  0.0054
* *  Branch  NTMP0000000262 - NTMP0000000263
R_R263  NTMP0000000262  nU_263  32.914993m  TC=0,0
V_Ui263  nU_263  nR_263  STIMULUS=U_IND_0000000263
R_V525  nR_263  nV_525  23.280268m  TC=0,0
L_V525  nR_263  nV_525  0.014646uH
R_V526  nV_525  nV_526  7.852787m  TC=0,0
L_V526  nV_525  nV_526  0.073723uH
L_L263  nV_526  NTMP0000000263  6.519695uH
K_K30048  L_L263  L_L264  0.1050
K_K30049  L_L263  L_L265  0.0397
K_K30050  L_L263  L_L266  0.0258
K_K30051  L_L263  L_L267  0.0192
K_K30052  L_L263  L_L268  0.0153
K_K30053  L_L263  L_L269  0.0127
K_K30054  L_L263  L_L270  0.0109
K_K30055  L_L263  L_L271  0.0095
K_K30056  L_L263  L_L272  0.0084
K_K30057  L_L263  L_L273  0.0076
K_K30058  L_L263  L_L274  0.0069
K_K30059  L_L263  L_L275  0.0063
K_K30060  L_L263  L_L276  0.0058
* *  Branch  NTMP0000000263 - NTMP0000000264
R_R264  NTMP0000000263  nU_264  32.914993m  TC=0,0
V_Ui264  nU_264  nR_264  STIMULUS=U_IND_0000000264
R_V527  nR_264  nV_527  23.280268m  TC=0,0
L_V527  nR_264  nV_527  0.014646uH
R_V528  nV_527  nV_528  7.852787m  TC=0,0
L_V528  nV_527  nV_528  0.073723uH
L_L264  nV_528  NTMP0000000264  6.519695uH
K_K30061  L_L264  L_L265  0.1050
K_K30062  L_L264  L_L266  0.0397
K_K30063  L_L264  L_L267  0.0258
K_K30064  L_L264  L_L268  0.0192
K_K30065  L_L264  L_L269  0.0153
K_K30066  L_L264  L_L270  0.0127
K_K30067  L_L264  L_L271  0.0109
K_K30068  L_L264  L_L272  0.0095
K_K30069  L_L264  L_L273  0.0084
K_K30070  L_L264  L_L274  0.0076
K_K30071  L_L264  L_L275  0.0069
K_K30072  L_L264  L_L276  0.0063
* *  Branch  NTMP0000000264 - NTMP0000000265
R_R265  NTMP0000000264  nU_265  32.914993m  TC=0,0
V_Ui265  nU_265  nR_265  STIMULUS=U_IND_0000000265
R_V529  nR_265  nV_529  23.280268m  TC=0,0
L_V529  nR_265  nV_529  0.014646uH
R_V530  nV_529  nV_530  7.852787m  TC=0,0
L_V530  nV_529  nV_530  0.073723uH
L_L265  nV_530  NTMP0000000265  6.519695uH
K_K30073  L_L265  L_L266  0.1050
K_K30074  L_L265  L_L267  0.0397
K_K30075  L_L265  L_L268  0.0258
K_K30076  L_L265  L_L269  0.0192
K_K30077  L_L265  L_L270  0.0153
K_K30078  L_L265  L_L271  0.0127
K_K30079  L_L265  L_L272  0.0109
K_K30080  L_L265  L_L273  0.0095
K_K30081  L_L265  L_L274  0.0084
K_K30082  L_L265  L_L275  0.0076
K_K30083  L_L265  L_L276  0.0069
* *  Branch  NTMP0000000265 - NTMP0000000266
R_R266  NTMP0000000265  nU_266  32.914993m  TC=0,0
V_Ui266  nU_266  nR_266  STIMULUS=U_IND_0000000266
R_V531  nR_266  nV_531  23.280268m  TC=0,0
L_V531  nR_266  nV_531  0.014646uH
R_V532  nV_531  nV_532  7.852787m  TC=0,0
L_V532  nV_531  nV_532  0.073723uH
L_L266  nV_532  NTMP0000000266  6.519695uH
K_K30084  L_L266  L_L267  0.1050
K_K30085  L_L266  L_L268  0.0397
K_K30086  L_L266  L_L269  0.0258
K_K30087  L_L266  L_L270  0.0192
K_K30088  L_L266  L_L271  0.0153
K_K30089  L_L266  L_L272  0.0127
K_K30090  L_L266  L_L273  0.0109
K_K30091  L_L266  L_L274  0.0095
K_K30092  L_L266  L_L275  0.0084
K_K30093  L_L266  L_L276  0.0076
* *  Branch  NTMP0000000266 - NTMP0000000267
R_R267  NTMP0000000266  nU_267  32.914993m  TC=0,0
V_Ui267  nU_267  nR_267  STIMULUS=U_IND_0000000267
R_V533  nR_267  nV_533  23.280268m  TC=0,0
L_V533  nR_267  nV_533  0.014646uH
R_V534  nV_533  nV_534  7.852787m  TC=0,0
L_V534  nV_533  nV_534  0.073723uH
L_L267  nV_534  NTMP0000000267  6.519695uH
K_K30094  L_L267  L_L268  0.1050
K_K30095  L_L267  L_L269  0.0397
K_K30096  L_L267  L_L270  0.0258
K_K30097  L_L267  L_L271  0.0192
K_K30098  L_L267  L_L272  0.0153
K_K30099  L_L267  L_L273  0.0127
K_K30100  L_L267  L_L274  0.0109
K_K30101  L_L267  L_L275  0.0095
K_K30102  L_L267  L_L276  0.0084
* *  Branch  NTMP0000000267 - NTMP0000000268
R_R268  NTMP0000000267  nU_268  32.914993m  TC=0,0
V_Ui268  nU_268  nR_268  STIMULUS=U_IND_0000000268
R_V535  nR_268  nV_535  23.280268m  TC=0,0
L_V535  nR_268  nV_535  0.014646uH
R_V536  nV_535  nV_536  7.852787m  TC=0,0
L_V536  nV_535  nV_536  0.073723uH
L_L268  nV_536  NTMP0000000268  6.519695uH
K_K30103  L_L268  L_L269  0.1050
K_K30104  L_L268  L_L270  0.0397
K_K30105  L_L268  L_L271  0.0258
K_K30106  L_L268  L_L272  0.0192
K_K30107  L_L268  L_L273  0.0153
K_K30108  L_L268  L_L274  0.0127
K_K30109  L_L268  L_L275  0.0109
K_K30110  L_L268  L_L276  0.0095
* *  Branch  NTMP0000000268 - NTMP0000000269
R_R269  NTMP0000000268  nU_269  32.914993m  TC=0,0
V_Ui269  nU_269  nR_269  STIMULUS=U_IND_0000000269
R_V537  nR_269  nV_537  23.280268m  TC=0,0
L_V537  nR_269  nV_537  0.014646uH
R_V538  nV_537  nV_538  7.852787m  TC=0,0
L_V538  nV_537  nV_538  0.073723uH
L_L269  nV_538  NTMP0000000269  6.519695uH
K_K30111  L_L269  L_L270  0.1050
K_K30112  L_L269  L_L271  0.0397
K_K30113  L_L269  L_L272  0.0258
K_K30114  L_L269  L_L273  0.0192
K_K30115  L_L269  L_L274  0.0153
K_K30116  L_L269  L_L275  0.0127
K_K30117  L_L269  L_L276  0.0109
* *  Branch  NTMP0000000269 - NTMP0000000270
R_R270  NTMP0000000269  nU_270  32.914993m  TC=0,0
V_Ui270  nU_270  nR_270  STIMULUS=U_IND_0000000270
R_V539  nR_270  nV_539  23.280268m  TC=0,0
L_V539  nR_270  nV_539  0.014646uH
R_V540  nV_539  nV_540  7.852787m  TC=0,0
L_V540  nV_539  nV_540  0.073723uH
L_L270  nV_540  NTMP0000000270  6.519695uH
K_K30118  L_L270  L_L271  0.1050
K_K30119  L_L270  L_L272  0.0397
K_K30120  L_L270  L_L273  0.0258
K_K30121  L_L270  L_L274  0.0192
K_K30122  L_L270  L_L275  0.0153
K_K30123  L_L270  L_L276  0.0127
* *  Branch  NTMP0000000270 - NTMP0000000271
R_R271  NTMP0000000270  nU_271  32.914993m  TC=0,0
V_Ui271  nU_271  nR_271  STIMULUS=U_IND_0000000271
R_V541  nR_271  nV_541  23.280268m  TC=0,0
L_V541  nR_271  nV_541  0.014646uH
R_V542  nV_541  nV_542  7.852787m  TC=0,0
L_V542  nV_541  nV_542  0.073723uH
L_L271  nV_542  NTMP0000000271  6.519695uH
K_K30124  L_L271  L_L272  0.1050
K_K30125  L_L271  L_L273  0.0397
K_K30126  L_L271  L_L274  0.0258
K_K30127  L_L271  L_L275  0.0192
K_K30128  L_L271  L_L276  0.0153
* *  Branch  NTMP0000000271 - NTMP0000000272
R_R272  NTMP0000000271  nU_272  32.914993m  TC=0,0
V_Ui272  nU_272  nR_272  STIMULUS=U_IND_0000000272
R_V543  nR_272  nV_543  23.280268m  TC=0,0
L_V543  nR_272  nV_543  0.014646uH
R_V544  nV_543  nV_544  7.852787m  TC=0,0
L_V544  nV_543  nV_544  0.073723uH
L_L272  nV_544  NTMP0000000272  6.519695uH
K_K30129  L_L272  L_L273  0.1050
K_K30130  L_L272  L_L274  0.0397
K_K30131  L_L272  L_L275  0.0258
K_K30132  L_L272  L_L276  0.0192
* *  Branch  NTMP0000000272 - NTMP0000000273
R_R273  NTMP0000000272  nU_273  32.914993m  TC=0,0
V_Ui273  nU_273  nR_273  STIMULUS=U_IND_0000000273
R_V545  nR_273  nV_545  23.280268m  TC=0,0
L_V545  nR_273  nV_545  0.014646uH
R_V546  nV_545  nV_546  7.852787m  TC=0,0
L_V546  nV_545  nV_546  0.073723uH
L_L273  nV_546  NTMP0000000273  6.519695uH
K_K30133  L_L273  L_L274  0.1050
K_K30134  L_L273  L_L275  0.0397
K_K30135  L_L273  L_L276  0.0258
* *  Branch  NTMP0000000273 - NTMP0000000274
R_R274  NTMP0000000273  nU_274  32.914993m  TC=0,0
V_Ui274  nU_274  nR_274  STIMULUS=U_IND_0000000274
R_V547  nR_274  nV_547  23.280268m  TC=0,0
L_V547  nR_274  nV_547  0.014646uH
R_V548  nV_547  nV_548  7.852787m  TC=0,0
L_V548  nV_547  nV_548  0.073723uH
L_L274  nV_548  NTMP0000000274  6.519695uH
K_K30136  L_L274  L_L275  0.1050
K_K30137  L_L274  L_L276  0.0397
* *  Branch  NTMP0000000274 - NTMP0000000275
R_R275  NTMP0000000274  nU_275  32.914993m  TC=0,0
V_Ui275  nU_275  nR_275  STIMULUS=U_IND_0000000275
R_V549  nR_275  nV_549  23.280268m  TC=0,0
L_V549  nR_275  nV_549  0.014646uH
R_V550  nV_549  nV_550  7.852787m  TC=0,0
L_V550  nV_549  nV_550  0.073723uH
L_L275  nV_550  NTMP0000000275  6.519695uH
K_K30138  L_L275  L_L276  0.1050
* *  Branch  NTMP0000000275 - NN15
R_R276  NTMP0000000275  nU_276  32.914993m  TC=0,0
V_Ui276  nU_276  nR_276  STIMULUS=U_IND_0000000276
R_V551  nR_276  nV_551  23.280268m  TC=0,0
L_V551  nR_276  nV_551  0.014646uH
R_V552  nV_551  nV_552  7.852787m  TC=0,0
L_V552  nV_551  nV_552  0.073723uH
L_L276  nV_552  NN15  6.519695uH
* *  Branch  NG01 - NTMP0000000277
R_R277  NG01  nU_277  50.587938m  TC=0,0
V_Ui277  nU_277  nR_277  STIMULUS=U_IND_0000000277
R_V553  nR_277  nV_553  34.327182m  TC=0,0
L_V553  nR_277  nV_553  0.018694uH
R_V554  nV_553  nV_554  11.962040m  TC=0,0
L_V554  nV_553  nV_554  0.078288uH
L_L277  nV_554  NTMP0000000277  3.972761uH
K_K30139  L_L277  L_L278  0.0994
* *  Branch  NTMP0000000277 - NN01
R_R278  NTMP0000000277  nU_278  50.587938m  TC=0,0
V_Ui278  nU_278  nR_278  STIMULUS=U_IND_0000000278
R_V555  nR_278  nV_555  34.327182m  TC=0,0
L_V555  nR_278  nV_555  0.018694uH
R_V556  nV_555  nV_556  11.962040m  TC=0,0
L_V556  nV_555  nV_556  0.078288uH
L_L278  nV_556  NN01  3.972761uH
* *  Branch  NG09 - NTMP0000000279
R_R279  NG09  nU_279  50.587938m  TC=0,0
V_Ui279  nU_279  nR_279  STIMULUS=U_IND_0000000279
R_V557  nR_279  nV_557  34.327182m  TC=0,0
L_V557  nR_279  nV_557  0.018694uH
R_V558  nV_557  nV_558  11.962040m  TC=0,0
L_V558  nV_557  nV_558  0.078288uH
L_L279  nV_558  NTMP0000000279  3.972761uH
K_K30140  L_L279  L_L280  0.0994
* *  Branch  NTMP0000000279 - NN09
R_R280  NTMP0000000279  nU_280  50.587938m  TC=0,0
V_Ui280  nU_280  nR_280  STIMULUS=U_IND_0000000280
R_V559  nR_280  nV_559  34.327182m  TC=0,0
L_V559  nR_280  nV_559  0.018694uH
R_V560  nV_559  nV_560  11.962040m  TC=0,0
L_V560  nV_559  nV_560  0.078288uH
L_L280  nV_560  NN09  3.972761uH
* *  Branch  NG15 - NTMP0000000281
R_R281  NG15  nU_281  50.587938m  TC=0,0
V_Ui281  nU_281  nR_281  STIMULUS=U_IND_0000000281
R_V561  nR_281  nV_561  34.327182m  TC=0,0
L_V561  nR_281  nV_561  0.018694uH
R_V562  nV_561  nV_562  11.962040m  TC=0,0
L_V562  nV_561  nV_562  0.078288uH
L_L281  nV_562  NTMP0000000281  3.972761uH
K_K30141  L_L281  L_L282  0.0994
* *  Branch  NTMP0000000281 - NN15
R_R282  NTMP0000000281  nU_282  50.587938m  TC=0,0
V_Ui282  nU_282  nR_282  STIMULUS=U_IND_0000000282
R_V563  nR_282  nV_563  34.327182m  TC=0,0
L_V563  nR_282  nV_563  0.018694uH
R_V564  nV_563  nV_564  11.962040m  TC=0,0
L_V564  nV_563  nV_564  0.078288uH
L_L282  nV_564  NN15  3.972761uH
.ENDS induced_paper
