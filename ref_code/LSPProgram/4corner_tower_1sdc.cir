.SUBCKT 4corner_tower_1sdc N_S0_UP N_C1_UP N_C2_UP N_S0_OUT N_C1_OUT
+ N_C2_OUT J1 J4 J3 J2
+ N_C0_CONN_TOP N_TOP
**************************************
*   Model Generated by Chen Hongcai  *
*   Hong Kong Polytechic University  *
*         All Rights Reserved        *
*       Email:  hc.chen@live.com     *
**************************************
* Model generated on 30-Jul-2019
* MODEL FORMAT: PSpice
* *  Branch  N_S0_170 - NTMP0000000001
R_R1  N_S0_170  nR_1  129.863277m  TC=0,0
L_L1  nR_1  NTMP0000000001  13.403962uH
K_K1  L_L1  L_L2  0.0674
K_K2  L_L1  L_L3  0.9214
K_K3  L_L1  L_L4  0.0621
K_K4  L_L1  L_L5  0.9214
K_K5  L_L1  L_L6  0.0621
K_K6  L_L1  L_L10  0.0671
K_K7  L_L1  L_L11  0.0680
K_K8  L_L1  L_L12  0.0671
K_K9  L_L1  L_L13  0.0663
K_K10  L_L1  L_L14  -0.1949
K_K11  L_L1  L_L15  -0.2447
K_K12  L_L1  L_L16  -0.2447
K_K13  L_L1  L_L17  -0.1949
K_K14  L_L1  L_L18  -0.3095
K_K15  L_L1  L_L19  -0.1545
K_K16  L_L1  L_L20  -0.2252
K_K17  L_L1  L_L21  -0.1358
K_K18  L_L1  L_L22  -0.1770
K_K19  L_L1  L_L23  -0.1318
K_K20  L_L1  L_L24  -0.1868
K_K21  L_L1  L_L25  -0.1411
K_K22  L_L1  L_L26  -0.2252
K_K23  L_L1  L_L27  -0.1358
K_K24  L_L1  L_L28  -0.3095
K_K25  L_L1  L_L29  -0.1545
K_K26  L_L1  L_L30  -0.1868
K_K27  L_L1  L_L31  -0.1411
K_K28  L_L1  L_L32  -0.1770
K_K29  L_L1  L_L33  -0.1318
K_K30  L_L1  L_L42  -0.2449
K_K31  L_L1  L_L43  -0.3455
K_K32  L_L1  L_L44  -0.3455
K_K33  L_L1  L_L45  -0.2449
K_K34  L_L1  L_L46  -0.3277
K_K35  L_L1  L_L47  -0.3433
K_K36  L_L1  L_L48  -0.2307
K_K37  L_L1  L_L49  -0.2042
K_K38  L_L1  L_L50  -0.1783
K_K39  L_L1  L_L51  -0.1911
K_K40  L_L1  L_L52  -0.1911
K_K41  L_L1  L_L53  -0.2455
K_K42  L_L1  L_L54  -0.2307
K_K43  L_L1  L_L55  -0.2042
K_K44  L_L1  L_L56  -0.3277
K_K45  L_L1  L_L57  -0.3433
K_K46  L_L1  L_L58  -0.1911
K_K47  L_L1  L_L59  -0.2455
K_K48  L_L1  L_L60  -0.1783
K_K49  L_L1  L_L61  -0.1911
K_K50  L_L1  L_L66  -0.1481
K_K51  L_L1  L_L67  -0.1772
K_K52  L_L1  L_L68  -0.1772
K_K53  L_L1  L_L69  -0.1481
K_K54  L_L1  L_L70  0.0424
K_K55  L_L1  L_L71  -0.1861
K_K56  L_L1  L_L72  0.0420
K_K57  L_L1  L_L73  -0.1380
K_K58  L_L1  L_L74  0.0409
K_K59  L_L1  L_L75  -0.1333
K_K60  L_L1  L_L76  0.0413
K_K61  L_L1  L_L77  -0.1649
K_K62  L_L1  L_L78  0.0420
K_K63  L_L1  L_L79  -0.1380
K_K64  L_L1  L_L80  0.0424
K_K65  L_L1  L_L81  -0.1861
K_K66  L_L1  L_L82  0.0413
K_K67  L_L1  L_L83  -0.1649
K_K68  L_L1  L_L84  0.0409
K_K69  L_L1  L_L85  -0.1333
K_K70  L_L1  L_L86  0.0264
K_K71  L_L1  L_L87  0.0268
K_K72  L_L1  L_L88  0.0264
K_K73  L_L1  L_L89  0.0261
K_K74  L_L1  L_L90  -0.0782
K_K75  L_L1  L_L91  -0.0791
K_K76  L_L1  L_L92  -0.0791
K_K77  L_L1  L_L93  -0.0782
K_K78  L_L1  L_L94  0.0195
K_K79  L_L1  L_L95  0.0274
K_K80  L_L1  L_L96  0.0194
K_K81  L_L1  L_L97  0.0269
K_K82  L_L1  L_L98  0.0192
K_K83  L_L1  L_L99  0.0268
K_K84  L_L1  L_L100  0.0193
K_K85  L_L1  L_L101  0.0272
K_K86  L_L1  L_L102  0.0194
K_K87  L_L1  L_L103  0.0269
K_K88  L_L1  L_L104  0.0195
K_K89  L_L1  L_L105  0.0274
K_K90  L_L1  L_L106  0.0193
K_K91  L_L1  L_L107  0.0272
K_K92  L_L1  L_L108  0.0192
K_K93  L_L1  L_L109  0.0268
K_K94  L_L1  L_L110  0.0134
K_K95  L_L1  L_L111  0.0106
K_K96  L_L1  L_L112  0.0106
K_K97  L_L1  L_L113  0.0134
K_K98  L_L1  L_L114  0.0133
K_K99  L_L1  L_L115  0.0118
K_K100  L_L1  L_L116  0.0119
K_K101  L_L1  L_L117  0.0119
K_K102  L_L1  L_L118  0.0118
K_K103  L_L1  L_L119  0.0151
* *  Branch  NTMP0000000001 - N_S0_UP
R_R2  NTMP0000000001  nR_2  129.863277m  TC=0,0
L_L2  nR_2  N_S0_UP  12.570239uH
K_K104  L_L2  L_L3  0.0624
K_K105  L_L2  L_L4  0.9167
K_K106  L_L2  L_L5  0.0624
K_K107  L_L2  L_L6  0.9167
K_K108  L_L2  L_L7  0.0367
K_K109  L_L2  L_L8  0.0335
K_K110  L_L2  L_L9  0.0335
K_K111  L_L2  L_L10  0.0308
K_K112  L_L2  L_L11  0.0309
K_K113  L_L2  L_L12  0.0308
K_K114  L_L2  L_L13  0.0307
K_K115  L_L2  L_L14  0.0106
K_K116  L_L2  L_L15  0.0107
K_K117  L_L2  L_L16  0.0107
K_K118  L_L2  L_L17  0.0106
K_K119  L_L2  L_L18  0.0152
K_K120  L_L2  L_L20  0.0152
K_K121  L_L2  L_L22  0.0150
K_K122  L_L2  L_L24  0.0151
K_K123  L_L2  L_L26  0.0152
K_K124  L_L2  L_L28  0.0152
K_K125  L_L2  L_L30  0.0151
K_K126  L_L2  L_L32  0.0150
K_K127  L_L2  L_L38  0.0334
K_K128  L_L2  L_L39  0.0336
K_K129  L_L2  L_L40  0.0334
K_K130  L_L2  L_L41  0.0333
K_K131  L_L2  L_L42  -0.1046
K_K132  L_L2  L_L43  -0.1083
K_K133  L_L2  L_L44  -0.1083
K_K134  L_L2  L_L45  -0.1046
K_K135  L_L2  L_L46  0.0459
K_K136  L_L2  L_L47  0.0270
K_K137  L_L2  L_L48  0.0455
K_K138  L_L2  L_L49  0.0266
K_K139  L_L2  L_L50  0.0444
K_K140  L_L2  L_L51  0.0264
K_K141  L_L2  L_L52  0.0447
K_K142  L_L2  L_L53  0.0268
K_K143  L_L2  L_L54  0.0455
K_K144  L_L2  L_L55  0.0266
K_K145  L_L2  L_L56  0.0459
K_K146  L_L2  L_L57  0.0270
K_K147  L_L2  L_L58  0.0447
K_K148  L_L2  L_L59  0.0268
K_K149  L_L2  L_L60  0.0444
K_K150  L_L2  L_L61  0.0264
K_K151  L_L2  L_L62  0.0483
K_K152  L_L2  L_L63  0.0494
K_K153  L_L2  L_L64  0.0483
K_K154  L_L2  L_L65  0.0472
K_K155  L_L2  L_L66  -0.1991
K_K156  L_L2  L_L67  -0.2766
K_K157  L_L2  L_L68  -0.2766
K_K158  L_L2  L_L69  -0.1991
K_K159  L_L2  L_L70  -0.3286
K_K160  L_L2  L_L71  -0.2355
K_K161  L_L2  L_L72  -0.2283
K_K162  L_L2  L_L73  -0.1405
K_K163  L_L2  L_L74  -0.1731
K_K164  L_L2  L_L75  -0.1314
K_K165  L_L2  L_L76  -0.1859
K_K166  L_L2  L_L77  -0.1565
K_K167  L_L2  L_L78  -0.2283
K_K168  L_L2  L_L79  -0.1405
K_K169  L_L2  L_L80  -0.3286
K_K170  L_L2  L_L81  -0.2355
K_K171  L_L2  L_L82  -0.1859
K_K172  L_L2  L_L83  -0.1565
K_K173  L_L2  L_L84  -0.1731
K_K174  L_L2  L_L85  -0.1314
K_K175  L_L2  L_L86  -0.0115
K_K176  L_L2  L_L87  -0.0115
K_K177  L_L2  L_L88  -0.0115
K_K178  L_L2  L_L89  -0.0115
K_K179  L_L2  L_L90  -0.2163
K_K180  L_L2  L_L91  -0.3124
K_K181  L_L2  L_L92  -0.3124
K_K182  L_L2  L_L93  -0.2163
K_K183  L_L2  L_L94  -0.2993
K_K184  L_L2  L_L95  -0.3371
K_K185  L_L2  L_L96  -0.2007
K_K186  L_L2  L_L97  -0.1928
K_K187  L_L2  L_L98  -0.1547
K_K188  L_L2  L_L99  -0.1793
K_K189  L_L2  L_L100  -0.1670
K_K190  L_L2  L_L101  -0.2358
K_K191  L_L2  L_L102  -0.2007
K_K192  L_L2  L_L103  -0.1928
K_K193  L_L2  L_L104  -0.2993
K_K194  L_L2  L_L105  -0.3371
K_K195  L_L2  L_L106  -0.1670
K_K196  L_L2  L_L107  -0.2358
K_K197  L_L2  L_L108  -0.1547
K_K198  L_L2  L_L109  -0.1793
K_K199  L_L2  L_L110  0.0688
K_K200  L_L2  L_L111  0.0555
K_K201  L_L2  L_L112  0.0555
K_K202  L_L2  L_L113  0.0688
K_K203  L_L2  L_L114  0.0666
K_K204  L_L2  L_L115  0.0602
K_K205  L_L2  L_L116  0.0622
K_K206  L_L2  L_L117  0.0622
K_K207  L_L2  L_L118  0.0602
K_K208  L_L2  L_L119  -0.1180
* *  Branch  N_C1_170 - NTMP0000000003
R_R3  N_C1_170  nR_3  606.851502m  TC=0,0
R_V1  nR_3  nV_1  412.388623m  TC=0,0
L_V1  nR_3  nV_1  0.056868uH
R_V2  nV_1  nV_2  144.646087m  TC=0,0
L_V2  nV_1  nV_2  0.243855uH
L_L3  nV_2  NTMP0000000003  15.633840uH
K_K209  L_L3  L_L4  0.0576
K_K210  L_L3  L_L5  0.8695
K_K211  L_L3  L_L6  0.0575
K_K212  L_L3  L_L10  0.0621
K_K213  L_L3  L_L11  0.0629
K_K214  L_L3  L_L12  0.0621
K_K215  L_L3  L_L13  0.0614
K_K216  L_L3  L_L14  -0.1805
K_K217  L_L3  L_L15  -0.2264
K_K218  L_L3  L_L16  -0.2267
K_K219  L_L3  L_L17  -0.1805
K_K220  L_L3  L_L18  -0.2860
K_K221  L_L3  L_L19  -0.1431
K_K222  L_L3  L_L20  -0.2087
K_K223  L_L3  L_L21  -0.1258
K_K224  L_L3  L_L22  -0.1639
K_K225  L_L3  L_L23  -0.1220
K_K226  L_L3  L_L24  -0.1729
K_K227  L_L3  L_L25  -0.1306
K_K228  L_L3  L_L26  -0.2084
K_K229  L_L3  L_L27  -0.1257
K_K230  L_L3  L_L28  -0.2871
K_K231  L_L3  L_L29  -0.1431
K_K232  L_L3  L_L30  -0.1730
K_K233  L_L3  L_L31  -0.1307
K_K234  L_L3  L_L32  -0.1639
K_K235  L_L3  L_L33  -0.1220
K_K236  L_L3  L_L42  -0.2267
K_K237  L_L3  L_L43  -0.3196
K_K238  L_L3  L_L44  -0.3202
K_K239  L_L3  L_L45  -0.2268
K_K240  L_L3  L_L46  -0.3029
K_K241  L_L3  L_L47  -0.3184
K_K242  L_L3  L_L48  -0.2138
K_K243  L_L3  L_L49  -0.1891
K_K244  L_L3  L_L50  -0.1651
K_K245  L_L3  L_L51  -0.1769
K_K246  L_L3  L_L52  -0.1769
K_K247  L_L3  L_L53  -0.2272
K_K248  L_L3  L_L54  -0.2134
K_K249  L_L3  L_L55  -0.1890
K_K250  L_L3  L_L56  -0.3041
K_K251  L_L3  L_L57  -0.3173
K_K252  L_L3  L_L58  -0.1770
K_K253  L_L3  L_L59  -0.2275
K_K254  L_L3  L_L60  -0.1651
K_K255  L_L3  L_L61  -0.1769
K_K256  L_L3  L_L66  -0.1371
K_K257  L_L3  L_L67  -0.1640
K_K258  L_L3  L_L68  -0.1641
K_K259  L_L3  L_L69  -0.1371
K_K260  L_L3  L_L70  0.0392
K_K261  L_L3  L_L71  -0.1725
K_K262  L_L3  L_L72  0.0389
K_K263  L_L3  L_L73  -0.1278
K_K264  L_L3  L_L74  0.0379
K_K265  L_L3  L_L75  -0.1234
K_K266  L_L3  L_L76  0.0382
K_K267  L_L3  L_L77  -0.1526
K_K268  L_L3  L_L78  0.0389
K_K269  L_L3  L_L79  -0.1278
K_K270  L_L3  L_L80  0.0392
K_K271  L_L3  L_L81  -0.1722
K_K272  L_L3  L_L82  0.0382
K_K273  L_L3  L_L83  -0.1528
K_K274  L_L3  L_L84  0.0379
K_K275  L_L3  L_L85  -0.1234
K_K276  L_L3  L_L86  0.0245
K_K277  L_L3  L_L87  0.0248
K_K278  L_L3  L_L88  0.0245
K_K279  L_L3  L_L89  0.0241
K_K280  L_L3  L_L90  -0.0724
K_K281  L_L3  L_L91  -0.0733
K_K282  L_L3  L_L92  -0.0733
K_K283  L_L3  L_L93  -0.0724
K_K284  L_L3  L_L94  0.0181
K_K285  L_L3  L_L95  0.0253
K_K286  L_L3  L_L96  0.0180
K_K287  L_L3  L_L97  0.0249
K_K288  L_L3  L_L98  0.0178
K_K289  L_L3  L_L99  0.0248
K_K290  L_L3  L_L100  0.0179
K_K291  L_L3  L_L101  0.0252
K_K292  L_L3  L_L102  0.0180
K_K293  L_L3  L_L103  0.0249
K_K294  L_L3  L_L104  0.0181
K_K295  L_L3  L_L105  0.0253
K_K296  L_L3  L_L106  0.0179
K_K297  L_L3  L_L107  0.0252
K_K298  L_L3  L_L108  0.0178
K_K299  L_L3  L_L109  0.0248
K_K300  L_L3  L_L110  0.0124
K_K301  L_L3  L_L113  0.0124
K_K302  L_L3  L_L114  0.0124
K_K303  L_L3  L_L115  0.0109
K_K304  L_L3  L_L116  0.0110
K_K305  L_L3  L_L117  0.0110
K_K306  L_L3  L_L118  0.0109
K_K307  L_L3  L_L119  0.0140
* *  Branch  NTMP0000000003 - N_C1_UP
R_R4  NTMP0000000003  nR_4  606.851502m  TC=0,0
R_V3  nR_4  nV_3  412.388623m  TC=0,0
L_V3  nR_4  nV_3  0.056868uH
R_V4  nV_3  nV_4  144.646087m  TC=0,0
L_V4  nV_3  nV_4  0.243855uH
L_L4  nV_4  N_C1_UP  14.800116uH
K_K308  L_L4  L_L5  0.0575
K_K309  L_L4  L_L6  0.8622
K_K310  L_L4  L_L7  0.0339
K_K311  L_L4  L_L8  0.0309
K_K312  L_L4  L_L9  0.0309
K_K313  L_L4  L_L10  0.0284
K_K314  L_L4  L_L11  0.0284
K_K315  L_L4  L_L12  0.0284
K_K316  L_L4  L_L13  0.0283
K_K317  L_L4  L_L18  0.0141
K_K318  L_L4  L_L20  0.0140
K_K319  L_L4  L_L22  0.0138
K_K320  L_L4  L_L24  0.0139
K_K321  L_L4  L_L26  0.0140
K_K322  L_L4  L_L28  0.0141
K_K323  L_L4  L_L30  0.0139
K_K324  L_L4  L_L32  0.0138
K_K325  L_L4  L_L38  0.0308
K_K326  L_L4  L_L39  0.0310
K_K327  L_L4  L_L40  0.0308
K_K328  L_L4  L_L41  0.0307
K_K329  L_L4  L_L42  -0.0964
K_K330  L_L4  L_L43  -0.0998
K_K331  L_L4  L_L44  -0.0998
K_K332  L_L4  L_L45  -0.0964
K_K333  L_L4  L_L46  0.0423
K_K334  L_L4  L_L47  0.0249
K_K335  L_L4  L_L48  0.0419
K_K336  L_L4  L_L49  0.0245
K_K337  L_L4  L_L50  0.0409
K_K338  L_L4  L_L51  0.0243
K_K339  L_L4  L_L52  0.0412
K_K340  L_L4  L_L53  0.0247
K_K341  L_L4  L_L54  0.0419
K_K342  L_L4  L_L55  0.0245
K_K343  L_L4  L_L56  0.0423
K_K344  L_L4  L_L57  0.0249
K_K345  L_L4  L_L58  0.0412
K_K346  L_L4  L_L59  0.0247
K_K347  L_L4  L_L60  0.0409
K_K348  L_L4  L_L61  0.0243
K_K349  L_L4  L_L62  0.0445
K_K350  L_L4  L_L63  0.0455
K_K351  L_L4  L_L64  0.0445
K_K352  L_L4  L_L65  0.0435
K_K353  L_L4  L_L66  -0.1834
K_K354  L_L4  L_L67  -0.2547
K_K355  L_L4  L_L68  -0.2552
K_K356  L_L4  L_L69  -0.1835
K_K357  L_L4  L_L70  -0.3023
K_K358  L_L4  L_L71  -0.2175
K_K359  L_L4  L_L72  -0.2106
K_K360  L_L4  L_L73  -0.1295
K_K361  L_L4  L_L74  -0.1596
K_K362  L_L4  L_L75  -0.1211
K_K363  L_L4  L_L76  -0.1713
K_K364  L_L4  L_L77  -0.1441
K_K365  L_L4  L_L78  -0.2103
K_K366  L_L4  L_L79  -0.1294
K_K367  L_L4  L_L80  -0.3035
K_K368  L_L4  L_L81  -0.2166
K_K369  L_L4  L_L82  -0.1714
K_K370  L_L4  L_L83  -0.1443
K_K371  L_L4  L_L84  -0.1595
K_K372  L_L4  L_L85  -0.1211
K_K373  L_L4  L_L86  -0.0106
K_K374  L_L4  L_L87  -0.0106
K_K375  L_L4  L_L88  -0.0106
K_K376  L_L4  L_L89  -0.0106
K_K377  L_L4  L_L90  -0.1993
K_K378  L_L4  L_L91  -0.2876
K_K379  L_L4  L_L92  -0.2882
K_K380  L_L4  L_L93  -0.1994
K_K381  L_L4  L_L94  -0.2752
K_K382  L_L4  L_L95  -0.3113
K_K383  L_L4  L_L96  -0.1851
K_K384  L_L4  L_L97  -0.1777
K_K385  L_L4  L_L98  -0.1426
K_K386  L_L4  L_L99  -0.1652
K_K387  L_L4  L_L100  -0.1538
K_K388  L_L4  L_L101  -0.2171
K_K389  L_L4  L_L102  -0.1849
K_K390  L_L4  L_L103  -0.1776
K_K391  L_L4  L_L104  -0.2764
K_K392  L_L4  L_L105  -0.3100
K_K393  L_L4  L_L106  -0.1539
K_K394  L_L4  L_L107  -0.2174
K_K395  L_L4  L_L108  -0.1425
K_K396  L_L4  L_L109  -0.1653
K_K397  L_L4  L_L110  0.0634
K_K398  L_L4  L_L111  0.0511
K_K399  L_L4  L_L112  0.0511
K_K400  L_L4  L_L113  0.0634
K_K401  L_L4  L_L114  0.0613
K_K402  L_L4  L_L115  0.0554
K_K403  L_L4  L_L116  0.0574
K_K404  L_L4  L_L117  0.0574
K_K405  L_L4  L_L118  0.0554
K_K406  L_L4  L_L119  -0.1088
* *  Branch  N_C2_170 - NTMP0000000005
R_R5  N_C2_170  nR_5  606.851502m  TC=0,0
R_V5  nR_5  nV_5  412.388623m  TC=0,0
L_V5  nR_5  nV_5  0.056868uH
R_V6  nV_5  nV_6  144.646087m  TC=0,0
L_V6  nV_5  nV_6  0.243855uH
L_L5  nV_6  NTMP0000000005  15.633840uH
K_K407  L_L5  L_L6  0.0576
K_K408  L_L5  L_L10  0.0621
K_K409  L_L5  L_L11  0.0629
K_K410  L_L5  L_L12  0.0621
K_K411  L_L5  L_L13  0.0614
K_K412  L_L5  L_L14  -0.1805
K_K413  L_L5  L_L15  -0.2267
K_K414  L_L5  L_L16  -0.2264
K_K415  L_L5  L_L17  -0.1805
K_K416  L_L5  L_L18  -0.2871
K_K417  L_L5  L_L19  -0.1431
K_K418  L_L5  L_L20  -0.2084
K_K419  L_L5  L_L21  -0.1257
K_K420  L_L5  L_L22  -0.1639
K_K421  L_L5  L_L23  -0.1220
K_K422  L_L5  L_L24  -0.1730
K_K423  L_L5  L_L25  -0.1307
K_K424  L_L5  L_L26  -0.2087
K_K425  L_L5  L_L27  -0.1258
K_K426  L_L5  L_L28  -0.2860
K_K427  L_L5  L_L29  -0.1431
K_K428  L_L5  L_L30  -0.1729
K_K429  L_L5  L_L31  -0.1306
K_K430  L_L5  L_L32  -0.1639
K_K431  L_L5  L_L33  -0.1220
K_K432  L_L5  L_L42  -0.2268
K_K433  L_L5  L_L43  -0.3202
K_K434  L_L5  L_L44  -0.3196
K_K435  L_L5  L_L45  -0.2267
K_K436  L_L5  L_L46  -0.3041
K_K437  L_L5  L_L47  -0.3173
K_K438  L_L5  L_L48  -0.2134
K_K439  L_L5  L_L49  -0.1890
K_K440  L_L5  L_L50  -0.1651
K_K441  L_L5  L_L51  -0.1769
K_K442  L_L5  L_L52  -0.1770
K_K443  L_L5  L_L53  -0.2275
K_K444  L_L5  L_L54  -0.2138
K_K445  L_L5  L_L55  -0.1891
K_K446  L_L5  L_L56  -0.3029
K_K447  L_L5  L_L57  -0.3184
K_K448  L_L5  L_L58  -0.1769
K_K449  L_L5  L_L59  -0.2272
K_K450  L_L5  L_L60  -0.1651
K_K451  L_L5  L_L61  -0.1769
K_K452  L_L5  L_L66  -0.1371
K_K453  L_L5  L_L67  -0.1641
K_K454  L_L5  L_L68  -0.1640
K_K455  L_L5  L_L69  -0.1371
K_K456  L_L5  L_L70  0.0392
K_K457  L_L5  L_L71  -0.1722
K_K458  L_L5  L_L72  0.0389
K_K459  L_L5  L_L73  -0.1278
K_K460  L_L5  L_L74  0.0379
K_K461  L_L5  L_L75  -0.1234
K_K462  L_L5  L_L76  0.0382
K_K463  L_L5  L_L77  -0.1528
K_K464  L_L5  L_L78  0.0389
K_K465  L_L5  L_L79  -0.1278
K_K466  L_L5  L_L80  0.0392
K_K467  L_L5  L_L81  -0.1725
K_K468  L_L5  L_L82  0.0382
K_K469  L_L5  L_L83  -0.1526
K_K470  L_L5  L_L84  0.0379
K_K471  L_L5  L_L85  -0.1234
K_K472  L_L5  L_L86  0.0245
K_K473  L_L5  L_L87  0.0248
K_K474  L_L5  L_L88  0.0245
K_K475  L_L5  L_L89  0.0241
K_K476  L_L5  L_L90  -0.0724
K_K477  L_L5  L_L91  -0.0733
K_K478  L_L5  L_L92  -0.0733
K_K479  L_L5  L_L93  -0.0724
K_K480  L_L5  L_L94  0.0181
K_K481  L_L5  L_L95  0.0253
K_K482  L_L5  L_L96  0.0180
K_K483  L_L5  L_L97  0.0249
K_K484  L_L5  L_L98  0.0178
K_K485  L_L5  L_L99  0.0248
K_K486  L_L5  L_L100  0.0179
K_K487  L_L5  L_L101  0.0252
K_K488  L_L5  L_L102  0.0180
K_K489  L_L5  L_L103  0.0249
K_K490  L_L5  L_L104  0.0181
K_K491  L_L5  L_L105  0.0253
K_K492  L_L5  L_L106  0.0179
K_K493  L_L5  L_L107  0.0252
K_K494  L_L5  L_L108  0.0178
K_K495  L_L5  L_L109  0.0248
K_K496  L_L5  L_L110  0.0124
K_K497  L_L5  L_L113  0.0124
K_K498  L_L5  L_L114  0.0124
K_K499  L_L5  L_L115  0.0109
K_K500  L_L5  L_L116  0.0110
K_K501  L_L5  L_L117  0.0110
K_K502  L_L5  L_L118  0.0109
K_K503  L_L5  L_L119  0.0140
* *  Branch  NTMP0000000005 - N_C2_UP
R_R6  NTMP0000000005  nR_6  606.851502m  TC=0,0
R_V7  nR_6  nV_7  412.388623m  TC=0,0
L_V7  nR_6  nV_7  0.056868uH
R_V8  nV_7  nV_8  144.646087m  TC=0,0
L_V8  nV_7  nV_8  0.243855uH
L_L6  nV_8  N_C2_UP  14.800116uH
K_K504  L_L6  L_L7  0.0339
K_K505  L_L6  L_L8  0.0309
K_K506  L_L6  L_L9  0.0309
K_K507  L_L6  L_L10  0.0284
K_K508  L_L6  L_L11  0.0284
K_K509  L_L6  L_L12  0.0284
K_K510  L_L6  L_L13  0.0283
K_K511  L_L6  L_L18  0.0141
K_K512  L_L6  L_L20  0.0140
K_K513  L_L6  L_L22  0.0138
K_K514  L_L6  L_L24  0.0139
K_K515  L_L6  L_L26  0.0140
K_K516  L_L6  L_L28  0.0141
K_K517  L_L6  L_L30  0.0139
K_K518  L_L6  L_L32  0.0138
K_K519  L_L6  L_L38  0.0308
K_K520  L_L6  L_L39  0.0310
K_K521  L_L6  L_L40  0.0308
K_K522  L_L6  L_L41  0.0307
K_K523  L_L6  L_L42  -0.0964
K_K524  L_L6  L_L43  -0.0998
K_K525  L_L6  L_L44  -0.0998
K_K526  L_L6  L_L45  -0.0964
K_K527  L_L6  L_L46  0.0423
K_K528  L_L6  L_L47  0.0249
K_K529  L_L6  L_L48  0.0419
K_K530  L_L6  L_L49  0.0245
K_K531  L_L6  L_L50  0.0409
K_K532  L_L6  L_L51  0.0243
K_K533  L_L6  L_L52  0.0412
K_K534  L_L6  L_L53  0.0247
K_K535  L_L6  L_L54  0.0419
K_K536  L_L6  L_L55  0.0245
K_K537  L_L6  L_L56  0.0423
K_K538  L_L6  L_L57  0.0249
K_K539  L_L6  L_L58  0.0412
K_K540  L_L6  L_L59  0.0247
K_K541  L_L6  L_L60  0.0409
K_K542  L_L6  L_L61  0.0243
K_K543  L_L6  L_L62  0.0445
K_K544  L_L6  L_L63  0.0455
K_K545  L_L6  L_L64  0.0445
K_K546  L_L6  L_L65  0.0435
K_K547  L_L6  L_L66  -0.1835
K_K548  L_L6  L_L67  -0.2552
K_K549  L_L6  L_L68  -0.2547
K_K550  L_L6  L_L69  -0.1834
K_K551  L_L6  L_L70  -0.3035
K_K552  L_L6  L_L71  -0.2166
K_K553  L_L6  L_L72  -0.2103
K_K554  L_L6  L_L73  -0.1294
K_K555  L_L6  L_L74  -0.1595
K_K556  L_L6  L_L75  -0.1211
K_K557  L_L6  L_L76  -0.1714
K_K558  L_L6  L_L77  -0.1443
K_K559  L_L6  L_L78  -0.2106
K_K560  L_L6  L_L79  -0.1295
K_K561  L_L6  L_L80  -0.3023
K_K562  L_L6  L_L81  -0.2175
K_K563  L_L6  L_L82  -0.1713
K_K564  L_L6  L_L83  -0.1441
K_K565  L_L6  L_L84  -0.1596
K_K566  L_L6  L_L85  -0.1211
K_K567  L_L6  L_L86  -0.0106
K_K568  L_L6  L_L87  -0.0106
K_K569  L_L6  L_L88  -0.0106
K_K570  L_L6  L_L89  -0.0106
K_K571  L_L6  L_L90  -0.1994
K_K572  L_L6  L_L91  -0.2882
K_K573  L_L6  L_L92  -0.2876
K_K574  L_L6  L_L93  -0.1993
K_K575  L_L6  L_L94  -0.2764
K_K576  L_L6  L_L95  -0.3100
K_K577  L_L6  L_L96  -0.1849
K_K578  L_L6  L_L97  -0.1776
K_K579  L_L6  L_L98  -0.1425
K_K580  L_L6  L_L99  -0.1653
K_K581  L_L6  L_L100  -0.1539
K_K582  L_L6  L_L101  -0.2174
K_K583  L_L6  L_L102  -0.1851
K_K584  L_L6  L_L103  -0.1777
K_K585  L_L6  L_L104  -0.2752
K_K586  L_L6  L_L105  -0.3113
K_K587  L_L6  L_L106  -0.1538
K_K588  L_L6  L_L107  -0.2171
K_K589  L_L6  L_L108  -0.1426
K_K590  L_L6  L_L109  -0.1652
K_K591  L_L6  L_L110  0.0634
K_K592  L_L6  L_L111  0.0511
K_K593  L_L6  L_L112  0.0511
K_K594  L_L6  L_L113  0.0634
K_K595  L_L6  L_L114  0.0613
K_K596  L_L6  L_L115  0.0554
K_K597  L_L6  L_L116  0.0574
K_K598  L_L6  L_L117  0.0574
K_K599  L_L6  L_L118  0.0554
K_K600  L_L6  L_L119  -0.1088
* *  Branch  N_S0_170 - N_S0_OUT
R_R7  N_S0_170  nR_7  74.250015m  TC=0,0
L_L7  nR_7  N_S0_OUT  6.317846uH
K_K601  L_L7  L_L8  0.9067
K_K602  L_L7  L_L9  0.9067
K_K603  L_L7  L_L12  0.1846
K_K604  L_L7  L_L13  0.0817
K_K605  L_L7  L_L20  -0.0207
K_K606  L_L7  L_L24  0.0156
K_K607  L_L7  L_L25  0.0132
K_K608  L_L7  L_L26  -0.0207
K_K609  L_L7  L_L30  0.0156
K_K610  L_L7  L_L31  0.0132
K_K611  L_L7  L_L34  0.0393
K_K612  L_L7  L_L35  0.0297
K_K613  L_L7  L_L36  0.0297
K_K614  L_L7  L_L37  0.0393
K_K615  L_L7  L_L38  0.0347
K_K616  L_L7  L_L40  0.1025
K_K617  L_L7  L_L41  0.0606
K_K618  L_L7  L_L46  0.0524
K_K619  L_L7  L_L48  0.0596
K_K620  L_L7  L_L50  0.0475
K_K621  L_L7  L_L52  0.0402
K_K622  L_L7  L_L53  0.0109
K_K623  L_L7  L_L54  0.0596
K_K624  L_L7  L_L56  0.0524
K_K625  L_L7  L_L58  0.0402
K_K626  L_L7  L_L59  0.0109
K_K627  L_L7  L_L60  0.0475
K_K628  L_L7  L_L62  0.0131
K_K629  L_L7  L_L63  0.0141
K_K630  L_L7  L_L64  0.0131
K_K631  L_L7  L_L65  0.0122
K_K632  L_L7  L_L66  -0.0293
K_K633  L_L7  L_L67  -0.0299
K_K634  L_L7  L_L68  -0.0299
K_K635  L_L7  L_L69  -0.0293
K_K636  L_L7  L_L71  0.0139
K_K637  L_L7  L_L73  0.0127
K_K638  L_L7  L_L75  0.0124
K_K639  L_L7  L_L77  0.0135
K_K640  L_L7  L_L79  0.0127
K_K641  L_L7  L_L81  0.0139
K_K642  L_L7  L_L83  0.0135
K_K643  L_L7  L_L85  0.0124
* *  Branch  N_C1_170 - N_C1_OUT
R_R8  N_C1_170  nR_8  346.970556m  TC=0,0
R_V9  nR_8  nV_9  235.785376m  TC=0,0
L_V9  nR_8  nV_9  0.032514uH
R_V10  nV_9  nV_10  82.702165m  TC=0,0
L_V10  nV_9  nV_10  0.139425uH
L_L8  nV_10  N_C1_OUT  7.592517uH
K_K644  L_L8  L_L9  0.8464
K_K645  L_L8  L_L12  0.1684
K_K646  L_L8  L_L13  0.0745
K_K647  L_L8  L_L20  -0.0189
K_K648  L_L8  L_L24  0.0143
K_K649  L_L8  L_L25  0.0120
K_K650  L_L8  L_L26  -0.0188
K_K651  L_L8  L_L30  0.0143
K_K652  L_L8  L_L31  0.0120
K_K653  L_L8  L_L34  0.0358
K_K654  L_L8  L_L35  0.0271
K_K655  L_L8  L_L36  0.0271
K_K656  L_L8  L_L37  0.0358
K_K657  L_L8  L_L38  0.0316
K_K658  L_L8  L_L40  0.0935
K_K659  L_L8  L_L41  0.0553
K_K660  L_L8  L_L46  0.0478
K_K661  L_L8  L_L48  0.0544
K_K662  L_L8  L_L50  0.0434
K_K663  L_L8  L_L52  0.0367
K_K664  L_L8  L_L54  0.0544
K_K665  L_L8  L_L56  0.0478
K_K666  L_L8  L_L58  0.0367
K_K667  L_L8  L_L60  0.0434
K_K668  L_L8  L_L62  0.0119
K_K669  L_L8  L_L63  0.0129
K_K670  L_L8  L_L64  0.0119
K_K671  L_L8  L_L65  0.0111
K_K672  L_L8  L_L66  -0.0268
K_K673  L_L8  L_L67  -0.0273
K_K674  L_L8  L_L68  -0.0273
K_K675  L_L8  L_L69  -0.0268
K_K676  L_L8  L_L71  0.0127
K_K677  L_L8  L_L73  0.0116
K_K678  L_L8  L_L75  0.0113
K_K679  L_L8  L_L77  0.0123
K_K680  L_L8  L_L79  0.0116
K_K681  L_L8  L_L81  0.0127
K_K682  L_L8  L_L83  0.0123
K_K683  L_L8  L_L85  0.0113
* *  Branch  N_C2_170 - N_C2_OUT
R_R9  N_C2_170  nR_9  346.970556m  TC=0,0
R_V11  nR_9  nV_11  235.785376m  TC=0,0
L_V11  nR_9  nV_11  0.032514uH
R_V12  nV_11  nV_12  82.702165m  TC=0,0
L_V12  nV_11  nV_12  0.139425uH
L_L9  nV_12  N_C2_OUT  7.592517uH
K_K684  L_L9  L_L12  0.1684
K_K685  L_L9  L_L13  0.0745
K_K686  L_L9  L_L20  -0.0188
K_K687  L_L9  L_L24  0.0143
K_K688  L_L9  L_L25  0.0120
K_K689  L_L9  L_L26  -0.0189
K_K690  L_L9  L_L30  0.0143
K_K691  L_L9  L_L31  0.0120
K_K692  L_L9  L_L34  0.0358
K_K693  L_L9  L_L35  0.0271
K_K694  L_L9  L_L36  0.0271
K_K695  L_L9  L_L37  0.0358
K_K696  L_L9  L_L38  0.0316
K_K697  L_L9  L_L40  0.0935
K_K698  L_L9  L_L41  0.0553
K_K699  L_L9  L_L46  0.0478
K_K700  L_L9  L_L48  0.0544
K_K701  L_L9  L_L50  0.0434
K_K702  L_L9  L_L52  0.0367
K_K703  L_L9  L_L54  0.0544
K_K704  L_L9  L_L56  0.0478
K_K705  L_L9  L_L58  0.0367
K_K706  L_L9  L_L60  0.0434
K_K707  L_L9  L_L62  0.0119
K_K708  L_L9  L_L63  0.0129
K_K709  L_L9  L_L64  0.0119
K_K710  L_L9  L_L65  0.0111
K_K711  L_L9  L_L66  -0.0268
K_K712  L_L9  L_L67  -0.0273
K_K713  L_L9  L_L68  -0.0273
K_K714  L_L9  L_L69  -0.0268
K_K715  L_L9  L_L71  0.0127
K_K716  L_L9  L_L73  0.0116
K_K717  L_L9  L_L75  0.0113
K_K718  L_L9  L_L77  0.0123
K_K719  L_L9  L_L79  0.0116
K_K720  L_L9  L_L81  0.0127
K_K721  L_L9  L_L83  0.0123
K_K722  L_L9  L_L85  0.0113
* *  Branch  N_C0_1 - N_C0_2
R_R10  N_C0_1  nR_10  0.541340m  TC=0,0
L_L10  nR_10  N_C0_2  0.590310uH
K_K723  L_L10  L_L18  -0.0867
K_K724  L_L10  L_L20  -0.1080
K_K725  L_L10  L_L22  -0.0838
K_K726  L_L10  L_L24  -0.0603
K_K727  L_L10  L_L25  0.0217
K_K728  L_L10  L_L26  -0.1160
K_K729  L_L10  L_L27  -0.0217
K_K730  L_L10  L_L28  -0.0838
K_K731  L_L10  L_L30  -0.0570
K_K732  L_L10  L_L32  -0.0867
K_K733  L_L10  L_L34  0.1873
K_K734  L_L10  L_L35  0.1873
K_K735  L_L10  L_L36  0.0838
K_K736  L_L10  L_L37  0.0838
K_K737  L_L10  L_L42  -0.0589
K_K738  L_L10  L_L43  -0.0589
K_K739  L_L10  L_L44  -0.0578
K_K740  L_L10  L_L45  -0.0578
K_K741  L_L10  L_L47  -0.0528
K_K742  L_L10  L_L49  -0.0682
K_K743  L_L10  L_L51  -0.0535
K_K744  L_L10  L_L53  -0.0376
K_K745  L_L10  L_L55  -0.0700
K_K746  L_L10  L_L57  -0.0535
K_K747  L_L10  L_L59  -0.0367
K_K748  L_L10  L_L61  -0.0528
* *  Branch  N_C0_2 - N_C0_3
R_R11  N_C0_2  nR_11  0.541340m  TC=0,0
L_L11  nR_11  N_C0_3  0.590310uH
K_K749  L_L11  L_L18  -0.0603
K_K750  L_L11  L_L19  0.0217
K_K751  L_L11  L_L20  -0.0867
K_K752  L_L11  L_L22  -0.1080
K_K753  L_L11  L_L24  -0.0838
K_K754  L_L11  L_L26  -0.0867
K_K755  L_L11  L_L28  -0.1160
K_K756  L_L11  L_L29  -0.0217
K_K757  L_L11  L_L30  -0.0838
K_K758  L_L11  L_L32  -0.0570
K_K759  L_L11  L_L34  0.1873
K_K760  L_L11  L_L35  0.0838
K_K761  L_L11  L_L36  0.0838
K_K762  L_L11  L_L37  0.1873
K_K763  L_L11  L_L42  -0.0578
K_K764  L_L11  L_L43  -0.0589
K_K765  L_L11  L_L44  -0.0589
K_K766  L_L11  L_L45  -0.0578
K_K767  L_L11  L_L47  -0.0376
K_K768  L_L11  L_L49  -0.0528
K_K769  L_L11  L_L51  -0.0682
K_K770  L_L11  L_L53  -0.0535
K_K771  L_L11  L_L55  -0.0528
K_K772  L_L11  L_L57  -0.0700
K_K773  L_L11  L_L59  -0.0535
K_K774  L_L11  L_L61  -0.0367
* *  Branch  N_C0_3 - N_C0_4
R_R12  N_C0_3  nR_12  0.541340m  TC=0,0
L_L12  nR_12  N_C0_4  0.590310uH
K_K775  L_L12  L_L18  -0.0838
K_K776  L_L12  L_L20  -0.0603
K_K777  L_L12  L_L21  0.0217
K_K778  L_L12  L_L22  -0.0867
K_K779  L_L12  L_L24  -0.1080
K_K780  L_L12  L_L26  -0.0570
K_K781  L_L12  L_L28  -0.0867
K_K782  L_L12  L_L30  -0.1160
K_K783  L_L12  L_L31  -0.0217
K_K784  L_L12  L_L32  -0.0838
K_K785  L_L12  L_L34  0.0838
K_K786  L_L12  L_L35  0.0838
K_K787  L_L12  L_L36  0.1873
K_K788  L_L12  L_L37  0.1873
K_K789  L_L12  L_L42  -0.0578
K_K790  L_L12  L_L43  -0.0578
K_K791  L_L12  L_L44  -0.0589
K_K792  L_L12  L_L45  -0.0589
K_K793  L_L12  L_L47  -0.0535
K_K794  L_L12  L_L49  -0.0376
K_K795  L_L12  L_L51  -0.0528
K_K796  L_L12  L_L53  -0.0682
K_K797  L_L12  L_L55  -0.0367
K_K798  L_L12  L_L57  -0.0528
K_K799  L_L12  L_L59  -0.0700
K_K800  L_L12  L_L61  -0.0535
* *  Branch  N_C0_4 - N_C0_1
R_R13  N_C0_4  nR_13  0.541340m  TC=0,0
L_L13  nR_13  N_C0_1  0.590310uH
K_K801  L_L13  L_L18  -0.1080
K_K802  L_L13  L_L20  -0.0838
K_K803  L_L13  L_L22  -0.0603
K_K804  L_L13  L_L23  0.0217
K_K805  L_L13  L_L24  -0.0867
K_K806  L_L13  L_L26  -0.0838
K_K807  L_L13  L_L28  -0.0570
K_K808  L_L13  L_L30  -0.0867
K_K809  L_L13  L_L32  -0.1160
K_K810  L_L13  L_L33  -0.0217
K_K811  L_L13  L_L34  0.0838
K_K812  L_L13  L_L35  0.1873
K_K813  L_L13  L_L36  0.1873
K_K814  L_L13  L_L37  0.0838
K_K815  L_L13  L_L42  -0.0589
K_K816  L_L13  L_L43  -0.0578
K_K817  L_L13  L_L44  -0.0578
K_K818  L_L13  L_L45  -0.0589
K_K819  L_L13  L_L47  -0.0682
K_K820  L_L13  L_L49  -0.0535
K_K821  L_L13  L_L51  -0.0376
K_K822  L_L13  L_L53  -0.0528
K_K823  L_L13  L_L55  -0.0535
K_K824  L_L13  L_L57  -0.0367
K_K825  L_L13  L_L59  -0.0528
K_K826  L_L13  L_L61  -0.0700
* *  Branch  N_C0_5 - N_C0_1
R_R14  N_C0_5  nR_14  187.036335m  TC=0,0
R_V13  nR_14  nV_13  3.613632m  TC=0,0
L_V13  nR_14  nV_13  0.172542uH
R_V14  nV_13  nV_14  1.662059m  TC=0,0
L_V14  nV_13  nV_14  0.025488uH
R_V15  nV_14  nV_15  9.979026m  TC=0,0
L_V15  nV_14  nV_15  0.047373uH
R_V16  nV_15  nV_16  -61.869945m  TC=0,0
L_V16  nV_15  nV_16  -0.049053uH
R_V17  nV_16  nV_17  91.638090m  TC=0,0
L_V17  nV_16  nV_17  0.054944uH
R_V18  nV_17  nV_18  -2459.675348m  TC=0,0
L_V18  nV_17  nV_18  -0.243622uH
R_V19  nV_18  nV_19  2594.462084m  TC=0,0
L_V19  nV_18  nV_19  0.247849uH
R_VC20  nV_19  nVC_20  0.363625m  TC=0,0
C_V20  nVC_20  nV_20  20826.631975uF
R_V20  nV_19  nV_20  -0.397631m  TC=0,0
L_V20  nV_19  nV_20  0.002421uH
L_L14  nV_20  N_C0_1  5.319405uH
K_K827  L_L14  L_L15  0.3188
K_K828  L_L14  L_L16  0.2658
K_K829  L_L14  L_L17  0.3188
K_K830  L_L14  L_L18  0.2299
K_K831  L_L14  L_L19  0.2285
K_K832  L_L14  L_L20  0.2108
K_K833  L_L14  L_L21  0.2517
K_K834  L_L14  L_L22  0.2751
K_K835  L_L14  L_L23  0.4761
K_K836  L_L14  L_L24  0.4506
K_K837  L_L14  L_L25  0.2969
K_K838  L_L14  L_L26  0.2751
K_K839  L_L14  L_L27  0.4761
K_K840  L_L14  L_L28  0.2108
K_K841  L_L14  L_L29  0.2517
K_K842  L_L14  L_L30  0.2299
K_K843  L_L14  L_L31  0.2285
K_K844  L_L14  L_L32  0.4506
K_K845  L_L14  L_L33  0.2969
K_K846  L_L14  L_L34  0.1096
K_K847  L_L14  L_L35  0.1588
K_K848  L_L14  L_L36  0.1096
K_K849  L_L14  L_L37  0.0949
K_K850  L_L14  L_L42  0.1914
K_K851  L_L14  L_L43  0.1643
K_K852  L_L14  L_L44  0.1543
K_K853  L_L14  L_L45  0.1643
K_K854  L_L14  L_L46  0.0933
K_K855  L_L14  L_L47  0.1376
K_K856  L_L14  L_L48  0.0923
K_K857  L_L14  L_L49  0.1457
K_K858  L_L14  L_L50  0.0949
K_K859  L_L14  L_L51  0.1825
K_K860  L_L14  L_L52  0.0961
K_K861  L_L14  L_L53  0.1515
K_K862  L_L14  L_L54  0.0949
K_K863  L_L14  L_L55  0.1825
K_K864  L_L14  L_L56  0.0923
K_K865  L_L14  L_L57  0.1457
K_K866  L_L14  L_L58  0.0933
K_K867  L_L14  L_L59  0.1376
K_K868  L_L14  L_L60  0.0961
K_K869  L_L14  L_L61  0.1515
K_K870  L_L14  L_L62  0.0169
K_K871  L_L14  L_L63  0.0163
K_K872  L_L14  L_L64  0.0163
K_K873  L_L14  L_L65  0.0169
K_K874  L_L14  L_L66  0.0196
K_K875  L_L14  L_L67  0.0190
K_K876  L_L14  L_L68  0.0184
K_K877  L_L14  L_L69  0.0190
K_K878  L_L14  L_L70  0.0107
K_K879  L_L14  L_L71  0.0157
K_K880  L_L14  L_L72  0.0106
K_K881  L_L14  L_L73  0.0159
K_K882  L_L14  L_L74  0.0108
K_K883  L_L14  L_L75  0.0164
K_K884  L_L14  L_L76  0.0109
K_K885  L_L14  L_L77  0.0161
K_K886  L_L14  L_L78  0.0108
K_K887  L_L14  L_L79  0.0164
K_K888  L_L14  L_L80  0.0106
K_K889  L_L14  L_L81  0.0159
K_K890  L_L14  L_L82  0.0107
K_K891  L_L14  L_L83  0.0157
K_K892  L_L14  L_L84  0.0109
K_K893  L_L14  L_L85  0.0161
* *  Branch  N_C0_6 - N_C0_2
R_R15  N_C0_6  nR_15  187.036335m  TC=0,0
R_V21  nR_15  nV_21  3.613632m  TC=0,0
L_V21  nR_15  nV_21  0.172542uH
R_V22  nV_21  nV_22  1.662059m  TC=0,0
L_V22  nV_21  nV_22  0.025488uH
R_V23  nV_22  nV_23  9.979026m  TC=0,0
L_V23  nV_22  nV_23  0.047373uH
R_V24  nV_23  nV_24  -61.869945m  TC=0,0
L_V24  nV_23  nV_24  -0.049053uH
R_V25  nV_24  nV_25  91.638090m  TC=0,0
L_V25  nV_24  nV_25  0.054944uH
R_V26  nV_25  nV_26  -2459.675348m  TC=0,0
L_V26  nV_25  nV_26  -0.243622uH
R_V27  nV_26  nV_27  2594.462084m  TC=0,0
L_V27  nV_26  nV_27  0.247849uH
R_VC28  nV_27  nVC_28  0.363625m  TC=0,0
C_V28  nVC_28  nV_28  20826.631975uF
R_V28  nV_27  nV_28  -0.397631m  TC=0,0
L_V28  nV_27  nV_28  0.002421uH
L_L15  nV_28  N_C0_2  5.319405uH
K_K894  L_L15  L_L16  0.3188
K_K895  L_L15  L_L17  0.2658
K_K896  L_L15  L_L18  0.4506
K_K897  L_L15  L_L19  0.2969
K_K898  L_L15  L_L20  0.2299
K_K899  L_L15  L_L21  0.2285
K_K900  L_L15  L_L22  0.2108
K_K901  L_L15  L_L23  0.2517
K_K902  L_L15  L_L24  0.2751
K_K903  L_L15  L_L25  0.4761
K_K904  L_L15  L_L26  0.4506
K_K905  L_L15  L_L27  0.2969
K_K906  L_L15  L_L28  0.2751
K_K907  L_L15  L_L29  0.4761
K_K908  L_L15  L_L30  0.2108
K_K909  L_L15  L_L31  0.2517
K_K910  L_L15  L_L32  0.2299
K_K911  L_L15  L_L33  0.2285
K_K912  L_L15  L_L34  0.1588
K_K913  L_L15  L_L35  0.1096
K_K914  L_L15  L_L36  0.0949
K_K915  L_L15  L_L37  0.1096
K_K916  L_L15  L_L42  0.1643
K_K917  L_L15  L_L43  0.1914
K_K918  L_L15  L_L44  0.1643
K_K919  L_L15  L_L45  0.1543
K_K920  L_L15  L_L46  0.0961
K_K921  L_L15  L_L47  0.1515
K_K922  L_L15  L_L48  0.0933
K_K923  L_L15  L_L49  0.1376
K_K924  L_L15  L_L50  0.0923
K_K925  L_L15  L_L51  0.1457
K_K926  L_L15  L_L52  0.0949
K_K927  L_L15  L_L53  0.1825
K_K928  L_L15  L_L54  0.0961
K_K929  L_L15  L_L55  0.1515
K_K930  L_L15  L_L56  0.0949
K_K931  L_L15  L_L57  0.1825
K_K932  L_L15  L_L58  0.0923
K_K933  L_L15  L_L59  0.1457
K_K934  L_L15  L_L60  0.0933
K_K935  L_L15  L_L61  0.1376
K_K936  L_L15  L_L62  0.0169
K_K937  L_L15  L_L63  0.0169
K_K938  L_L15  L_L64  0.0163
K_K939  L_L15  L_L65  0.0163
K_K940  L_L15  L_L66  0.0190
K_K941  L_L15  L_L67  0.0196
K_K942  L_L15  L_L68  0.0190
K_K943  L_L15  L_L69  0.0184
K_K944  L_L15  L_L70  0.0109
K_K945  L_L15  L_L71  0.0161
K_K946  L_L15  L_L72  0.0107
K_K947  L_L15  L_L73  0.0157
K_K948  L_L15  L_L74  0.0106
K_K949  L_L15  L_L75  0.0159
K_K950  L_L15  L_L76  0.0108
K_K951  L_L15  L_L77  0.0164
K_K952  L_L15  L_L78  0.0109
K_K953  L_L15  L_L79  0.0161
K_K954  L_L15  L_L80  0.0108
K_K955  L_L15  L_L81  0.0164
K_K956  L_L15  L_L82  0.0106
K_K957  L_L15  L_L83  0.0159
K_K958  L_L15  L_L84  0.0107
K_K959  L_L15  L_L85  0.0157
* *  Branch  N_C0_7 - N_C0_3
R_R16  N_C0_7  nR_16  187.036335m  TC=0,0
R_V29  nR_16  nV_29  3.613632m  TC=0,0
L_V29  nR_16  nV_29  0.172542uH
R_V30  nV_29  nV_30  1.662059m  TC=0,0
L_V30  nV_29  nV_30  0.025488uH
R_V31  nV_30  nV_31  9.979026m  TC=0,0
L_V31  nV_30  nV_31  0.047373uH
R_V32  nV_31  nV_32  -61.869945m  TC=0,0
L_V32  nV_31  nV_32  -0.049053uH
R_V33  nV_32  nV_33  91.638090m  TC=0,0
L_V33  nV_32  nV_33  0.054944uH
R_V34  nV_33  nV_34  -2459.675348m  TC=0,0
L_V34  nV_33  nV_34  -0.243622uH
R_V35  nV_34  nV_35  2594.462084m  TC=0,0
L_V35  nV_34  nV_35  0.247849uH
R_VC36  nV_35  nVC_36  0.363625m  TC=0,0
C_V36  nVC_36  nV_36  20826.631975uF
R_V36  nV_35  nV_36  -0.397631m  TC=0,0
L_V36  nV_35  nV_36  0.002421uH
L_L16  nV_36  N_C0_3  5.319405uH
K_K960  L_L16  L_L17  0.3188
K_K961  L_L16  L_L18  0.2751
K_K962  L_L16  L_L19  0.4761
K_K963  L_L16  L_L20  0.4506
K_K964  L_L16  L_L21  0.2969
K_K965  L_L16  L_L22  0.2299
K_K966  L_L16  L_L23  0.2285
K_K967  L_L16  L_L24  0.2108
K_K968  L_L16  L_L25  0.2517
K_K969  L_L16  L_L26  0.2299
K_K970  L_L16  L_L27  0.2285
K_K971  L_L16  L_L28  0.4506
K_K972  L_L16  L_L29  0.2969
K_K973  L_L16  L_L30  0.2751
K_K974  L_L16  L_L31  0.4761
K_K975  L_L16  L_L32  0.2108
K_K976  L_L16  L_L33  0.2517
K_K977  L_L16  L_L34  0.1096
K_K978  L_L16  L_L35  0.0949
K_K979  L_L16  L_L36  0.1096
K_K980  L_L16  L_L37  0.1588
K_K981  L_L16  L_L42  0.1543
K_K982  L_L16  L_L43  0.1643
K_K983  L_L16  L_L44  0.1914
K_K984  L_L16  L_L45  0.1643
K_K985  L_L16  L_L46  0.0949
K_K986  L_L16  L_L47  0.1825
K_K987  L_L16  L_L48  0.0961
K_K988  L_L16  L_L49  0.1515
K_K989  L_L16  L_L50  0.0933
K_K990  L_L16  L_L51  0.1376
K_K991  L_L16  L_L52  0.0923
K_K992  L_L16  L_L53  0.1457
K_K993  L_L16  L_L54  0.0933
K_K994  L_L16  L_L55  0.1376
K_K995  L_L16  L_L56  0.0961
K_K996  L_L16  L_L57  0.1515
K_K997  L_L16  L_L58  0.0949
K_K998  L_L16  L_L59  0.1825
K_K999  L_L16  L_L60  0.0923
K_K1000  L_L16  L_L61  0.1457
K_K1001  L_L16  L_L62  0.0163
K_K1002  L_L16  L_L63  0.0169
K_K1003  L_L16  L_L64  0.0169
K_K1004  L_L16  L_L65  0.0163
K_K1005  L_L16  L_L66  0.0184
K_K1006  L_L16  L_L67  0.0190
K_K1007  L_L16  L_L68  0.0196
K_K1008  L_L16  L_L69  0.0190
K_K1009  L_L16  L_L70  0.0108
K_K1010  L_L16  L_L71  0.0164
K_K1011  L_L16  L_L72  0.0109
K_K1012  L_L16  L_L73  0.0161
K_K1013  L_L16  L_L74  0.0107
K_K1014  L_L16  L_L75  0.0157
K_K1015  L_L16  L_L76  0.0106
K_K1016  L_L16  L_L77  0.0159
K_K1017  L_L16  L_L78  0.0107
K_K1018  L_L16  L_L79  0.0157
K_K1019  L_L16  L_L80  0.0109
K_K1020  L_L16  L_L81  0.0161
K_K1021  L_L16  L_L82  0.0108
K_K1022  L_L16  L_L83  0.0164
K_K1023  L_L16  L_L84  0.0106
K_K1024  L_L16  L_L85  0.0159
* *  Branch  N_C0_8 - N_C0_4
R_R17  N_C0_8  nR_17  187.036335m  TC=0,0
R_V37  nR_17  nV_37  3.613632m  TC=0,0
L_V37  nR_17  nV_37  0.172542uH
R_V38  nV_37  nV_38  1.662059m  TC=0,0
L_V38  nV_37  nV_38  0.025488uH
R_V39  nV_38  nV_39  9.979026m  TC=0,0
L_V39  nV_38  nV_39  0.047373uH
R_V40  nV_39  nV_40  -61.869945m  TC=0,0
L_V40  nV_39  nV_40  -0.049053uH
R_V41  nV_40  nV_41  91.638090m  TC=0,0
L_V41  nV_40  nV_41  0.054944uH
R_V42  nV_41  nV_42  -2459.675348m  TC=0,0
L_V42  nV_41  nV_42  -0.243622uH
R_V43  nV_42  nV_43  2594.462084m  TC=0,0
L_V43  nV_42  nV_43  0.247849uH
R_VC44  nV_43  nVC_44  0.363625m  TC=0,0
C_V44  nVC_44  nV_44  20826.631975uF
R_V44  nV_43  nV_44  -0.397631m  TC=0,0
L_V44  nV_43  nV_44  0.002421uH
L_L17  nV_44  N_C0_4  5.319405uH
K_K1025  L_L17  L_L18  0.2108
K_K1026  L_L17  L_L19  0.2517
K_K1027  L_L17  L_L20  0.2751
K_K1028  L_L17  L_L21  0.4761
K_K1029  L_L17  L_L22  0.4506
K_K1030  L_L17  L_L23  0.2969
K_K1031  L_L17  L_L24  0.2299
K_K1032  L_L17  L_L25  0.2285
K_K1033  L_L17  L_L26  0.2108
K_K1034  L_L17  L_L27  0.2517
K_K1035  L_L17  L_L28  0.2299
K_K1036  L_L17  L_L29  0.2285
K_K1037  L_L17  L_L30  0.4506
K_K1038  L_L17  L_L31  0.2969
K_K1039  L_L17  L_L32  0.2751
K_K1040  L_L17  L_L33  0.4761
K_K1041  L_L17  L_L34  0.0949
K_K1042  L_L17  L_L35  0.1096
K_K1043  L_L17  L_L36  0.1588
K_K1044  L_L17  L_L37  0.1096
K_K1045  L_L17  L_L42  0.1643
K_K1046  L_L17  L_L43  0.1543
K_K1047  L_L17  L_L44  0.1643
K_K1048  L_L17  L_L45  0.1914
K_K1049  L_L17  L_L46  0.0923
K_K1050  L_L17  L_L47  0.1457
K_K1051  L_L17  L_L48  0.0949
K_K1052  L_L17  L_L49  0.1825
K_K1053  L_L17  L_L50  0.0961
K_K1054  L_L17  L_L51  0.1515
K_K1055  L_L17  L_L52  0.0933
K_K1056  L_L17  L_L53  0.1376
K_K1057  L_L17  L_L54  0.0923
K_K1058  L_L17  L_L55  0.1457
K_K1059  L_L17  L_L56  0.0933
K_K1060  L_L17  L_L57  0.1376
K_K1061  L_L17  L_L58  0.0961
K_K1062  L_L17  L_L59  0.1515
K_K1063  L_L17  L_L60  0.0949
K_K1064  L_L17  L_L61  0.1825
K_K1065  L_L17  L_L62  0.0163
K_K1066  L_L17  L_L63  0.0163
K_K1067  L_L17  L_L64  0.0169
K_K1068  L_L17  L_L65  0.0169
K_K1069  L_L17  L_L66  0.0190
K_K1070  L_L17  L_L67  0.0184
K_K1071  L_L17  L_L68  0.0190
K_K1072  L_L17  L_L69  0.0196
K_K1073  L_L17  L_L70  0.0106
K_K1074  L_L17  L_L71  0.0159
K_K1075  L_L17  L_L72  0.0108
K_K1076  L_L17  L_L73  0.0164
K_K1077  L_L17  L_L74  0.0109
K_K1078  L_L17  L_L75  0.0161
K_K1079  L_L17  L_L76  0.0107
K_K1080  L_L17  L_L77  0.0157
K_K1081  L_L17  L_L78  0.0106
K_K1082  L_L17  L_L79  0.0159
K_K1083  L_L17  L_L80  0.0107
K_K1084  L_L17  L_L81  0.0157
K_K1085  L_L17  L_L82  0.0109
K_K1086  L_L17  L_L83  0.0161
K_K1087  L_L17  L_L84  0.0108
K_K1088  L_L17  L_L85  0.0164
* *  Branch  N_C0_6 - N_C0_9
R_R18  N_C0_6  nR_18  0.941960m  TC=0,0
L_L18  nR_18  N_C0_9  2.100443uH
K_K1089  L_L18  L_L19  0.2102
K_K1090  L_L18  L_L20  0.1615
K_K1091  L_L18  L_L21  0.1572
K_K1092  L_L18  L_L22  0.0999
K_K1093  L_L18  L_L23  0.1499
K_K1094  L_L18  L_L24  0.1615
K_K1095  L_L18  L_L25  0.1778
K_K1096  L_L18  L_L26  0.3635
K_K1097  L_L18  L_L27  0.1663
K_K1098  L_L18  L_L28  0.2692
K_K1099  L_L18  L_L29  0.1997
K_K1100  L_L18  L_L30  0.1237
K_K1101  L_L18  L_L31  0.1670
K_K1102  L_L18  L_L32  0.1431
K_K1103  L_L18  L_L33  0.1559
K_K1104  L_L18  L_L34  0.0666
K_K1105  L_L18  L_L35  0.0618
K_K1106  L_L18  L_L36  0.0600
K_K1107  L_L18  L_L37  0.0644
K_K1108  L_L18  L_L38  -0.0290
K_K1109  L_L18  L_L39  0.0435
K_K1110  L_L18  L_L40  -0.0288
K_K1111  L_L18  L_L41  -0.0651
K_K1112  L_L18  L_L42  0.0767
K_K1113  L_L18  L_L43  0.1157
K_K1114  L_L18  L_L44  0.0825
K_K1115  L_L18  L_L45  0.0685
K_K1116  L_L18  L_L46  0.0416
K_K1117  L_L18  L_L47  0.1003
K_K1118  L_L18  L_L48  0.0338
K_K1119  L_L18  L_L49  0.0699
K_K1120  L_L18  L_L50  0.0273
K_K1121  L_L18  L_L51  0.0664
K_K1122  L_L18  L_L52  0.0346
K_K1123  L_L18  L_L53  0.1276
K_K1124  L_L18  L_L54  0.0357
K_K1125  L_L18  L_L55  0.0824
K_K1126  L_L18  L_L56  0.0299
K_K1127  L_L18  L_L57  0.1156
K_K1128  L_L18  L_L58  0.0328
K_K1129  L_L18  L_L59  0.0824
K_K1130  L_L18  L_L60  0.0384
K_K1131  L_L18  L_L61  0.0779
K_K1132  L_L18  L_L62  0.0226
K_K1133  L_L18  L_L63  0.0229
K_K1134  L_L18  L_L64  0.0221
K_K1135  L_L18  L_L65  0.0218
K_K1136  L_L18  L_L66  0.0213
K_K1137  L_L18  L_L67  0.0220
K_K1138  L_L18  L_L68  0.0216
K_K1139  L_L18  L_L69  0.0209
K_K1140  L_L18  L_L70  0.0141
K_K1141  L_L18  L_L71  0.0214
K_K1142  L_L18  L_L72  0.0139
K_K1143  L_L18  L_L73  0.0208
K_K1144  L_L18  L_L74  0.0137
K_K1145  L_L18  L_L75  0.0209
K_K1146  L_L18  L_L76  0.0139
K_K1147  L_L18  L_L77  0.0215
K_K1148  L_L18  L_L78  0.0140
K_K1149  L_L18  L_L79  0.0211
K_K1150  L_L18  L_L80  0.0140
K_K1151  L_L18  L_L81  0.0216
K_K1152  L_L18  L_L82  0.0138
K_K1153  L_L18  L_L83  0.0211
K_K1154  L_L18  L_L84  0.0138
K_K1155  L_L18  L_L85  0.0207
K_K1156  L_L18  L_L90  0.0108
K_K1157  L_L18  L_L91  0.0109
K_K1158  L_L18  L_L92  0.0108
K_K1159  L_L18  L_L93  0.0107
* *  Branch  N_C0_9 - N_C0_3
R_R19  N_C0_9  nR_19  145.206218m  TC=0,0
R_V45  nR_19  nV_45  1716.243046m  TC=0,0
L_V45  nR_19  nV_45  0.136028uH
R_V46  nV_45  nV_46  -1619.078956m  TC=0,0
L_V46  nV_45  nV_46  -0.135970uH
R_V47  nV_46  nV_47  537.962162m  TC=0,0
L_V47  nV_46  nV_47  0.216400uH
R_V48  nV_47  nV_48  -514.025827m  TC=0,0
L_V48  nV_47  nV_48  -0.218558uH
R_V49  nV_48  nV_49  252.446393m  TC=0,0
L_V49  nV_48  nV_49  0.448918uH
R_V50  nV_49  nV_50  -235.307304m  TC=0,0
L_V50  nV_49  nV_50  -0.433744uH
R_V51  nV_50  nV_51  -0.957781m  TC=0,0
L_V51  nV_50  nV_51  -0.006628uH
R_V52  nV_51  nV_52  5.534735m  TC=0,0
L_V52  nV_51  nV_52  0.056726uH
R_V53  nV_52  nV_53  -1.062476m  TC=0,0
L_V53  nV_52  nV_53  -0.041415uH
R_V54  nV_53  nV_54  2.054783m  TC=0,0
L_V54  nV_53  nV_54  0.166568uH
L_L19  nV_54  N_C0_3  2.364371uH
K_K1160  L_L19  L_L20  0.1778
K_K1161  L_L19  L_L21  0.2713
K_K1162  L_L19  L_L22  0.1499
K_K1163  L_L19  L_L23  0.2144
K_K1164  L_L19  L_L24  0.1572
K_K1165  L_L19  L_L25  0.2713
K_K1166  L_L19  L_L26  0.1663
K_K1167  L_L19  L_L27  0.2286
K_K1168  L_L19  L_L28  0.1996
K_K1169  L_L19  L_L29  0.3800
K_K1170  L_L19  L_L30  0.1670
K_K1171  L_L19  L_L31  0.4714
K_K1172  L_L19  L_L32  0.1559
K_K1173  L_L19  L_L33  0.2425
K_K1174  L_L19  L_L34  0.1340
K_K1175  L_L19  L_L35  0.1015
K_K1176  L_L19  L_L36  0.1165
K_K1177  L_L19  L_L37  0.2055
K_K1178  L_L19  L_L38  0.0244
K_K1179  L_L19  L_L39  0.0539
K_K1180  L_L19  L_L40  0.0262
K_K1181  L_L19  L_L41  0.0236
K_K1182  L_L19  L_L42  0.0184
K_K1183  L_L19  L_L43  0.0202
K_K1184  L_L19  L_L44  0.0210
K_K1185  L_L19  L_L45  0.0190
K_K1186  L_L19  L_L46  0.0105
K_K1187  L_L19  L_L47  0.0239
K_K1188  L_L19  L_L48  0.0106
K_K1189  L_L19  L_L49  0.0168
K_K1190  L_L19  L_L50  0.0102
K_K1191  L_L19  L_L51  0.0110
K_K1192  L_L19  L_L52  0.0101
K_K1193  L_L19  L_L53  0.0176
K_K1194  L_L19  L_L54  0.0104
K_K1195  L_L19  L_L55  0.0162
K_K1196  L_L19  L_L56  0.0107
K_K1197  L_L19  L_L57  0.0129
K_K1198  L_L19  L_L58  0.0104
K_K1199  L_L19  L_L59  0.0184
K_K1200  L_L19  L_L60  0.0101
K_K1201  L_L19  L_L61  0.0213
* *  Branch  N_C0_7 - N_C0_10
R_R20  N_C0_7  nR_20  0.941960m  TC=0,0
L_L20  nR_20  N_C0_10  2.100443uH
K_K1202  L_L20  L_L21  0.2102
K_K1203  L_L20  L_L22  0.1615
K_K1204  L_L20  L_L23  0.1572
K_K1205  L_L20  L_L24  0.0999
K_K1206  L_L20  L_L25  0.1499
K_K1207  L_L20  L_L26  0.1431
K_K1208  L_L20  L_L27  0.1559
K_K1209  L_L20  L_L28  0.3635
K_K1210  L_L20  L_L29  0.1663
K_K1211  L_L20  L_L30  0.2692
K_K1212  L_L20  L_L31  0.1997
K_K1213  L_L20  L_L32  0.1237
K_K1214  L_L20  L_L33  0.1670
K_K1215  L_L20  L_L34  0.0618
K_K1216  L_L20  L_L35  0.0600
K_K1217  L_L20  L_L36  0.0644
K_K1218  L_L20  L_L37  0.0666
K_K1219  L_L20  L_L38  -0.0651
K_K1220  L_L20  L_L39  -0.0290
K_K1221  L_L20  L_L40  0.0435
K_K1222  L_L20  L_L41  -0.0288
K_K1223  L_L20  L_L42  0.0685
K_K1224  L_L20  L_L43  0.0767
K_K1225  L_L20  L_L44  0.1157
K_K1226  L_L20  L_L45  0.0825
K_K1227  L_L20  L_L46  0.0346
K_K1228  L_L20  L_L47  0.1276
K_K1229  L_L20  L_L48  0.0416
K_K1230  L_L20  L_L49  0.1003
K_K1231  L_L20  L_L50  0.0338
K_K1232  L_L20  L_L51  0.0699
K_K1233  L_L20  L_L52  0.0273
K_K1234  L_L20  L_L53  0.0664
K_K1235  L_L20  L_L54  0.0384
K_K1236  L_L20  L_L55  0.0779
K_K1237  L_L20  L_L56  0.0357
K_K1238  L_L20  L_L57  0.0824
K_K1239  L_L20  L_L58  0.0299
K_K1240  L_L20  L_L59  0.1156
K_K1241  L_L20  L_L60  0.0328
K_K1242  L_L20  L_L61  0.0824
K_K1243  L_L20  L_L62  0.0218
K_K1244  L_L20  L_L63  0.0226
K_K1245  L_L20  L_L64  0.0229
K_K1246  L_L20  L_L65  0.0221
K_K1247  L_L20  L_L66  0.0209
K_K1248  L_L20  L_L67  0.0213
K_K1249  L_L20  L_L68  0.0220
K_K1250  L_L20  L_L69  0.0216
K_K1251  L_L20  L_L70  0.0139
K_K1252  L_L20  L_L71  0.0215
K_K1253  L_L20  L_L72  0.0141
K_K1254  L_L20  L_L73  0.0214
K_K1255  L_L20  L_L74  0.0139
K_K1256  L_L20  L_L75  0.0208
K_K1257  L_L20  L_L76  0.0137
K_K1258  L_L20  L_L77  0.0209
K_K1259  L_L20  L_L78  0.0138
K_K1260  L_L20  L_L79  0.0207
K_K1261  L_L20  L_L80  0.0140
K_K1262  L_L20  L_L81  0.0211
K_K1263  L_L20  L_L82  0.0140
K_K1264  L_L20  L_L83  0.0216
K_K1265  L_L20  L_L84  0.0138
K_K1266  L_L20  L_L85  0.0211
K_K1267  L_L20  L_L90  0.0107
K_K1268  L_L20  L_L91  0.0108
K_K1269  L_L20  L_L92  0.0109
K_K1270  L_L20  L_L93  0.0108
* *  Branch  N_C0_10 - N_C0_4
R_R21  N_C0_10  nR_21  145.206218m  TC=0,0
R_V55  nR_21  nV_55  1716.243046m  TC=0,0
L_V55  nR_21  nV_55  0.136028uH
R_V56  nV_55  nV_56  -1619.078956m  TC=0,0
L_V56  nV_55  nV_56  -0.135970uH
R_V57  nV_56  nV_57  537.962162m  TC=0,0
L_V57  nV_56  nV_57  0.216400uH
R_V58  nV_57  nV_58  -514.025827m  TC=0,0
L_V58  nV_57  nV_58  -0.218558uH
R_V59  nV_58  nV_59  252.446393m  TC=0,0
L_V59  nV_58  nV_59  0.448918uH
R_V60  nV_59  nV_60  -235.307304m  TC=0,0
L_V60  nV_59  nV_60  -0.433744uH
R_V61  nV_60  nV_61  -0.957781m  TC=0,0
L_V61  nV_60  nV_61  -0.006628uH
R_V62  nV_61  nV_62  5.534735m  TC=0,0
L_V62  nV_61  nV_62  0.056726uH
R_V63  nV_62  nV_63  -1.062476m  TC=0,0
L_V63  nV_62  nV_63  -0.041415uH
R_V64  nV_63  nV_64  2.054783m  TC=0,0
L_V64  nV_63  nV_64  0.166568uH
L_L21  nV_64  N_C0_4  2.364371uH
K_K1271  L_L21  L_L22  0.1778
K_K1272  L_L21  L_L23  0.2713
K_K1273  L_L21  L_L24  0.1499
K_K1274  L_L21  L_L25  0.2144
K_K1275  L_L21  L_L26  0.1559
K_K1276  L_L21  L_L27  0.2425
K_K1277  L_L21  L_L28  0.1663
K_K1278  L_L21  L_L29  0.2286
K_K1279  L_L21  L_L30  0.1996
K_K1280  L_L21  L_L31  0.3800
K_K1281  L_L21  L_L32  0.1670
K_K1282  L_L21  L_L33  0.4714
K_K1283  L_L21  L_L34  0.1015
K_K1284  L_L21  L_L35  0.1165
K_K1285  L_L21  L_L36  0.2055
K_K1286  L_L21  L_L37  0.1340
K_K1287  L_L21  L_L38  0.0236
K_K1288  L_L21  L_L39  0.0244
K_K1289  L_L21  L_L40  0.0539
K_K1290  L_L21  L_L41  0.0262
K_K1291  L_L21  L_L42  0.0190
K_K1292  L_L21  L_L43  0.0184
K_K1293  L_L21  L_L44  0.0202
K_K1294  L_L21  L_L45  0.0210
K_K1295  L_L21  L_L46  0.0101
K_K1296  L_L21  L_L47  0.0176
K_K1297  L_L21  L_L48  0.0105
K_K1298  L_L21  L_L49  0.0239
K_K1299  L_L21  L_L50  0.0106
K_K1300  L_L21  L_L51  0.0168
K_K1301  L_L21  L_L52  0.0102
K_K1302  L_L21  L_L53  0.0110
K_K1303  L_L21  L_L54  0.0101
K_K1304  L_L21  L_L55  0.0213
K_K1305  L_L21  L_L56  0.0104
K_K1306  L_L21  L_L57  0.0162
K_K1307  L_L21  L_L58  0.0107
K_K1308  L_L21  L_L59  0.0129
K_K1309  L_L21  L_L60  0.0104
K_K1310  L_L21  L_L61  0.0184
* *  Branch  N_C0_8 - N_C0_11
R_R22  N_C0_8  nR_22  0.941960m  TC=0,0
L_L22  nR_22  N_C0_11  2.100443uH
K_K1311  L_L22  L_L23  0.2102
K_K1312  L_L22  L_L24  0.1615
K_K1313  L_L22  L_L25  0.1572
K_K1314  L_L22  L_L26  0.1237
K_K1315  L_L22  L_L27  0.1670
K_K1316  L_L22  L_L28  0.1431
K_K1317  L_L22  L_L29  0.1559
K_K1318  L_L22  L_L30  0.3635
K_K1319  L_L22  L_L31  0.1663
K_K1320  L_L22  L_L32  0.2692
K_K1321  L_L22  L_L33  0.1997
K_K1322  L_L22  L_L34  0.0600
K_K1323  L_L22  L_L35  0.0644
K_K1324  L_L22  L_L36  0.0666
K_K1325  L_L22  L_L37  0.0618
K_K1326  L_L22  L_L38  -0.0288
K_K1327  L_L22  L_L39  -0.0651
K_K1328  L_L22  L_L40  -0.0290
K_K1329  L_L22  L_L41  0.0435
K_K1330  L_L22  L_L42  0.0825
K_K1331  L_L22  L_L43  0.0685
K_K1332  L_L22  L_L44  0.0767
K_K1333  L_L22  L_L45  0.1157
K_K1334  L_L22  L_L46  0.0273
K_K1335  L_L22  L_L47  0.0664
K_K1336  L_L22  L_L48  0.0346
K_K1337  L_L22  L_L49  0.1276
K_K1338  L_L22  L_L50  0.0416
K_K1339  L_L22  L_L51  0.1003
K_K1340  L_L22  L_L52  0.0338
K_K1341  L_L22  L_L53  0.0699
K_K1342  L_L22  L_L54  0.0328
K_K1343  L_L22  L_L55  0.0824
K_K1344  L_L22  L_L56  0.0384
K_K1345  L_L22  L_L57  0.0779
K_K1346  L_L22  L_L58  0.0357
K_K1347  L_L22  L_L59  0.0824
K_K1348  L_L22  L_L60  0.0299
K_K1349  L_L22  L_L61  0.1156
K_K1350  L_L22  L_L62  0.0221
K_K1351  L_L22  L_L63  0.0218
K_K1352  L_L22  L_L64  0.0226
K_K1353  L_L22  L_L65  0.0229
K_K1354  L_L22  L_L66  0.0216
K_K1355  L_L22  L_L67  0.0209
K_K1356  L_L22  L_L68  0.0213
K_K1357  L_L22  L_L69  0.0220
K_K1358  L_L22  L_L70  0.0137
K_K1359  L_L22  L_L71  0.0209
K_K1360  L_L22  L_L72  0.0139
K_K1361  L_L22  L_L73  0.0215
K_K1362  L_L22  L_L74  0.0141
K_K1363  L_L22  L_L75  0.0214
K_K1364  L_L22  L_L76  0.0139
K_K1365  L_L22  L_L77  0.0208
K_K1366  L_L22  L_L78  0.0138
K_K1367  L_L22  L_L79  0.0211
K_K1368  L_L22  L_L80  0.0138
K_K1369  L_L22  L_L81  0.0207
K_K1370  L_L22  L_L82  0.0140
K_K1371  L_L22  L_L83  0.0211
K_K1372  L_L22  L_L84  0.0140
K_K1373  L_L22  L_L85  0.0216
K_K1374  L_L22  L_L90  0.0108
K_K1375  L_L22  L_L91  0.0107
K_K1376  L_L22  L_L92  0.0108
K_K1377  L_L22  L_L93  0.0109
* *  Branch  N_C0_11 - N_C0_1
R_R23  N_C0_11  nR_23  145.206218m  TC=0,0
R_V65  nR_23  nV_65  1716.243046m  TC=0,0
L_V65  nR_23  nV_65  0.136028uH
R_V66  nV_65  nV_66  -1619.078956m  TC=0,0
L_V66  nV_65  nV_66  -0.135970uH
R_V67  nV_66  nV_67  537.962162m  TC=0,0
L_V67  nV_66  nV_67  0.216400uH
R_V68  nV_67  nV_68  -514.025827m  TC=0,0
L_V68  nV_67  nV_68  -0.218558uH
R_V69  nV_68  nV_69  252.446393m  TC=0,0
L_V69  nV_68  nV_69  0.448918uH
R_V70  nV_69  nV_70  -235.307304m  TC=0,0
L_V70  nV_69  nV_70  -0.433744uH
R_V71  nV_70  nV_71  -0.957781m  TC=0,0
L_V71  nV_70  nV_71  -0.006628uH
R_V72  nV_71  nV_72  5.534735m  TC=0,0
L_V72  nV_71  nV_72  0.056726uH
R_V73  nV_72  nV_73  -1.062476m  TC=0,0
L_V73  nV_72  nV_73  -0.041415uH
R_V74  nV_73  nV_74  2.054783m  TC=0,0
L_V74  nV_73  nV_74  0.166568uH
L_L23  nV_74  N_C0_1  2.364371uH
K_K1378  L_L23  L_L24  0.1778
K_K1379  L_L23  L_L25  0.2713
K_K1380  L_L23  L_L26  0.1670
K_K1381  L_L23  L_L27  0.4714
K_K1382  L_L23  L_L28  0.1559
K_K1383  L_L23  L_L29  0.2425
K_K1384  L_L23  L_L30  0.1663
K_K1385  L_L23  L_L31  0.2286
K_K1386  L_L23  L_L32  0.1996
K_K1387  L_L23  L_L33  0.3800
K_K1388  L_L23  L_L34  0.1165
K_K1389  L_L23  L_L35  0.2055
K_K1390  L_L23  L_L36  0.1340
K_K1391  L_L23  L_L37  0.1015
K_K1392  L_L23  L_L38  0.0262
K_K1393  L_L23  L_L39  0.0236
K_K1394  L_L23  L_L40  0.0244
K_K1395  L_L23  L_L41  0.0539
K_K1396  L_L23  L_L42  0.0210
K_K1397  L_L23  L_L43  0.0190
K_K1398  L_L23  L_L44  0.0184
K_K1399  L_L23  L_L45  0.0202
K_K1400  L_L23  L_L46  0.0102
K_K1401  L_L23  L_L47  0.0110
K_K1402  L_L23  L_L48  0.0101
K_K1403  L_L23  L_L49  0.0176
K_K1404  L_L23  L_L50  0.0105
K_K1405  L_L23  L_L51  0.0239
K_K1406  L_L23  L_L52  0.0106
K_K1407  L_L23  L_L53  0.0168
K_K1408  L_L23  L_L54  0.0104
K_K1409  L_L23  L_L55  0.0184
K_K1410  L_L23  L_L56  0.0101
K_K1411  L_L23  L_L57  0.0213
K_K1412  L_L23  L_L58  0.0104
K_K1413  L_L23  L_L59  0.0162
K_K1414  L_L23  L_L60  0.0107
K_K1415  L_L23  L_L61  0.0129
* *  Branch  N_C0_5 - N_C0_12
R_R24  N_C0_5  nR_24  0.941960m  TC=0,0
L_L24  nR_24  N_C0_12  2.100443uH
K_K1416  L_L24  L_L25  0.2102
K_K1417  L_L24  L_L26  0.2692
K_K1418  L_L24  L_L27  0.1997
K_K1419  L_L24  L_L28  0.1237
K_K1420  L_L24  L_L29  0.1670
K_K1421  L_L24  L_L30  0.1431
K_K1422  L_L24  L_L31  0.1559
K_K1423  L_L24  L_L32  0.3635
K_K1424  L_L24  L_L33  0.1663
K_K1425  L_L24  L_L34  0.0644
K_K1426  L_L24  L_L35  0.0666
K_K1427  L_L24  L_L36  0.0618
K_K1428  L_L24  L_L37  0.0600
K_K1429  L_L24  L_L38  0.0435
K_K1430  L_L24  L_L39  -0.0288
K_K1431  L_L24  L_L40  -0.0651
K_K1432  L_L24  L_L41  -0.0290
K_K1433  L_L24  L_L42  0.1157
K_K1434  L_L24  L_L43  0.0825
K_K1435  L_L24  L_L44  0.0685
K_K1436  L_L24  L_L45  0.0767
K_K1437  L_L24  L_L46  0.0338
K_K1438  L_L24  L_L47  0.0699
K_K1439  L_L24  L_L48  0.0273
K_K1440  L_L24  L_L49  0.0664
K_K1441  L_L24  L_L50  0.0346
K_K1442  L_L24  L_L51  0.1276
K_K1443  L_L24  L_L52  0.0416
K_K1444  L_L24  L_L53  0.1003
K_K1445  L_L24  L_L54  0.0299
K_K1446  L_L24  L_L55  0.1156
K_K1447  L_L24  L_L56  0.0328
K_K1448  L_L24  L_L57  0.0824
K_K1449  L_L24  L_L58  0.0384
K_K1450  L_L24  L_L59  0.0779
K_K1451  L_L24  L_L60  0.0357
K_K1452  L_L24  L_L61  0.0824
K_K1453  L_L24  L_L62  0.0229
K_K1454  L_L24  L_L63  0.0221
K_K1455  L_L24  L_L64  0.0218
K_K1456  L_L24  L_L65  0.0226
K_K1457  L_L24  L_L66  0.0220
K_K1458  L_L24  L_L67  0.0216
K_K1459  L_L24  L_L68  0.0209
K_K1460  L_L24  L_L69  0.0213
K_K1461  L_L24  L_L70  0.0139
K_K1462  L_L24  L_L71  0.0208
K_K1463  L_L24  L_L72  0.0137
K_K1464  L_L24  L_L73  0.0209
K_K1465  L_L24  L_L74  0.0139
K_K1466  L_L24  L_L75  0.0215
K_K1467  L_L24  L_L76  0.0141
K_K1468  L_L24  L_L77  0.0214
K_K1469  L_L24  L_L78  0.0140
K_K1470  L_L24  L_L79  0.0216
K_K1471  L_L24  L_L80  0.0138
K_K1472  L_L24  L_L81  0.0211
K_K1473  L_L24  L_L82  0.0138
K_K1474  L_L24  L_L83  0.0207
K_K1475  L_L24  L_L84  0.0140
K_K1476  L_L24  L_L85  0.0211
K_K1477  L_L24  L_L90  0.0109
K_K1478  L_L24  L_L91  0.0108
K_K1479  L_L24  L_L92  0.0107
K_K1480  L_L24  L_L93  0.0108
* *  Branch  N_C0_12 - N_C0_2
R_R25  N_C0_12  nR_25  145.206218m  TC=0,0
R_V75  nR_25  nV_75  1716.243046m  TC=0,0
L_V75  nR_25  nV_75  0.136028uH
R_V76  nV_75  nV_76  -1619.078956m  TC=0,0
L_V76  nV_75  nV_76  -0.135970uH
R_V77  nV_76  nV_77  537.962162m  TC=0,0
L_V77  nV_76  nV_77  0.216400uH
R_V78  nV_77  nV_78  -514.025827m  TC=0,0
L_V78  nV_77  nV_78  -0.218558uH
R_V79  nV_78  nV_79  252.446393m  TC=0,0
L_V79  nV_78  nV_79  0.448918uH
R_V80  nV_79  nV_80  -235.307304m  TC=0,0
L_V80  nV_79  nV_80  -0.433744uH
R_V81  nV_80  nV_81  -0.957781m  TC=0,0
L_V81  nV_80  nV_81  -0.006628uH
R_V82  nV_81  nV_82  5.534735m  TC=0,0
L_V82  nV_81  nV_82  0.056726uH
R_V83  nV_82  nV_83  -1.062476m  TC=0,0
L_V83  nV_82  nV_83  -0.041415uH
R_V84  nV_83  nV_84  2.054783m  TC=0,0
L_V84  nV_83  nV_84  0.166568uH
L_L25  nV_84  N_C0_2  2.364371uH
K_K1481  L_L25  L_L26  0.1996
K_K1482  L_L25  L_L27  0.3800
K_K1483  L_L25  L_L28  0.1670
K_K1484  L_L25  L_L29  0.4714
K_K1485  L_L25  L_L30  0.1559
K_K1486  L_L25  L_L31  0.2425
K_K1487  L_L25  L_L32  0.1663
K_K1488  L_L25  L_L33  0.2286
K_K1489  L_L25  L_L34  0.2055
K_K1490  L_L25  L_L35  0.1340
K_K1491  L_L25  L_L36  0.1015
K_K1492  L_L25  L_L37  0.1165
K_K1493  L_L25  L_L38  0.0539
K_K1494  L_L25  L_L39  0.0262
K_K1495  L_L25  L_L40  0.0236
K_K1496  L_L25  L_L41  0.0244
K_K1497  L_L25  L_L42  0.0202
K_K1498  L_L25  L_L43  0.0210
K_K1499  L_L25  L_L44  0.0190
K_K1500  L_L25  L_L45  0.0184
K_K1501  L_L25  L_L46  0.0106
K_K1502  L_L25  L_L47  0.0168
K_K1503  L_L25  L_L48  0.0102
K_K1504  L_L25  L_L49  0.0110
K_K1505  L_L25  L_L50  0.0101
K_K1506  L_L25  L_L51  0.0176
K_K1507  L_L25  L_L52  0.0105
K_K1508  L_L25  L_L53  0.0239
K_K1509  L_L25  L_L54  0.0107
K_K1510  L_L25  L_L55  0.0129
K_K1511  L_L25  L_L56  0.0104
K_K1512  L_L25  L_L57  0.0184
K_K1513  L_L25  L_L58  0.0101
K_K1514  L_L25  L_L59  0.0213
K_K1515  L_L25  L_L60  0.0104
K_K1516  L_L25  L_L61  0.0162
* *  Branch  N_C0_6 - N_C0_12
R_R26  N_C0_6  nR_26  0.941960m  TC=0,0
L_L26  nR_26  N_C0_12  2.100443uH
K_K1517  L_L26  L_L27  0.2102
K_K1518  L_L26  L_L28  0.1615
K_K1519  L_L26  L_L29  0.1778
K_K1520  L_L26  L_L30  0.0999
K_K1521  L_L26  L_L31  0.1499
K_K1522  L_L26  L_L32  0.1615
K_K1523  L_L26  L_L33  0.1572
K_K1524  L_L26  L_L34  0.0666
K_K1525  L_L26  L_L35  0.0644
K_K1526  L_L26  L_L36  0.0600
K_K1527  L_L26  L_L37  0.0618
K_K1528  L_L26  L_L38  -0.1018
K_K1529  L_L26  L_L39  -0.0290
K_K1530  L_L26  L_L41  -0.0288
K_K1531  L_L26  L_L42  0.0825
K_K1532  L_L26  L_L43  0.1157
K_K1533  L_L26  L_L44  0.0767
K_K1534  L_L26  L_L45  0.0685
K_K1535  L_L26  L_L46  0.0357
K_K1536  L_L26  L_L47  0.0824
K_K1537  L_L26  L_L48  0.0384
K_K1538  L_L26  L_L49  0.0779
K_K1539  L_L26  L_L50  0.0328
K_K1540  L_L26  L_L51  0.0824
K_K1541  L_L26  L_L52  0.0299
K_K1542  L_L26  L_L53  0.1156
K_K1543  L_L26  L_L54  0.0416
K_K1544  L_L26  L_L55  0.1003
K_K1545  L_L26  L_L56  0.0346
K_K1546  L_L26  L_L57  0.1276
K_K1547  L_L26  L_L58  0.0273
K_K1548  L_L26  L_L59  0.0664
K_K1549  L_L26  L_L60  0.0338
K_K1550  L_L26  L_L61  0.0699
K_K1551  L_L26  L_L62  0.0229
K_K1552  L_L26  L_L63  0.0226
K_K1553  L_L26  L_L64  0.0218
K_K1554  L_L26  L_L65  0.0221
K_K1555  L_L26  L_L66  0.0216
K_K1556  L_L26  L_L67  0.0220
K_K1557  L_L26  L_L68  0.0213
K_K1558  L_L26  L_L69  0.0209
K_K1559  L_L26  L_L70  0.0140
K_K1560  L_L26  L_L71  0.0211
K_K1561  L_L26  L_L72  0.0138
K_K1562  L_L26  L_L73  0.0207
K_K1563  L_L26  L_L74  0.0138
K_K1564  L_L26  L_L75  0.0211
K_K1565  L_L26  L_L76  0.0140
K_K1566  L_L26  L_L77  0.0216
K_K1567  L_L26  L_L78  0.0141
K_K1568  L_L26  L_L79  0.0214
K_K1569  L_L26  L_L80  0.0139
K_K1570  L_L26  L_L81  0.0215
K_K1571  L_L26  L_L82  0.0137
K_K1572  L_L26  L_L83  0.0209
K_K1573  L_L26  L_L84  0.0139
K_K1574  L_L26  L_L85  0.0208
K_K1575  L_L26  L_L90  0.0108
K_K1576  L_L26  L_L91  0.0109
K_K1577  L_L26  L_L92  0.0108
K_K1578  L_L26  L_L93  0.0107
* *  Branch  N_C0_12 - N_C0_1
R_R27  N_C0_12  nR_27  145.206218m  TC=0,0
R_V85  nR_27  nV_85  1716.243046m  TC=0,0
L_V85  nR_27  nV_85  0.136028uH
R_V86  nV_85  nV_86  -1619.078956m  TC=0,0
L_V86  nV_85  nV_86  -0.135970uH
R_V87  nV_86  nV_87  537.962162m  TC=0,0
L_V87  nV_86  nV_87  0.216400uH
R_V88  nV_87  nV_88  -514.025827m  TC=0,0
L_V88  nV_87  nV_88  -0.218558uH
R_V89  nV_88  nV_89  252.446393m  TC=0,0
L_V89  nV_88  nV_89  0.448918uH
R_V90  nV_89  nV_90  -235.307304m  TC=0,0
L_V90  nV_89  nV_90  -0.433744uH
R_V91  nV_90  nV_91  -0.957781m  TC=0,0
L_V91  nV_90  nV_91  -0.006628uH
R_V92  nV_91  nV_92  5.534735m  TC=0,0
L_V92  nV_91  nV_92  0.056726uH
R_V93  nV_92  nV_93  -1.062476m  TC=0,0
L_V93  nV_92  nV_93  -0.041415uH
R_V94  nV_93  nV_94  2.054783m  TC=0,0
L_V94  nV_93  nV_94  0.166568uH
L_L27  nV_94  N_C0_1  2.364371uH
K_K1579  L_L27  L_L28  0.1572
K_K1580  L_L27  L_L29  0.2713
K_K1581  L_L27  L_L30  0.1499
K_K1582  L_L27  L_L31  0.2144
K_K1583  L_L27  L_L32  0.1778
K_K1584  L_L27  L_L33  0.2713
K_K1585  L_L27  L_L34  0.1340
K_K1586  L_L27  L_L35  0.2055
K_K1587  L_L27  L_L36  0.1165
K_K1588  L_L27  L_L37  0.1015
K_K1589  L_L27  L_L38  0.0760
K_K1590  L_L27  L_L39  0.0244
K_K1591  L_L27  L_L40  0.0236
K_K1592  L_L27  L_L41  0.0262
K_K1593  L_L27  L_L42  0.0210
K_K1594  L_L27  L_L43  0.0202
K_K1595  L_L27  L_L44  0.0184
K_K1596  L_L27  L_L45  0.0190
K_K1597  L_L27  L_L46  0.0104
K_K1598  L_L27  L_L47  0.0162
K_K1599  L_L27  L_L48  0.0101
K_K1600  L_L27  L_L49  0.0213
K_K1601  L_L27  L_L50  0.0104
K_K1602  L_L27  L_L51  0.0184
K_K1603  L_L27  L_L52  0.0107
K_K1604  L_L27  L_L53  0.0129
K_K1605  L_L27  L_L54  0.0105
K_K1606  L_L27  L_L55  0.0239
K_K1607  L_L27  L_L56  0.0101
K_K1608  L_L27  L_L57  0.0176
K_K1609  L_L27  L_L58  0.0102
K_K1610  L_L27  L_L59  0.0110
K_K1611  L_L27  L_L60  0.0106
K_K1612  L_L27  L_L61  0.0168
* *  Branch  N_C0_7 - N_C0_9
R_R28  N_C0_7  nR_28  0.941960m  TC=0,0
L_L28  nR_28  N_C0_9  2.100443uH
K_K1613  L_L28  L_L29  0.2102
K_K1614  L_L28  L_L30  0.1615
K_K1615  L_L28  L_L31  0.1778
K_K1616  L_L28  L_L32  0.0999
K_K1617  L_L28  L_L33  0.1499
K_K1618  L_L28  L_L34  0.0644
K_K1619  L_L28  L_L35  0.0600
K_K1620  L_L28  L_L36  0.0618
K_K1621  L_L28  L_L37  0.0666
K_K1622  L_L28  L_L38  -0.0288
K_K1623  L_L28  L_L39  -0.1018
K_K1624  L_L28  L_L40  -0.0290
K_K1625  L_L28  L_L42  0.0685
K_K1626  L_L28  L_L43  0.0825
K_K1627  L_L28  L_L44  0.1157
K_K1628  L_L28  L_L45  0.0767
K_K1629  L_L28  L_L46  0.0299
K_K1630  L_L28  L_L47  0.1156
K_K1631  L_L28  L_L48  0.0357
K_K1632  L_L28  L_L49  0.0824
K_K1633  L_L28  L_L50  0.0384
K_K1634  L_L28  L_L51  0.0779
K_K1635  L_L28  L_L52  0.0328
K_K1636  L_L28  L_L53  0.0824
K_K1637  L_L28  L_L54  0.0338
K_K1638  L_L28  L_L55  0.0699
K_K1639  L_L28  L_L56  0.0416
K_K1640  L_L28  L_L57  0.1003
K_K1641  L_L28  L_L58  0.0346
K_K1642  L_L28  L_L59  0.1276
K_K1643  L_L28  L_L60  0.0273
K_K1644  L_L28  L_L61  0.0664
K_K1645  L_L28  L_L62  0.0221
K_K1646  L_L28  L_L63  0.0229
K_K1647  L_L28  L_L64  0.0226
K_K1648  L_L28  L_L65  0.0218
K_K1649  L_L28  L_L66  0.0209
K_K1650  L_L28  L_L67  0.0216
K_K1651  L_L28  L_L68  0.0220
K_K1652  L_L28  L_L69  0.0213
K_K1653  L_L28  L_L70  0.0140
K_K1654  L_L28  L_L71  0.0216
K_K1655  L_L28  L_L72  0.0140
K_K1656  L_L28  L_L73  0.0211
K_K1657  L_L28  L_L74  0.0138
K_K1658  L_L28  L_L75  0.0207
K_K1659  L_L28  L_L76  0.0138
K_K1660  L_L28  L_L77  0.0211
K_K1661  L_L28  L_L78  0.0139
K_K1662  L_L28  L_L79  0.0208
K_K1663  L_L28  L_L80  0.0141
K_K1664  L_L28  L_L81  0.0214
K_K1665  L_L28  L_L82  0.0139
K_K1666  L_L28  L_L83  0.0215
K_K1667  L_L28  L_L84  0.0137
K_K1668  L_L28  L_L85  0.0209
K_K1669  L_L28  L_L90  0.0107
K_K1670  L_L28  L_L91  0.0108
K_K1671  L_L28  L_L92  0.0109
K_K1672  L_L28  L_L93  0.0108
* *  Branch  N_C0_9 - N_C0_2
R_R29  N_C0_9  nR_29  145.206218m  TC=0,0
R_V95  nR_29  nV_95  1716.243046m  TC=0,0
L_V95  nR_29  nV_95  0.136028uH
R_V96  nV_95  nV_96  -1619.078956m  TC=0,0
L_V96  nV_95  nV_96  -0.135970uH
R_V97  nV_96  nV_97  537.962162m  TC=0,0
L_V97  nV_96  nV_97  0.216400uH
R_V98  nV_97  nV_98  -514.025827m  TC=0,0
L_V98  nV_97  nV_98  -0.218558uH
R_V99  nV_98  nV_99  252.446393m  TC=0,0
L_V99  nV_98  nV_99  0.448918uH
R_V100  nV_99  nV_100  -235.307304m  TC=0,0
L_V100  nV_99  nV_100  -0.433744uH
R_V101  nV_100  nV_101  -0.957781m  TC=0,0
L_V101  nV_100  nV_101  -0.006628uH
R_V102  nV_101  nV_102  5.534735m  TC=0,0
L_V102  nV_101  nV_102  0.056726uH
R_V103  nV_102  nV_103  -1.062476m  TC=0,0
L_V103  nV_102  nV_103  -0.041415uH
R_V104  nV_103  nV_104  2.054783m  TC=0,0
L_V104  nV_103  nV_104  0.166568uH
L_L29  nV_104  N_C0_2  2.364371uH
K_K1673  L_L29  L_L30  0.1572
K_K1674  L_L29  L_L31  0.2713
K_K1675  L_L29  L_L32  0.1499
K_K1676  L_L29  L_L33  0.2144
K_K1677  L_L29  L_L34  0.2055
K_K1678  L_L29  L_L35  0.1165
K_K1679  L_L29  L_L36  0.1015
K_K1680  L_L29  L_L37  0.1340
K_K1681  L_L29  L_L38  0.0262
K_K1682  L_L29  L_L39  0.0760
K_K1683  L_L29  L_L40  0.0244
K_K1684  L_L29  L_L41  0.0236
K_K1685  L_L29  L_L42  0.0190
K_K1686  L_L29  L_L43  0.0210
K_K1687  L_L29  L_L44  0.0202
K_K1688  L_L29  L_L45  0.0184
K_K1689  L_L29  L_L46  0.0107
K_K1690  L_L29  L_L47  0.0129
K_K1691  L_L29  L_L48  0.0104
K_K1692  L_L29  L_L49  0.0162
K_K1693  L_L29  L_L50  0.0101
K_K1694  L_L29  L_L51  0.0213
K_K1695  L_L29  L_L52  0.0104
K_K1696  L_L29  L_L53  0.0184
K_K1697  L_L29  L_L54  0.0106
K_K1698  L_L29  L_L55  0.0168
K_K1699  L_L29  L_L56  0.0105
K_K1700  L_L29  L_L57  0.0239
K_K1701  L_L29  L_L58  0.0101
K_K1702  L_L29  L_L59  0.0176
K_K1703  L_L29  L_L60  0.0102
K_K1704  L_L29  L_L61  0.0110
* *  Branch  N_C0_8 - N_C0_10
R_R30  N_C0_8  nR_30  0.941960m  TC=0,0
L_L30  nR_30  N_C0_10  2.100443uH
K_K1705  L_L30  L_L31  0.2102
K_K1706  L_L30  L_L32  0.1615
K_K1707  L_L30  L_L33  0.1778
K_K1708  L_L30  L_L34  0.0600
K_K1709  L_L30  L_L35  0.0618
K_K1710  L_L30  L_L36  0.0666
K_K1711  L_L30  L_L37  0.0644
K_K1712  L_L30  L_L39  -0.0288
K_K1713  L_L30  L_L40  -0.1018
K_K1714  L_L30  L_L41  -0.0290
K_K1715  L_L30  L_L42  0.0767
K_K1716  L_L30  L_L43  0.0685
K_K1717  L_L30  L_L44  0.0825
K_K1718  L_L30  L_L45  0.1157
K_K1719  L_L30  L_L46  0.0328
K_K1720  L_L30  L_L47  0.0824
K_K1721  L_L30  L_L48  0.0299
K_K1722  L_L30  L_L49  0.1156
K_K1723  L_L30  L_L50  0.0357
K_K1724  L_L30  L_L51  0.0824
K_K1725  L_L30  L_L52  0.0384
K_K1726  L_L30  L_L53  0.0779
K_K1727  L_L30  L_L54  0.0273
K_K1728  L_L30  L_L55  0.0664
K_K1729  L_L30  L_L56  0.0338
K_K1730  L_L30  L_L57  0.0699
K_K1731  L_L30  L_L58  0.0416
K_K1732  L_L30  L_L59  0.1003
K_K1733  L_L30  L_L60  0.0346
K_K1734  L_L30  L_L61  0.1276
K_K1735  L_L30  L_L62  0.0218
K_K1736  L_L30  L_L63  0.0221
K_K1737  L_L30  L_L64  0.0229
K_K1738  L_L30  L_L65  0.0226
K_K1739  L_L30  L_L66  0.0213
K_K1740  L_L30  L_L67  0.0209
K_K1741  L_L30  L_L68  0.0216
K_K1742  L_L30  L_L69  0.0220
K_K1743  L_L30  L_L70  0.0138
K_K1744  L_L30  L_L71  0.0211
K_K1745  L_L30  L_L72  0.0140
K_K1746  L_L30  L_L73  0.0216
K_K1747  L_L30  L_L74  0.0140
K_K1748  L_L30  L_L75  0.0211
K_K1749  L_L30  L_L76  0.0138
K_K1750  L_L30  L_L77  0.0207
K_K1751  L_L30  L_L78  0.0137
K_K1752  L_L30  L_L79  0.0209
K_K1753  L_L30  L_L80  0.0139
K_K1754  L_L30  L_L81  0.0208
K_K1755  L_L30  L_L82  0.0141
K_K1756  L_L30  L_L83  0.0214
K_K1757  L_L30  L_L84  0.0139
K_K1758  L_L30  L_L85  0.0215
K_K1759  L_L30  L_L90  0.0108
K_K1760  L_L30  L_L91  0.0107
K_K1761  L_L30  L_L92  0.0108
K_K1762  L_L30  L_L93  0.0109
* *  Branch  N_C0_10 - N_C0_3
R_R31  N_C0_10  nR_31  145.206218m  TC=0,0
R_V105  nR_31  nV_105  1716.243046m  TC=0,0
L_V105  nR_31  nV_105  0.136028uH
R_V106  nV_105  nV_106  -1619.078956m  TC=0,0
L_V106  nV_105  nV_106  -0.135970uH
R_V107  nV_106  nV_107  537.962162m  TC=0,0
L_V107  nV_106  nV_107  0.216400uH
R_V108  nV_107  nV_108  -514.025827m  TC=0,0
L_V108  nV_107  nV_108  -0.218558uH
R_V109  nV_108  nV_109  252.446393m  TC=0,0
L_V109  nV_108  nV_109  0.448918uH
R_V110  nV_109  nV_110  -235.307304m  TC=0,0
L_V110  nV_109  nV_110  -0.433744uH
R_V111  nV_110  nV_111  -0.957781m  TC=0,0
L_V111  nV_110  nV_111  -0.006628uH
R_V112  nV_111  nV_112  5.534735m  TC=0,0
L_V112  nV_111  nV_112  0.056726uH
R_V113  nV_112  nV_113  -1.062476m  TC=0,0
L_V113  nV_112  nV_113  -0.041415uH
R_V114  nV_113  nV_114  2.054783m  TC=0,0
L_V114  nV_113  nV_114  0.166568uH
L_L31  nV_114  N_C0_3  2.364371uH
K_K1763  L_L31  L_L32  0.1572
K_K1764  L_L31  L_L33  0.2713
K_K1765  L_L31  L_L34  0.1165
K_K1766  L_L31  L_L35  0.1015
K_K1767  L_L31  L_L36  0.1340
K_K1768  L_L31  L_L37  0.2055
K_K1769  L_L31  L_L38  0.0236
K_K1770  L_L31  L_L39  0.0262
K_K1771  L_L31  L_L40  0.0760
K_K1772  L_L31  L_L41  0.0244
K_K1773  L_L31  L_L42  0.0184
K_K1774  L_L31  L_L43  0.0190
K_K1775  L_L31  L_L44  0.0210
K_K1776  L_L31  L_L45  0.0202
K_K1777  L_L31  L_L46  0.0104
K_K1778  L_L31  L_L47  0.0184
K_K1779  L_L31  L_L48  0.0107
K_K1780  L_L31  L_L49  0.0129
K_K1781  L_L31  L_L50  0.0104
K_K1782  L_L31  L_L51  0.0162
K_K1783  L_L31  L_L52  0.0101
K_K1784  L_L31  L_L53  0.0213
K_K1785  L_L31  L_L54  0.0102
K_K1786  L_L31  L_L55  0.0110
K_K1787  L_L31  L_L56  0.0106
K_K1788  L_L31  L_L57  0.0168
K_K1789  L_L31  L_L58  0.0105
K_K1790  L_L31  L_L59  0.0239
K_K1791  L_L31  L_L60  0.0101
K_K1792  L_L31  L_L61  0.0176
* *  Branch  N_C0_5 - N_C0_11
R_R32  N_C0_5  nR_32  0.941960m  TC=0,0
L_L32  nR_32  N_C0_11  2.100443uH
K_K1793  L_L32  L_L33  0.2102
K_K1794  L_L32  L_L34  0.0618
K_K1795  L_L32  L_L35  0.0666
K_K1796  L_L32  L_L36  0.0644
K_K1797  L_L32  L_L37  0.0600
K_K1798  L_L32  L_L38  -0.0290
K_K1799  L_L32  L_L40  -0.0288
K_K1800  L_L32  L_L41  -0.1018
K_K1801  L_L32  L_L42  0.1157
K_K1802  L_L32  L_L43  0.0767
K_K1803  L_L32  L_L44  0.0685
K_K1804  L_L32  L_L45  0.0825
K_K1805  L_L32  L_L46  0.0384
K_K1806  L_L32  L_L47  0.0779
K_K1807  L_L32  L_L48  0.0328
K_K1808  L_L32  L_L49  0.0824
K_K1809  L_L32  L_L50  0.0299
K_K1810  L_L32  L_L51  0.1156
K_K1811  L_L32  L_L52  0.0357
K_K1812  L_L32  L_L53  0.0824
K_K1813  L_L32  L_L54  0.0346
K_K1814  L_L32  L_L55  0.1276
K_K1815  L_L32  L_L56  0.0273
K_K1816  L_L32  L_L57  0.0664
K_K1817  L_L32  L_L58  0.0338
K_K1818  L_L32  L_L59  0.0699
K_K1819  L_L32  L_L60  0.0416
K_K1820  L_L32  L_L61  0.1003
K_K1821  L_L32  L_L62  0.0226
K_K1822  L_L32  L_L63  0.0218
K_K1823  L_L32  L_L64  0.0221
K_K1824  L_L32  L_L65  0.0229
K_K1825  L_L32  L_L66  0.0220
K_K1826  L_L32  L_L67  0.0213
K_K1827  L_L32  L_L68  0.0209
K_K1828  L_L32  L_L69  0.0216
K_K1829  L_L32  L_L70  0.0138
K_K1830  L_L32  L_L71  0.0207
K_K1831  L_L32  L_L72  0.0138
K_K1832  L_L32  L_L73  0.0211
K_K1833  L_L32  L_L74  0.0140
K_K1834  L_L32  L_L75  0.0216
K_K1835  L_L32  L_L76  0.0140
K_K1836  L_L32  L_L77  0.0211
K_K1837  L_L32  L_L78  0.0139
K_K1838  L_L32  L_L79  0.0215
K_K1839  L_L32  L_L80  0.0137
K_K1840  L_L32  L_L81  0.0209
K_K1841  L_L32  L_L82  0.0139
K_K1842  L_L32  L_L83  0.0208
K_K1843  L_L32  L_L84  0.0141
K_K1844  L_L32  L_L85  0.0214
K_K1845  L_L32  L_L90  0.0109
K_K1846  L_L32  L_L91  0.0108
K_K1847  L_L32  L_L92  0.0107
K_K1848  L_L32  L_L93  0.0108
* *  Branch  N_C0_11 - N_C0_4
R_R33  N_C0_11  nR_33  145.206218m  TC=0,0
R_V115  nR_33  nV_115  1716.243046m  TC=0,0
L_V115  nR_33  nV_115  0.136028uH
R_V116  nV_115  nV_116  -1619.078956m  TC=0,0
L_V116  nV_115  nV_116  -0.135970uH
R_V117  nV_116  nV_117  537.962162m  TC=0,0
L_V117  nV_116  nV_117  0.216400uH
R_V118  nV_117  nV_118  -514.025827m  TC=0,0
L_V118  nV_117  nV_118  -0.218558uH
R_V119  nV_118  nV_119  252.446393m  TC=0,0
L_V119  nV_118  nV_119  0.448918uH
R_V120  nV_119  nV_120  -235.307304m  TC=0,0
L_V120  nV_119  nV_120  -0.433744uH
R_V121  nV_120  nV_121  -0.957781m  TC=0,0
L_V121  nV_120  nV_121  -0.006628uH
R_V122  nV_121  nV_122  5.534735m  TC=0,0
L_V122  nV_121  nV_122  0.056726uH
R_V123  nV_122  nV_123  -1.062476m  TC=0,0
L_V123  nV_122  nV_123  -0.041415uH
R_V124  nV_123  nV_124  2.054783m  TC=0,0
L_V124  nV_123  nV_124  0.166568uH
L_L33  nV_124  N_C0_4  2.364371uH
K_K1849  L_L33  L_L34  0.1015
K_K1850  L_L33  L_L35  0.1340
K_K1851  L_L33  L_L36  0.2055
K_K1852  L_L33  L_L37  0.1165
K_K1853  L_L33  L_L38  0.0244
K_K1854  L_L33  L_L39  0.0236
K_K1855  L_L33  L_L40  0.0262
K_K1856  L_L33  L_L41  0.0760
K_K1857  L_L33  L_L42  0.0202
K_K1858  L_L33  L_L43  0.0184
K_K1859  L_L33  L_L44  0.0190
K_K1860  L_L33  L_L45  0.0210
K_K1861  L_L33  L_L46  0.0101
K_K1862  L_L33  L_L47  0.0213
K_K1863  L_L33  L_L48  0.0104
K_K1864  L_L33  L_L49  0.0184
K_K1865  L_L33  L_L50  0.0107
K_K1866  L_L33  L_L51  0.0129
K_K1867  L_L33  L_L52  0.0104
K_K1868  L_L33  L_L53  0.0162
K_K1869  L_L33  L_L54  0.0101
K_K1870  L_L33  L_L55  0.0176
K_K1871  L_L33  L_L56  0.0102
K_K1872  L_L33  L_L57  0.0110
K_K1873  L_L33  L_L58  0.0106
K_K1874  L_L33  L_L59  0.0168
K_K1875  L_L33  L_L60  0.0105
K_K1876  L_L33  L_L61  0.0239
* *  Branch  N_C0_2 - J1
R_R34  N_C0_2  nR_34  0.003609m  TC=0,0
L_L34  nR_34  J1  0.000193uH
* *  Branch  N_C0_1 - J4
R_R35  N_C0_1  nR_35  0.003609m  TC=0,0
L_L35  nR_35  J4  0.000193uH
* *  Branch  N_C0_4 - J3
R_R36  N_C0_4  nR_36  0.003609m  TC=0,0
L_L36  nR_36  J3  0.000193uH
* *  Branch  N_C0_3 - J2
R_R37  N_C0_3  nR_37  0.003609m  TC=0,0
L_L37  nR_37  J2  0.000193uH
* *  Branch  N_C0_5 - N_C0_6
R_R38  N_C0_5  nR_38  0.541340m  TC=0,0
L_L38  nR_38  N_C0_6  1.072056uH
K_K1877  L_L38  L_L39  -0.0205
K_K1878  L_L38  L_L40  -0.1511
K_K1879  L_L38  L_L41  -0.0205
K_K1880  L_L38  L_L42  -0.0266
K_K1881  L_L38  L_L43  -0.0266
K_K1882  L_L38  L_L44  -0.0265
K_K1883  L_L38  L_L45  -0.0265
K_K1884  L_L38  L_L46  -0.0185
K_K1885  L_L38  L_L47  -0.0224
K_K1886  L_L38  L_L48  -0.0370
K_K1887  L_L38  L_L49  -0.0585
K_K1888  L_L38  L_L50  -0.0184
K_K1889  L_L38  L_L51  -0.0225
K_K1890  L_L38  L_L53  0.0494
K_K1891  L_L38  L_L54  -0.0388
K_K1892  L_L38  L_L55  -0.0946
K_K1893  L_L38  L_L56  -0.0184
K_K1894  L_L38  L_L57  -0.0225
K_K1895  L_L38  L_L59  0.0137
K_K1896  L_L38  L_L60  -0.0185
K_K1897  L_L38  L_L61  -0.0224
K_K1898  L_L38  L_L62  0.0280
K_K1899  L_L38  L_L63  0.0271
K_K1900  L_L38  L_L64  0.0263
K_K1901  L_L38  L_L65  0.0271
K_K1902  L_L38  L_L66  -0.0190
K_K1903  L_L38  L_L67  -0.0190
K_K1904  L_L38  L_L68  -0.0189
K_K1905  L_L38  L_L69  -0.0189
K_K1906  L_L38  L_L70  0.0159
K_K1907  L_L38  L_L71  -0.0156
K_K1908  L_L38  L_L72  0.0156
K_K1909  L_L38  L_L73  -0.0272
K_K1910  L_L38  L_L74  0.0157
K_K1911  L_L38  L_L75  -0.0156
K_K1912  L_L38  L_L76  0.0160
K_K1913  L_L38  L_L78  0.0160
K_K1914  L_L38  L_L79  -0.0276
K_K1915  L_L38  L_L80  0.0157
K_K1916  L_L38  L_L81  -0.0156
K_K1917  L_L38  L_L82  0.0156
K_K1918  L_L38  L_L84  0.0159
K_K1919  L_L38  L_L85  -0.0156
K_K1920  L_L38  L_L86  0.0105
K_K1921  L_L38  L_L87  0.0104
K_K1922  L_L38  L_L88  0.0103
K_K1923  L_L38  L_L89  0.0104
K_K1924  L_L38  L_L90  0.0120
K_K1925  L_L38  L_L91  0.0120
K_K1926  L_L38  L_L92  0.0119
K_K1927  L_L38  L_L93  0.0119
K_K1928  L_L38  L_L95  0.0109
K_K1929  L_L38  L_L97  0.0108
K_K1930  L_L38  L_L99  0.0109
K_K1931  L_L38  L_L101  0.0110
K_K1932  L_L38  L_L103  0.0110
K_K1933  L_L38  L_L105  0.0109
K_K1934  L_L38  L_L107  0.0108
K_K1935  L_L38  L_L109  0.0109
* *  Branch  N_C0_6 - N_C0_7
R_R39  N_C0_6  nR_39  0.541340m  TC=0,0
L_L39  nR_39  N_C0_7  1.072056uH
K_K1936  L_L39  L_L40  -0.0205
K_K1937  L_L39  L_L41  -0.1511
K_K1938  L_L39  L_L42  -0.0265
K_K1939  L_L39  L_L43  -0.0266
K_K1940  L_L39  L_L44  -0.0266
K_K1941  L_L39  L_L45  -0.0265
K_K1942  L_L39  L_L47  0.0494
K_K1943  L_L39  L_L48  -0.0185
K_K1944  L_L39  L_L49  -0.0224
K_K1945  L_L39  L_L50  -0.0370
K_K1946  L_L39  L_L51  -0.0585
K_K1947  L_L39  L_L52  -0.0184
K_K1948  L_L39  L_L53  -0.0225
K_K1949  L_L39  L_L54  -0.0185
K_K1950  L_L39  L_L55  -0.0224
K_K1951  L_L39  L_L56  -0.0388
K_K1952  L_L39  L_L57  -0.0946
K_K1953  L_L39  L_L58  -0.0184
K_K1954  L_L39  L_L59  -0.0225
K_K1955  L_L39  L_L61  0.0137
K_K1956  L_L39  L_L62  0.0271
K_K1957  L_L39  L_L63  0.0280
K_K1958  L_L39  L_L64  0.0271
K_K1959  L_L39  L_L65  0.0263
K_K1960  L_L39  L_L66  -0.0189
K_K1961  L_L39  L_L67  -0.0190
K_K1962  L_L39  L_L68  -0.0190
K_K1963  L_L39  L_L69  -0.0189
K_K1964  L_L39  L_L70  0.0160
K_K1965  L_L39  L_L72  0.0159
K_K1966  L_L39  L_L73  -0.0156
K_K1967  L_L39  L_L74  0.0156
K_K1968  L_L39  L_L75  -0.0272
K_K1969  L_L39  L_L76  0.0157
K_K1970  L_L39  L_L77  -0.0156
K_K1971  L_L39  L_L78  0.0159
K_K1972  L_L39  L_L79  -0.0156
K_K1973  L_L39  L_L80  0.0160
K_K1974  L_L39  L_L81  -0.0276
K_K1975  L_L39  L_L82  0.0157
K_K1976  L_L39  L_L83  -0.0156
K_K1977  L_L39  L_L84  0.0156
K_K1978  L_L39  L_L86  0.0104
K_K1979  L_L39  L_L87  0.0105
K_K1980  L_L39  L_L88  0.0104
K_K1981  L_L39  L_L89  0.0103
K_K1982  L_L39  L_L90  0.0119
K_K1983  L_L39  L_L91  0.0120
K_K1984  L_L39  L_L92  0.0120
K_K1985  L_L39  L_L93  0.0119
K_K1986  L_L39  L_L95  0.0110
K_K1987  L_L39  L_L97  0.0109
K_K1988  L_L39  L_L99  0.0108
K_K1989  L_L39  L_L101  0.0109
K_K1990  L_L39  L_L103  0.0109
K_K1991  L_L39  L_L105  0.0110
K_K1992  L_L39  L_L107  0.0109
K_K1993  L_L39  L_L109  0.0108
* *  Branch  N_C0_7 - N_C0_8
R_R40  N_C0_7  nR_40  0.541340m  TC=0,0
L_L40  nR_40  N_C0_8  1.072056uH
K_K1994  L_L40  L_L41  -0.0205
K_K1995  L_L40  L_L42  -0.0265
K_K1996  L_L40  L_L43  -0.0265
K_K1997  L_L40  L_L44  -0.0266
K_K1998  L_L40  L_L45  -0.0266
K_K1999  L_L40  L_L46  -0.0184
K_K2000  L_L40  L_L47  -0.0225
K_K2001  L_L40  L_L49  0.0494
K_K2002  L_L40  L_L50  -0.0185
K_K2003  L_L40  L_L51  -0.0224
K_K2004  L_L40  L_L52  -0.0370
K_K2005  L_L40  L_L53  -0.0585
K_K2006  L_L40  L_L55  0.0137
K_K2007  L_L40  L_L56  -0.0185
K_K2008  L_L40  L_L57  -0.0224
K_K2009  L_L40  L_L58  -0.0388
K_K2010  L_L40  L_L59  -0.0946
K_K2011  L_L40  L_L60  -0.0184
K_K2012  L_L40  L_L61  -0.0225
K_K2013  L_L40  L_L62  0.0263
K_K2014  L_L40  L_L63  0.0271
K_K2015  L_L40  L_L64  0.0280
K_K2016  L_L40  L_L65  0.0271
K_K2017  L_L40  L_L66  -0.0189
K_K2018  L_L40  L_L67  -0.0189
K_K2019  L_L40  L_L68  -0.0190
K_K2020  L_L40  L_L69  -0.0190
K_K2021  L_L40  L_L70  0.0157
K_K2022  L_L40  L_L71  -0.0156
K_K2023  L_L40  L_L72  0.0160
K_K2024  L_L40  L_L74  0.0159
K_K2025  L_L40  L_L75  -0.0156
K_K2026  L_L40  L_L76  0.0156
K_K2027  L_L40  L_L77  -0.0272
K_K2028  L_L40  L_L78  0.0156
K_K2029  L_L40  L_L80  0.0159
K_K2030  L_L40  L_L81  -0.0156
K_K2031  L_L40  L_L82  0.0160
K_K2032  L_L40  L_L83  -0.0276
K_K2033  L_L40  L_L84  0.0157
K_K2034  L_L40  L_L85  -0.0156
K_K2035  L_L40  L_L86  0.0103
K_K2036  L_L40  L_L87  0.0104
K_K2037  L_L40  L_L88  0.0105
K_K2038  L_L40  L_L89  0.0104
K_K2039  L_L40  L_L90  0.0119
K_K2040  L_L40  L_L91  0.0119
K_K2041  L_L40  L_L92  0.0120
K_K2042  L_L40  L_L93  0.0120
K_K2043  L_L40  L_L95  0.0109
K_K2044  L_L40  L_L97  0.0110
K_K2045  L_L40  L_L99  0.0109
K_K2046  L_L40  L_L101  0.0108
K_K2047  L_L40  L_L103  0.0108
K_K2048  L_L40  L_L105  0.0109
K_K2049  L_L40  L_L107  0.0110
K_K2050  L_L40  L_L109  0.0109
* *  Branch  N_C0_8 - N_C0_5
R_R41  N_C0_8  nR_41  0.541340m  TC=0,0
L_L41  nR_41  N_C0_5  1.072056uH
K_K2051  L_L41  L_L42  -0.0266
K_K2052  L_L41  L_L43  -0.0265
K_K2053  L_L41  L_L44  -0.0265
K_K2054  L_L41  L_L45  -0.0266
K_K2055  L_L41  L_L46  -0.0370
K_K2056  L_L41  L_L47  -0.0585
K_K2057  L_L41  L_L48  -0.0184
K_K2058  L_L41  L_L49  -0.0225
K_K2059  L_L41  L_L51  0.0494
K_K2060  L_L41  L_L52  -0.0185
K_K2061  L_L41  L_L53  -0.0224
K_K2062  L_L41  L_L54  -0.0184
K_K2063  L_L41  L_L55  -0.0225
K_K2064  L_L41  L_L57  0.0137
K_K2065  L_L41  L_L58  -0.0185
K_K2066  L_L41  L_L59  -0.0224
K_K2067  L_L41  L_L60  -0.0388
K_K2068  L_L41  L_L61  -0.0946
K_K2069  L_L41  L_L62  0.0271
K_K2070  L_L41  L_L63  0.0263
K_K2071  L_L41  L_L64  0.0271
K_K2072  L_L41  L_L65  0.0280
K_K2073  L_L41  L_L66  -0.0190
K_K2074  L_L41  L_L67  -0.0189
K_K2075  L_L41  L_L68  -0.0189
K_K2076  L_L41  L_L69  -0.0190
K_K2077  L_L41  L_L70  0.0156
K_K2078  L_L41  L_L71  -0.0272
K_K2079  L_L41  L_L72  0.0157
K_K2080  L_L41  L_L73  -0.0156
K_K2081  L_L41  L_L74  0.0160
K_K2082  L_L41  L_L76  0.0159
K_K2083  L_L41  L_L77  -0.0156
K_K2084  L_L41  L_L78  0.0157
K_K2085  L_L41  L_L79  -0.0156
K_K2086  L_L41  L_L80  0.0156
K_K2087  L_L41  L_L82  0.0159
K_K2088  L_L41  L_L83  -0.0156
K_K2089  L_L41  L_L84  0.0160
K_K2090  L_L41  L_L85  -0.0276
K_K2091  L_L41  L_L86  0.0104
K_K2092  L_L41  L_L87  0.0103
K_K2093  L_L41  L_L88  0.0104
K_K2094  L_L41  L_L89  0.0105
K_K2095  L_L41  L_L90  0.0120
K_K2096  L_L41  L_L91  0.0119
K_K2097  L_L41  L_L92  0.0119
K_K2098  L_L41  L_L93  0.0120
K_K2099  L_L41  L_L95  0.0108
K_K2100  L_L41  L_L97  0.0109
K_K2101  L_L41  L_L99  0.0110
K_K2102  L_L41  L_L101  0.0109
K_K2103  L_L41  L_L103  0.0109
K_K2104  L_L41  L_L105  0.0108
K_K2105  L_L41  L_L107  0.0109
K_K2106  L_L41  L_L109  0.0110
* *  Branch  N_C0_17 - N_C0_5
R_R42  N_C0_17  nR_42  280.220642m  TC=0,0
R_V125  nR_42  nV_125  3312.024205m  TC=0,0
L_V125  nR_42  nV_125  0.262509uH
R_V126  nV_125  nV_126  -3124.515817m  TC=0,0
L_V126  nV_125  nV_126  -0.262397uH
R_V127  nV_126  nV_127  1038.166027m  TC=0,0
L_V127  nV_126  nV_127  0.417612uH
R_V128  nV_127  nV_128  -991.973409m  TC=0,0
L_V128  nV_127  nV_128  -0.421775uH
R_V129  nV_128  nV_129  487.173540m  TC=0,0
L_V129  nV_128  nV_129  0.866327uH
R_V130  nV_129  nV_130  -454.098326m  TC=0,0
L_V130  nV_129  nV_130  -0.837043uH
R_V131  nV_130  nV_131  -1.848336m  TC=0,0
L_V131  nV_130  nV_131  -0.012791uH
R_V132  nV_131  nV_132  10.680996m  TC=0,0
L_V132  nV_131  nV_132  0.109470uH
R_V133  nV_132  nV_133  -2.050378m  TC=0,0
L_V133  nV_132  nV_133  -0.079923uH
R_V134  nV_133  nV_134  3.965345m  TC=0,0
L_V134  nV_133  nV_134  0.321445uH
L_L42  nV_134  N_C0_5  4.566075uH
K_K2107  L_L42  L_L43  0.2215
K_K2108  L_L42  L_L44  0.1682
K_K2109  L_L42  L_L45  0.2215
K_K2110  L_L42  L_L46  0.1572
K_K2111  L_L42  L_L47  0.1337
K_K2112  L_L42  L_L48  0.1376
K_K2113  L_L42  L_L49  0.1533
K_K2114  L_L42  L_L50  0.2039
K_K2115  L_L42  L_L51  0.3870
K_K2116  L_L42  L_L52  0.3901
K_K2117  L_L42  L_L53  0.2001
K_K2118  L_L42  L_L54  0.2039
K_K2119  L_L42  L_L55  0.3870
K_K2120  L_L42  L_L56  0.1376
K_K2121  L_L42  L_L57  0.1533
K_K2122  L_L42  L_L58  0.1572
K_K2123  L_L42  L_L59  0.1337
K_K2124  L_L42  L_L60  0.3901
K_K2125  L_L42  L_L61  0.2001
K_K2126  L_L42  L_L62  -0.0190
K_K2127  L_L42  L_L63  -0.0190
K_K2128  L_L42  L_L64  -0.0190
K_K2129  L_L42  L_L65  -0.0190
K_K2130  L_L42  L_L66  0.1231
K_K2131  L_L42  L_L67  0.0949
K_K2132  L_L42  L_L68  0.0850
K_K2133  L_L42  L_L69  0.0949
K_K2134  L_L42  L_L70  0.0469
K_K2135  L_L42  L_L71  0.0815
K_K2136  L_L42  L_L72  0.0460
K_K2137  L_L42  L_L73  0.0897
K_K2138  L_L42  L_L74  0.0485
K_K2139  L_L42  L_L75  0.1285
K_K2140  L_L42  L_L76  0.0496
K_K2141  L_L42  L_L77  0.0956
K_K2142  L_L42  L_L78  0.0485
K_K2143  L_L42  L_L79  0.1285
K_K2144  L_L42  L_L80  0.0460
K_K2145  L_L42  L_L81  0.0897
K_K2146  L_L42  L_L82  0.0469
K_K2147  L_L42  L_L83  0.0815
K_K2148  L_L42  L_L84  0.0496
K_K2149  L_L42  L_L85  0.0956
K_K2150  L_L42  L_L86  0.0298
K_K2151  L_L42  L_L87  0.0290
K_K2152  L_L42  L_L88  0.0290
K_K2153  L_L42  L_L89  0.0298
K_K2154  L_L42  L_L90  0.0352
K_K2155  L_L42  L_L91  0.0345
K_K2156  L_L42  L_L92  0.0337
K_K2157  L_L42  L_L93  0.0345
K_K2158  L_L42  L_L94  0.0211
K_K2159  L_L42  L_L95  0.0295
K_K2160  L_L42  L_L96  0.0210
K_K2161  L_L42  L_L97  0.0298
K_K2162  L_L42  L_L98  0.0213
K_K2163  L_L42  L_L99  0.0304
K_K2164  L_L42  L_L100  0.0214
K_K2165  L_L42  L_L101  0.0301
K_K2166  L_L42  L_L102  0.0213
K_K2167  L_L42  L_L103  0.0304
K_K2168  L_L42  L_L104  0.0210
K_K2169  L_L42  L_L105  0.0298
K_K2170  L_L42  L_L106  0.0211
K_K2171  L_L42  L_L107  0.0295
K_K2172  L_L42  L_L108  0.0214
K_K2173  L_L42  L_L109  0.0301
K_K2174  L_L42  L_L110  0.0147
K_K2175  L_L42  L_L111  0.0114
K_K2176  L_L42  L_L112  0.0113
K_K2177  L_L42  L_L113  0.0146
K_K2178  L_L42  L_L114  0.0147
K_K2179  L_L42  L_L115  0.0130
K_K2180  L_L42  L_L116  0.0129
K_K2181  L_L42  L_L117  0.0129
K_K2182  L_L42  L_L118  0.0129
K_K2183  L_L42  L_L119  0.0164
* *  Branch  N_C0_18 - N_C0_6
R_R43  N_C0_18  nR_43  280.220642m  TC=0,0
R_V135  nR_43  nV_135  3312.024205m  TC=0,0
L_V135  nR_43  nV_135  0.262509uH
R_V136  nV_135  nV_136  -3124.515817m  TC=0,0
L_V136  nV_135  nV_136  -0.262397uH
R_V137  nV_136  nV_137  1038.166027m  TC=0,0
L_V137  nV_136  nV_137  0.417612uH
R_V138  nV_137  nV_138  -991.973409m  TC=0,0
L_V138  nV_137  nV_138  -0.421775uH
R_V139  nV_138  nV_139  487.173540m  TC=0,0
L_V139  nV_138  nV_139  0.866327uH
R_V140  nV_139  nV_140  -454.098326m  TC=0,0
L_V140  nV_139  nV_140  -0.837043uH
R_V141  nV_140  nV_141  -1.848336m  TC=0,0
L_V141  nV_140  nV_141  -0.012791uH
R_V142  nV_141  nV_142  10.680996m  TC=0,0
L_V142  nV_141  nV_142  0.109470uH
R_V143  nV_142  nV_143  -2.050378m  TC=0,0
L_V143  nV_142  nV_143  -0.079923uH
R_V144  nV_143  nV_144  3.965345m  TC=0,0
L_V144  nV_143  nV_144  0.321445uH
L_L43  nV_144  N_C0_6  4.566075uH
K_K2184  L_L43  L_L44  0.2215
K_K2185  L_L43  L_L45  0.1682
K_K2186  L_L43  L_L46  0.3901
K_K2187  L_L43  L_L47  0.2001
K_K2188  L_L43  L_L48  0.1572
K_K2189  L_L43  L_L49  0.1337
K_K2190  L_L43  L_L50  0.1376
K_K2191  L_L43  L_L51  0.1533
K_K2192  L_L43  L_L52  0.2039
K_K2193  L_L43  L_L53  0.3870
K_K2194  L_L43  L_L54  0.3901
K_K2195  L_L43  L_L55  0.2001
K_K2196  L_L43  L_L56  0.2039
K_K2197  L_L43  L_L57  0.3870
K_K2198  L_L43  L_L58  0.1376
K_K2199  L_L43  L_L59  0.1533
K_K2200  L_L43  L_L60  0.1572
K_K2201  L_L43  L_L61  0.1337
K_K2202  L_L43  L_L62  -0.0190
K_K2203  L_L43  L_L63  -0.0190
K_K2204  L_L43  L_L64  -0.0190
K_K2205  L_L43  L_L65  -0.0190
K_K2206  L_L43  L_L66  0.0949
K_K2207  L_L43  L_L67  0.1231
K_K2208  L_L43  L_L68  0.0949
K_K2209  L_L43  L_L69  0.0850
K_K2210  L_L43  L_L70  0.0496
K_K2211  L_L43  L_L71  0.0956
K_K2212  L_L43  L_L72  0.0469
K_K2213  L_L43  L_L73  0.0815
K_K2214  L_L43  L_L74  0.0460
K_K2215  L_L43  L_L75  0.0897
K_K2216  L_L43  L_L76  0.0485
K_K2217  L_L43  L_L77  0.1285
K_K2218  L_L43  L_L78  0.0496
K_K2219  L_L43  L_L79  0.0956
K_K2220  L_L43  L_L80  0.0485
K_K2221  L_L43  L_L81  0.1285
K_K2222  L_L43  L_L82  0.0460
K_K2223  L_L43  L_L83  0.0897
K_K2224  L_L43  L_L84  0.0469
K_K2225  L_L43  L_L85  0.0815
K_K2226  L_L43  L_L86  0.0298
K_K2227  L_L43  L_L87  0.0298
K_K2228  L_L43  L_L88  0.0290
K_K2229  L_L43  L_L89  0.0290
K_K2230  L_L43  L_L90  0.0345
K_K2231  L_L43  L_L91  0.0352
K_K2232  L_L43  L_L92  0.0345
K_K2233  L_L43  L_L93  0.0337
K_K2234  L_L43  L_L94  0.0214
K_K2235  L_L43  L_L95  0.0301
K_K2236  L_L43  L_L96  0.0211
K_K2237  L_L43  L_L97  0.0295
K_K2238  L_L43  L_L98  0.0210
K_K2239  L_L43  L_L99  0.0298
K_K2240  L_L43  L_L100  0.0213
K_K2241  L_L43  L_L101  0.0304
K_K2242  L_L43  L_L102  0.0214
K_K2243  L_L43  L_L103  0.0301
K_K2244  L_L43  L_L104  0.0213
K_K2245  L_L43  L_L105  0.0304
K_K2246  L_L43  L_L106  0.0210
K_K2247  L_L43  L_L107  0.0298
K_K2248  L_L43  L_L108  0.0211
K_K2249  L_L43  L_L109  0.0295
K_K2250  L_L43  L_L110  0.0147
K_K2251  L_L43  L_L111  0.0115
K_K2252  L_L43  L_L112  0.0115
K_K2253  L_L43  L_L113  0.0146
K_K2254  L_L43  L_L114  0.0146
K_K2255  L_L43  L_L115  0.0129
K_K2256  L_L43  L_L116  0.0129
K_K2257  L_L43  L_L117  0.0130
K_K2258  L_L43  L_L118  0.0129
K_K2259  L_L43  L_L119  0.0164
* *  Branch  N_C0_19 - N_C0_7
R_R44  N_C0_19  nR_44  280.220642m  TC=0,0
R_V145  nR_44  nV_145  3312.024205m  TC=0,0
L_V145  nR_44  nV_145  0.262509uH
R_V146  nV_145  nV_146  -3124.515817m  TC=0,0
L_V146  nV_145  nV_146  -0.262397uH
R_V147  nV_146  nV_147  1038.166027m  TC=0,0
L_V147  nV_146  nV_147  0.417612uH
R_V148  nV_147  nV_148  -991.973409m  TC=0,0
L_V148  nV_147  nV_148  -0.421775uH
R_V149  nV_148  nV_149  487.173540m  TC=0,0
L_V149  nV_148  nV_149  0.866327uH
R_V150  nV_149  nV_150  -454.098326m  TC=0,0
L_V150  nV_149  nV_150  -0.837043uH
R_V151  nV_150  nV_151  -1.848336m  TC=0,0
L_V151  nV_150  nV_151  -0.012791uH
R_V152  nV_151  nV_152  10.680996m  TC=0,0
L_V152  nV_151  nV_152  0.109470uH
R_V153  nV_152  nV_153  -2.050378m  TC=0,0
L_V153  nV_152  nV_153  -0.079923uH
R_V154  nV_153  nV_154  3.965345m  TC=0,0
L_V154  nV_153  nV_154  0.321445uH
L_L44  nV_154  N_C0_7  4.566075uH
K_K2260  L_L44  L_L45  0.2215
K_K2261  L_L44  L_L46  0.2039
K_K2262  L_L44  L_L47  0.3870
K_K2263  L_L44  L_L48  0.3901
K_K2264  L_L44  L_L49  0.2001
K_K2265  L_L44  L_L50  0.1572
K_K2266  L_L44  L_L51  0.1337
K_K2267  L_L44  L_L52  0.1376
K_K2268  L_L44  L_L53  0.1533
K_K2269  L_L44  L_L54  0.1572
K_K2270  L_L44  L_L55  0.1337
K_K2271  L_L44  L_L56  0.3901
K_K2272  L_L44  L_L57  0.2001
K_K2273  L_L44  L_L58  0.2039
K_K2274  L_L44  L_L59  0.3870
K_K2275  L_L44  L_L60  0.1376
K_K2276  L_L44  L_L61  0.1533
K_K2277  L_L44  L_L62  -0.0190
K_K2278  L_L44  L_L63  -0.0190
K_K2279  L_L44  L_L64  -0.0190
K_K2280  L_L44  L_L65  -0.0190
K_K2281  L_L44  L_L66  0.0850
K_K2282  L_L44  L_L67  0.0949
K_K2283  L_L44  L_L68  0.1231
K_K2284  L_L44  L_L69  0.0949
K_K2285  L_L44  L_L70  0.0485
K_K2286  L_L44  L_L71  0.1285
K_K2287  L_L44  L_L72  0.0496
K_K2288  L_L44  L_L73  0.0956
K_K2289  L_L44  L_L74  0.0469
K_K2290  L_L44  L_L75  0.0815
K_K2291  L_L44  L_L76  0.0460
K_K2292  L_L44  L_L77  0.0897
K_K2293  L_L44  L_L78  0.0469
K_K2294  L_L44  L_L79  0.0815
K_K2295  L_L44  L_L80  0.0496
K_K2296  L_L44  L_L81  0.0956
K_K2297  L_L44  L_L82  0.0485
K_K2298  L_L44  L_L83  0.1285
K_K2299  L_L44  L_L84  0.0460
K_K2300  L_L44  L_L85  0.0897
K_K2301  L_L44  L_L86  0.0290
K_K2302  L_L44  L_L87  0.0298
K_K2303  L_L44  L_L88  0.0298
K_K2304  L_L44  L_L89  0.0290
K_K2305  L_L44  L_L90  0.0337
K_K2306  L_L44  L_L91  0.0345
K_K2307  L_L44  L_L92  0.0352
K_K2308  L_L44  L_L93  0.0345
K_K2309  L_L44  L_L94  0.0213
K_K2310  L_L44  L_L95  0.0304
K_K2311  L_L44  L_L96  0.0214
K_K2312  L_L44  L_L97  0.0301
K_K2313  L_L44  L_L98  0.0211
K_K2314  L_L44  L_L99  0.0295
K_K2315  L_L44  L_L100  0.0210
K_K2316  L_L44  L_L101  0.0298
K_K2317  L_L44  L_L102  0.0211
K_K2318  L_L44  L_L103  0.0295
K_K2319  L_L44  L_L104  0.0214
K_K2320  L_L44  L_L105  0.0301
K_K2321  L_L44  L_L106  0.0213
K_K2322  L_L44  L_L107  0.0304
K_K2323  L_L44  L_L108  0.0210
K_K2324  L_L44  L_L109  0.0298
K_K2325  L_L44  L_L110  0.0146
K_K2326  L_L44  L_L111  0.0115
K_K2327  L_L44  L_L112  0.0115
K_K2328  L_L44  L_L113  0.0147
K_K2329  L_L44  L_L114  0.0146
K_K2330  L_L44  L_L115  0.0129
K_K2331  L_L44  L_L116  0.0130
K_K2332  L_L44  L_L117  0.0129
K_K2333  L_L44  L_L118  0.0129
K_K2334  L_L44  L_L119  0.0164
* *  Branch  N_C0_20 - N_C0_8
R_R45  N_C0_20  nR_45  280.220642m  TC=0,0
R_V155  nR_45  nV_155  3312.024205m  TC=0,0
L_V155  nR_45  nV_155  0.262509uH
R_V156  nV_155  nV_156  -3124.515817m  TC=0,0
L_V156  nV_155  nV_156  -0.262397uH
R_V157  nV_156  nV_157  1038.166027m  TC=0,0
L_V157  nV_156  nV_157  0.417612uH
R_V158  nV_157  nV_158  -991.973409m  TC=0,0
L_V158  nV_157  nV_158  -0.421775uH
R_V159  nV_158  nV_159  487.173540m  TC=0,0
L_V159  nV_158  nV_159  0.866327uH
R_V160  nV_159  nV_160  -454.098326m  TC=0,0
L_V160  nV_159  nV_160  -0.837043uH
R_V161  nV_160  nV_161  -1.848336m  TC=0,0
L_V161  nV_160  nV_161  -0.012791uH
R_V162  nV_161  nV_162  10.680996m  TC=0,0
L_V162  nV_161  nV_162  0.109470uH
R_V163  nV_162  nV_163  -2.050378m  TC=0,0
L_V163  nV_162  nV_163  -0.079923uH
R_V164  nV_163  nV_164  3.965345m  TC=0,0
L_V164  nV_163  nV_164  0.321445uH
L_L45  nV_164  N_C0_8  4.566075uH
K_K2335  L_L45  L_L46  0.1376
K_K2336  L_L45  L_L47  0.1533
K_K2337  L_L45  L_L48  0.2039
K_K2338  L_L45  L_L49  0.3870
K_K2339  L_L45  L_L50  0.3901
K_K2340  L_L45  L_L51  0.2001
K_K2341  L_L45  L_L52  0.1572
K_K2342  L_L45  L_L53  0.1337
K_K2343  L_L45  L_L54  0.1376
K_K2344  L_L45  L_L55  0.1533
K_K2345  L_L45  L_L56  0.1572
K_K2346  L_L45  L_L57  0.1337
K_K2347  L_L45  L_L58  0.3901
K_K2348  L_L45  L_L59  0.2001
K_K2349  L_L45  L_L60  0.2039
K_K2350  L_L45  L_L61  0.3870
K_K2351  L_L45  L_L62  -0.0190
K_K2352  L_L45  L_L63  -0.0190
K_K2353  L_L45  L_L64  -0.0190
K_K2354  L_L45  L_L65  -0.0190
K_K2355  L_L45  L_L66  0.0949
K_K2356  L_L45  L_L67  0.0850
K_K2357  L_L45  L_L68  0.0949
K_K2358  L_L45  L_L69  0.1231
K_K2359  L_L45  L_L70  0.0460
K_K2360  L_L45  L_L71  0.0897
K_K2361  L_L45  L_L72  0.0485
K_K2362  L_L45  L_L73  0.1285
K_K2363  L_L45  L_L74  0.0496
K_K2364  L_L45  L_L75  0.0956
K_K2365  L_L45  L_L76  0.0469
K_K2366  L_L45  L_L77  0.0815
K_K2367  L_L45  L_L78  0.0460
K_K2368  L_L45  L_L79  0.0897
K_K2369  L_L45  L_L80  0.0469
K_K2370  L_L45  L_L81  0.0815
K_K2371  L_L45  L_L82  0.0496
K_K2372  L_L45  L_L83  0.0956
K_K2373  L_L45  L_L84  0.0485
K_K2374  L_L45  L_L85  0.1285
K_K2375  L_L45  L_L86  0.0290
K_K2376  L_L45  L_L87  0.0290
K_K2377  L_L45  L_L88  0.0298
K_K2378  L_L45  L_L89  0.0298
K_K2379  L_L45  L_L90  0.0345
K_K2380  L_L45  L_L91  0.0337
K_K2381  L_L45  L_L92  0.0345
K_K2382  L_L45  L_L93  0.0352
K_K2383  L_L45  L_L94  0.0210
K_K2384  L_L45  L_L95  0.0298
K_K2385  L_L45  L_L96  0.0213
K_K2386  L_L45  L_L97  0.0304
K_K2387  L_L45  L_L98  0.0214
K_K2388  L_L45  L_L99  0.0301
K_K2389  L_L45  L_L100  0.0211
K_K2390  L_L45  L_L101  0.0295
K_K2391  L_L45  L_L102  0.0210
K_K2392  L_L45  L_L103  0.0298
K_K2393  L_L45  L_L104  0.0211
K_K2394  L_L45  L_L105  0.0295
K_K2395  L_L45  L_L106  0.0214
K_K2396  L_L45  L_L107  0.0301
K_K2397  L_L45  L_L108  0.0213
K_K2398  L_L45  L_L109  0.0304
K_K2399  L_L45  L_L110  0.0146
K_K2400  L_L45  L_L111  0.0113
K_K2401  L_L45  L_L112  0.0114
K_K2402  L_L45  L_L113  0.0147
K_K2403  L_L45  L_L114  0.0147
K_K2404  L_L45  L_L115  0.0129
K_K2405  L_L45  L_L116  0.0129
K_K2406  L_L45  L_L117  0.0129
K_K2407  L_L45  L_L118  0.0130
K_K2408  L_L45  L_L119  0.0164
* *  Branch  N_C0_18 - N_C0_21
R_R46  N_C0_18  nR_46  0.941960m  TC=0,0
L_L46  nR_46  N_C0_21  2.150429uH
K_K2409  L_L46  L_L47  0.1465
K_K2410  L_L46  L_L48  0.1805
K_K2411  L_L46  L_L49  0.0886
K_K2412  L_L46  L_L50  0.1200
K_K2413  L_L46  L_L51  0.0757
K_K2414  L_L46  L_L52  0.1805
K_K2415  L_L46  L_L53  0.1073
K_K2416  L_L46  L_L54  0.3782
K_K2417  L_L46  L_L55  0.0971
K_K2418  L_L46  L_L56  0.2860
K_K2419  L_L46  L_L57  0.1245
K_K2420  L_L46  L_L58  0.1432
K_K2421  L_L46  L_L59  0.0971
K_K2422  L_L46  L_L60  0.1624
K_K2423  L_L46  L_L61  0.0925
K_K2424  L_L46  L_L62  -0.0135
K_K2425  L_L46  L_L63  0.0579
K_K2426  L_L46  L_L64  -0.0135
K_K2427  L_L46  L_L65  -0.0493
K_K2428  L_L46  L_L66  0.0918
K_K2429  L_L46  L_L67  0.1303
K_K2430  L_L46  L_L68  0.0977
K_K2431  L_L46  L_L69  0.0836
K_K2432  L_L46  L_L70  0.0527
K_K2433  L_L46  L_L71  0.1139
K_K2434  L_L46  L_L72  0.0448
K_K2435  L_L46  L_L73  0.0837
K_K2436  L_L46  L_L74  0.0382
K_K2437  L_L46  L_L75  0.0804
K_K2438  L_L46  L_L76  0.0456
K_K2439  L_L46  L_L77  0.1408
K_K2440  L_L46  L_L78  0.0468
K_K2441  L_L46  L_L79  0.0961
K_K2442  L_L46  L_L80  0.0409
K_K2443  L_L46  L_L81  0.1290
K_K2444  L_L46  L_L82  0.0437
K_K2445  L_L46  L_L83  0.0961
K_K2446  L_L46  L_L84  0.0493
K_K2447  L_L46  L_L85  0.0916
K_K2448  L_L46  L_L86  0.0299
K_K2449  L_L46  L_L87  0.0302
K_K2450  L_L46  L_L88  0.0294
K_K2451  L_L46  L_L89  0.0291
K_K2452  L_L46  L_L90  0.0304
K_K2453  L_L46  L_L91  0.0312
K_K2454  L_L46  L_L92  0.0307
K_K2455  L_L46  L_L93  0.0299
K_K2456  L_L46  L_L94  0.0204
K_K2457  L_L46  L_L95  0.0297
K_K2458  L_L46  L_L96  0.0202
K_K2459  L_L46  L_L97  0.0290
K_K2460  L_L46  L_L98  0.0200
K_K2461  L_L46  L_L99  0.0291
K_K2462  L_L46  L_L100  0.0202
K_K2463  L_L46  L_L101  0.0298
K_K2464  L_L46  L_L102  0.0204
K_K2465  L_L46  L_L103  0.0294
K_K2466  L_L46  L_L104  0.0203
K_K2467  L_L46  L_L105  0.0299
K_K2468  L_L46  L_L106  0.0200
K_K2469  L_L46  L_L107  0.0294
K_K2470  L_L46  L_L108  0.0201
K_K2471  L_L46  L_L109  0.0289
K_K2472  L_L46  L_L110  0.0138
K_K2473  L_L46  L_L111  0.0109
K_K2474  L_L46  L_L112  0.0108
K_K2475  L_L46  L_L113  0.0138
K_K2476  L_L46  L_L114  0.0137
K_K2477  L_L46  L_L115  0.0122
K_K2478  L_L46  L_L116  0.0122
K_K2479  L_L46  L_L117  0.0123
K_K2480  L_L46  L_L118  0.0121
K_K2481  L_L46  L_L119  0.0153
* *  Branch  N_C0_21 - N_C0_7
R_R47  N_C0_21  nR_47  0.941960m  TC=0,0
L_L47  nR_47  N_C0_7  2.135276uH
K_K2482  L_L47  L_L48  0.1073
K_K2483  L_L47  L_L49  0.1748
K_K2484  L_L47  L_L50  0.0757
K_K2485  L_L47  L_L51  0.1139
K_K2486  L_L47  L_L52  0.0886
K_K2487  L_L47  L_L53  0.1748
K_K2488  L_L47  L_L54  0.0971
K_K2489  L_L47  L_L55  0.1373
K_K2490  L_L47  L_L56  0.1245
K_K2491  L_L47  L_L57  0.2810
K_K2492  L_L47  L_L58  0.0971
K_K2493  L_L47  L_L59  0.3738
K_K2494  L_L47  L_L60  0.0925
K_K2495  L_L47  L_L61  0.1565
K_K2496  L_L47  L_L62  0.0490
K_K2497  L_L47  L_L63  0.0527
K_K2498  L_L47  L_L64  0.0514
K_K2499  L_L47  L_L65  0.0479
K_K2500  L_L47  L_L66  0.0429
K_K2501  L_L47  L_L67  0.0453
K_K2502  L_L47  L_L68  0.0464
K_K2503  L_L47  L_L69  0.0438
K_K2504  L_L47  L_L70  0.0267
K_K2505  L_L47  L_L71  0.0483
K_K2506  L_L47  L_L72  0.0268
K_K2507  L_L47  L_L73  0.0405
K_K2508  L_L47  L_L74  0.0261
K_K2509  L_L47  L_L75  0.0340
K_K2510  L_L47  L_L76  0.0260
K_K2511  L_L47  L_L77  0.0413
K_K2512  L_L47  L_L78  0.0264
K_K2513  L_L47  L_L79  0.0394
K_K2514  L_L47  L_L80  0.0269
K_K2515  L_L47  L_L81  0.0367
K_K2516  L_L47  L_L82  0.0264
K_K2517  L_L47  L_L83  0.0424
K_K2518  L_L47  L_L84  0.0259
K_K2519  L_L47  L_L85  0.0449
K_K2520  L_L47  L_L86  0.0171
K_K2521  L_L47  L_L87  0.0174
K_K2522  L_L47  L_L88  0.0173
K_K2523  L_L47  L_L89  0.0170
K_K2524  L_L47  L_L90  0.0182
K_K2525  L_L47  L_L91  0.0185
K_K2526  L_L47  L_L92  0.0187
K_K2527  L_L47  L_L93  0.0184
K_K2528  L_L47  L_L94  0.0129
K_K2529  L_L47  L_L95  0.0179
K_K2530  L_L47  L_L96  0.0129
K_K2531  L_L47  L_L97  0.0177
K_K2532  L_L47  L_L98  0.0128
K_K2533  L_L47  L_L99  0.0175
K_K2534  L_L47  L_L100  0.0127
K_K2535  L_L47  L_L101  0.0177
K_K2536  L_L47  L_L102  0.0128
K_K2537  L_L47  L_L103  0.0176
K_K2538  L_L47  L_L104  0.0129
K_K2539  L_L47  L_L105  0.0179
K_K2540  L_L47  L_L106  0.0128
K_K2541  L_L47  L_L107  0.0179
K_K2542  L_L47  L_L108  0.0127
K_K2543  L_L47  L_L109  0.0176
K_K2544  L_L47  L_L119  0.0100
* *  Branch  N_C0_19 - N_C0_22
R_R48  N_C0_19  nR_48  0.941960m  TC=0,0
L_L48  nR_48  N_C0_22  2.150429uH
K_K2545  L_L48  L_L49  0.1465
K_K2546  L_L48  L_L50  0.1805
K_K2547  L_L48  L_L51  0.0886
K_K2548  L_L48  L_L52  0.1200
K_K2549  L_L48  L_L53  0.0757
K_K2550  L_L48  L_L54  0.1624
K_K2551  L_L48  L_L55  0.0925
K_K2552  L_L48  L_L56  0.3782
K_K2553  L_L48  L_L57  0.0971
K_K2554  L_L48  L_L58  0.2860
K_K2555  L_L48  L_L59  0.1245
K_K2556  L_L48  L_L60  0.1432
K_K2557  L_L48  L_L61  0.0971
K_K2558  L_L48  L_L62  -0.0493
K_K2559  L_L48  L_L63  -0.0135
K_K2560  L_L48  L_L64  0.0579
K_K2561  L_L48  L_L65  -0.0135
K_K2562  L_L48  L_L66  0.0836
K_K2563  L_L48  L_L67  0.0918
K_K2564  L_L48  L_L68  0.1303
K_K2565  L_L48  L_L69  0.0977
K_K2566  L_L48  L_L70  0.0456
K_K2567  L_L48  L_L71  0.1408
K_K2568  L_L48  L_L72  0.0527
K_K2569  L_L48  L_L73  0.1139
K_K2570  L_L48  L_L74  0.0448
K_K2571  L_L48  L_L75  0.0837
K_K2572  L_L48  L_L76  0.0382
K_K2573  L_L48  L_L77  0.0804
K_K2574  L_L48  L_L78  0.0493
K_K2575  L_L48  L_L79  0.0916
K_K2576  L_L48  L_L80  0.0468
K_K2577  L_L48  L_L81  0.0961
K_K2578  L_L48  L_L82  0.0409
K_K2579  L_L48  L_L83  0.1290
K_K2580  L_L48  L_L84  0.0437
K_K2581  L_L48  L_L85  0.0961
K_K2582  L_L48  L_L86  0.0291
K_K2583  L_L48  L_L87  0.0299
K_K2584  L_L48  L_L88  0.0302
K_K2585  L_L48  L_L89  0.0294
K_K2586  L_L48  L_L90  0.0299
K_K2587  L_L48  L_L91  0.0304
K_K2588  L_L48  L_L92  0.0312
K_K2589  L_L48  L_L93  0.0307
K_K2590  L_L48  L_L94  0.0202
K_K2591  L_L48  L_L95  0.0298
K_K2592  L_L48  L_L96  0.0204
K_K2593  L_L48  L_L97  0.0297
K_K2594  L_L48  L_L98  0.0202
K_K2595  L_L48  L_L99  0.0290
K_K2596  L_L48  L_L100  0.0200
K_K2597  L_L48  L_L101  0.0291
K_K2598  L_L48  L_L102  0.0201
K_K2599  L_L48  L_L103  0.0289
K_K2600  L_L48  L_L104  0.0204
K_K2601  L_L48  L_L105  0.0294
K_K2602  L_L48  L_L106  0.0203
K_K2603  L_L48  L_L107  0.0299
K_K2604  L_L48  L_L108  0.0200
K_K2605  L_L48  L_L109  0.0294
K_K2606  L_L48  L_L110  0.0137
K_K2607  L_L48  L_L111  0.0108
K_K2608  L_L48  L_L112  0.0109
K_K2609  L_L48  L_L113  0.0139
K_K2610  L_L48  L_L114  0.0138
K_K2611  L_L48  L_L115  0.0121
K_K2612  L_L48  L_L116  0.0123
K_K2613  L_L48  L_L117  0.0122
K_K2614  L_L48  L_L118  0.0122
K_K2615  L_L48  L_L119  0.0153
* *  Branch  N_C0_22 - N_C0_8
R_R49  N_C0_22  nR_49  0.941960m  TC=0,0
L_L49  nR_49  N_C0_8  2.135276uH
K_K2616  L_L49  L_L50  0.1073
K_K2617  L_L49  L_L51  0.1748
K_K2618  L_L49  L_L52  0.0757
K_K2619  L_L49  L_L53  0.1139
K_K2620  L_L49  L_L54  0.0925
K_K2621  L_L49  L_L55  0.1565
K_K2622  L_L49  L_L56  0.0971
K_K2623  L_L49  L_L57  0.1373
K_K2624  L_L49  L_L58  0.1245
K_K2625  L_L49  L_L59  0.2810
K_K2626  L_L49  L_L60  0.0971
K_K2627  L_L49  L_L61  0.3738
K_K2628  L_L49  L_L62  0.0479
K_K2629  L_L49  L_L63  0.0490
K_K2630  L_L49  L_L64  0.0527
K_K2631  L_L49  L_L65  0.0514
K_K2632  L_L49  L_L66  0.0438
K_K2633  L_L49  L_L67  0.0429
K_K2634  L_L49  L_L68  0.0453
K_K2635  L_L49  L_L69  0.0464
K_K2636  L_L49  L_L70  0.0260
K_K2637  L_L49  L_L71  0.0413
K_K2638  L_L49  L_L72  0.0267
K_K2639  L_L49  L_L73  0.0483
K_K2640  L_L49  L_L74  0.0268
K_K2641  L_L49  L_L75  0.0405
K_K2642  L_L49  L_L76  0.0261
K_K2643  L_L49  L_L77  0.0340
K_K2644  L_L49  L_L78  0.0259
K_K2645  L_L49  L_L79  0.0449
K_K2646  L_L49  L_L80  0.0264
K_K2647  L_L49  L_L81  0.0394
K_K2648  L_L49  L_L82  0.0269
K_K2649  L_L49  L_L83  0.0367
K_K2650  L_L49  L_L84  0.0264
K_K2651  L_L49  L_L85  0.0424
K_K2652  L_L49  L_L86  0.0170
K_K2653  L_L49  L_L87  0.0171
K_K2654  L_L49  L_L88  0.0174
K_K2655  L_L49  L_L89  0.0173
K_K2656  L_L49  L_L90  0.0184
K_K2657  L_L49  L_L91  0.0182
K_K2658  L_L49  L_L92  0.0185
K_K2659  L_L49  L_L93  0.0187
K_K2660  L_L49  L_L94  0.0127
K_K2661  L_L49  L_L95  0.0177
K_K2662  L_L49  L_L96  0.0129
K_K2663  L_L49  L_L97  0.0179
K_K2664  L_L49  L_L98  0.0129
K_K2665  L_L49  L_L99  0.0177
K_K2666  L_L49  L_L100  0.0128
K_K2667  L_L49  L_L101  0.0175
K_K2668  L_L49  L_L102  0.0127
K_K2669  L_L49  L_L103  0.0176
K_K2670  L_L49  L_L104  0.0128
K_K2671  L_L49  L_L105  0.0176
K_K2672  L_L49  L_L106  0.0129
K_K2673  L_L49  L_L107  0.0179
K_K2674  L_L49  L_L108  0.0128
K_K2675  L_L49  L_L109  0.0179
K_K2676  L_L49  L_L119  0.0100
* *  Branch  N_C0_20 - N_C0_23
R_R50  N_C0_20  nR_50  0.941960m  TC=0,0
L_L50  nR_50  N_C0_23  2.150429uH
K_K2677  L_L50  L_L51  0.1465
K_K2678  L_L50  L_L52  0.1805
K_K2679  L_L50  L_L53  0.0886
K_K2680  L_L50  L_L54  0.1432
K_K2681  L_L50  L_L55  0.0971
K_K2682  L_L50  L_L56  0.1624
K_K2683  L_L50  L_L57  0.0925
K_K2684  L_L50  L_L58  0.3782
K_K2685  L_L50  L_L59  0.0971
K_K2686  L_L50  L_L60  0.2860
K_K2687  L_L50  L_L61  0.1245
K_K2688  L_L50  L_L62  -0.0135
K_K2689  L_L50  L_L63  -0.0493
K_K2690  L_L50  L_L64  -0.0135
K_K2691  L_L50  L_L65  0.0579
K_K2692  L_L50  L_L66  0.0977
K_K2693  L_L50  L_L67  0.0836
K_K2694  L_L50  L_L68  0.0918
K_K2695  L_L50  L_L69  0.1303
K_K2696  L_L50  L_L70  0.0382
K_K2697  L_L50  L_L71  0.0804
K_K2698  L_L50  L_L72  0.0456
K_K2699  L_L50  L_L73  0.1408
K_K2700  L_L50  L_L74  0.0527
K_K2701  L_L50  L_L75  0.1139
K_K2702  L_L50  L_L76  0.0448
K_K2703  L_L50  L_L77  0.0837
K_K2704  L_L50  L_L78  0.0437
K_K2705  L_L50  L_L79  0.0961
K_K2706  L_L50  L_L80  0.0493
K_K2707  L_L50  L_L81  0.0916
K_K2708  L_L50  L_L82  0.0468
K_K2709  L_L50  L_L83  0.0961
K_K2710  L_L50  L_L84  0.0409
K_K2711  L_L50  L_L85  0.1290
K_K2712  L_L50  L_L86  0.0294
K_K2713  L_L50  L_L87  0.0291
K_K2714  L_L50  L_L88  0.0299
K_K2715  L_L50  L_L89  0.0302
K_K2716  L_L50  L_L90  0.0307
K_K2717  L_L50  L_L91  0.0299
K_K2718  L_L50  L_L92  0.0304
K_K2719  L_L50  L_L93  0.0312
K_K2720  L_L50  L_L94  0.0200
K_K2721  L_L50  L_L95  0.0291
K_K2722  L_L50  L_L96  0.0202
K_K2723  L_L50  L_L97  0.0298
K_K2724  L_L50  L_L98  0.0204
K_K2725  L_L50  L_L99  0.0297
K_K2726  L_L50  L_L100  0.0202
K_K2727  L_L50  L_L101  0.0290
K_K2728  L_L50  L_L102  0.0200
K_K2729  L_L50  L_L103  0.0294
K_K2730  L_L50  L_L104  0.0201
K_K2731  L_L50  L_L105  0.0289
K_K2732  L_L50  L_L106  0.0204
K_K2733  L_L50  L_L107  0.0294
K_K2734  L_L50  L_L108  0.0203
K_K2735  L_L50  L_L109  0.0299
K_K2736  L_L50  L_L110  0.0138
K_K2737  L_L50  L_L111  0.0107
K_K2738  L_L50  L_L112  0.0107
K_K2739  L_L50  L_L113  0.0138
K_K2740  L_L50  L_L114  0.0139
K_K2741  L_L50  L_L115  0.0122
K_K2742  L_L50  L_L116  0.0122
K_K2743  L_L50  L_L117  0.0121
K_K2744  L_L50  L_L118  0.0123
K_K2745  L_L50  L_L119  0.0153
* *  Branch  N_C0_23 - N_C0_5
R_R51  N_C0_23  nR_51  0.941960m  TC=0,0
L_L51  nR_51  N_C0_5  2.135276uH
K_K2746  L_L51  L_L52  0.1073
K_K2747  L_L51  L_L53  0.1748
K_K2748  L_L51  L_L54  0.0971
K_K2749  L_L51  L_L55  0.3738
K_K2750  L_L51  L_L56  0.0925
K_K2751  L_L51  L_L57  0.1565
K_K2752  L_L51  L_L58  0.0971
K_K2753  L_L51  L_L59  0.1373
K_K2754  L_L51  L_L60  0.1245
K_K2755  L_L51  L_L61  0.2810
K_K2756  L_L51  L_L62  0.0514
K_K2757  L_L51  L_L63  0.0479
K_K2758  L_L51  L_L64  0.0490
K_K2759  L_L51  L_L65  0.0527
K_K2760  L_L51  L_L66  0.0464
K_K2761  L_L51  L_L67  0.0438
K_K2762  L_L51  L_L68  0.0429
K_K2763  L_L51  L_L69  0.0453
K_K2764  L_L51  L_L70  0.0261
K_K2765  L_L51  L_L71  0.0340
K_K2766  L_L51  L_L72  0.0260
K_K2767  L_L51  L_L73  0.0413
K_K2768  L_L51  L_L74  0.0267
K_K2769  L_L51  L_L75  0.0483
K_K2770  L_L51  L_L76  0.0268
K_K2771  L_L51  L_L77  0.0405
K_K2772  L_L51  L_L78  0.0264
K_K2773  L_L51  L_L79  0.0424
K_K2774  L_L51  L_L80  0.0259
K_K2775  L_L51  L_L81  0.0449
K_K2776  L_L51  L_L82  0.0264
K_K2777  L_L51  L_L83  0.0394
K_K2778  L_L51  L_L84  0.0269
K_K2779  L_L51  L_L85  0.0367
K_K2780  L_L51  L_L86  0.0173
K_K2781  L_L51  L_L87  0.0170
K_K2782  L_L51  L_L88  0.0171
K_K2783  L_L51  L_L89  0.0174
K_K2784  L_L51  L_L90  0.0187
K_K2785  L_L51  L_L91  0.0184
K_K2786  L_L51  L_L92  0.0182
K_K2787  L_L51  L_L93  0.0185
K_K2788  L_L51  L_L94  0.0128
K_K2789  L_L51  L_L95  0.0175
K_K2790  L_L51  L_L96  0.0127
K_K2791  L_L51  L_L97  0.0177
K_K2792  L_L51  L_L98  0.0129
K_K2793  L_L51  L_L99  0.0179
K_K2794  L_L51  L_L100  0.0129
K_K2795  L_L51  L_L101  0.0177
K_K2796  L_L51  L_L102  0.0128
K_K2797  L_L51  L_L103  0.0179
K_K2798  L_L51  L_L104  0.0127
K_K2799  L_L51  L_L105  0.0176
K_K2800  L_L51  L_L106  0.0128
K_K2801  L_L51  L_L107  0.0176
K_K2802  L_L51  L_L108  0.0129
K_K2803  L_L51  L_L109  0.0179
K_K2804  L_L51  L_L119  0.0100
* *  Branch  N_C0_17 - N_C0_24
R_R52  N_C0_17  nR_52  0.941960m  TC=0,0
L_L52  nR_52  N_C0_24  2.150429uH
K_K2805  L_L52  L_L53  0.1465
K_K2806  L_L52  L_L54  0.2860
K_K2807  L_L52  L_L55  0.1245
K_K2808  L_L52  L_L56  0.1432
K_K2809  L_L52  L_L57  0.0971
K_K2810  L_L52  L_L58  0.1624
K_K2811  L_L52  L_L59  0.0925
K_K2812  L_L52  L_L60  0.3782
K_K2813  L_L52  L_L61  0.0971
K_K2814  L_L52  L_L62  0.0579
K_K2815  L_L52  L_L63  -0.0135
K_K2816  L_L52  L_L64  -0.0493
K_K2817  L_L52  L_L65  -0.0135
K_K2818  L_L52  L_L66  0.1303
K_K2819  L_L52  L_L67  0.0977
K_K2820  L_L52  L_L68  0.0836
K_K2821  L_L52  L_L69  0.0918
K_K2822  L_L52  L_L70  0.0448
K_K2823  L_L52  L_L71  0.0837
K_K2824  L_L52  L_L72  0.0382
K_K2825  L_L52  L_L73  0.0804
K_K2826  L_L52  L_L74  0.0456
K_K2827  L_L52  L_L75  0.1408
K_K2828  L_L52  L_L76  0.0527
K_K2829  L_L52  L_L77  0.1139
K_K2830  L_L52  L_L78  0.0409
K_K2831  L_L52  L_L79  0.1290
K_K2832  L_L52  L_L80  0.0437
K_K2833  L_L52  L_L81  0.0961
K_K2834  L_L52  L_L82  0.0493
K_K2835  L_L52  L_L83  0.0916
K_K2836  L_L52  L_L84  0.0468
K_K2837  L_L52  L_L85  0.0961
K_K2838  L_L52  L_L86  0.0302
K_K2839  L_L52  L_L87  0.0294
K_K2840  L_L52  L_L88  0.0291
K_K2841  L_L52  L_L89  0.0299
K_K2842  L_L52  L_L90  0.0312
K_K2843  L_L52  L_L91  0.0307
K_K2844  L_L52  L_L92  0.0299
K_K2845  L_L52  L_L93  0.0304
K_K2846  L_L52  L_L94  0.0202
K_K2847  L_L52  L_L95  0.0290
K_K2848  L_L52  L_L96  0.0200
K_K2849  L_L52  L_L97  0.0291
K_K2850  L_L52  L_L98  0.0202
K_K2851  L_L52  L_L99  0.0298
K_K2852  L_L52  L_L100  0.0204
K_K2853  L_L52  L_L101  0.0297
K_K2854  L_L52  L_L102  0.0203
K_K2855  L_L52  L_L103  0.0299
K_K2856  L_L52  L_L104  0.0200
K_K2857  L_L52  L_L105  0.0294
K_K2858  L_L52  L_L106  0.0201
K_K2859  L_L52  L_L107  0.0289
K_K2860  L_L52  L_L108  0.0204
K_K2861  L_L52  L_L109  0.0294
K_K2862  L_L52  L_L110  0.0139
K_K2863  L_L52  L_L111  0.0108
K_K2864  L_L52  L_L112  0.0107
K_K2865  L_L52  L_L113  0.0137
K_K2866  L_L52  L_L114  0.0138
K_K2867  L_L52  L_L115  0.0123
K_K2868  L_L52  L_L116  0.0121
K_K2869  L_L52  L_L117  0.0122
K_K2870  L_L52  L_L118  0.0122
K_K2871  L_L52  L_L119  0.0153
* *  Branch  N_C0_24 - N_C0_6
R_R53  N_C0_24  nR_53  0.941960m  TC=0,0
L_L53  nR_53  N_C0_6  2.135276uH
K_K2872  L_L53  L_L54  0.1245
K_K2873  L_L53  L_L55  0.2810
K_K2874  L_L53  L_L56  0.0971
K_K2875  L_L53  L_L57  0.3738
K_K2876  L_L53  L_L58  0.0925
K_K2877  L_L53  L_L59  0.1565
K_K2878  L_L53  L_L60  0.0971
K_K2879  L_L53  L_L61  0.1373
K_K2880  L_L53  L_L62  0.0527
K_K2881  L_L53  L_L63  0.0514
K_K2882  L_L53  L_L64  0.0479
K_K2883  L_L53  L_L65  0.0490
K_K2884  L_L53  L_L66  0.0453
K_K2885  L_L53  L_L67  0.0464
K_K2886  L_L53  L_L68  0.0438
K_K2887  L_L53  L_L69  0.0429
K_K2888  L_L53  L_L70  0.0268
K_K2889  L_L53  L_L71  0.0405
K_K2890  L_L53  L_L72  0.0261
K_K2891  L_L53  L_L73  0.0340
K_K2892  L_L53  L_L74  0.0260
K_K2893  L_L53  L_L75  0.0413
K_K2894  L_L53  L_L76  0.0267
K_K2895  L_L53  L_L77  0.0483
K_K2896  L_L53  L_L78  0.0269
K_K2897  L_L53  L_L79  0.0367
K_K2898  L_L53  L_L80  0.0264
K_K2899  L_L53  L_L81  0.0424
K_K2900  L_L53  L_L82  0.0259
K_K2901  L_L53  L_L83  0.0449
K_K2902  L_L53  L_L84  0.0264
K_K2903  L_L53  L_L85  0.0394
K_K2904  L_L53  L_L86  0.0174
K_K2905  L_L53  L_L87  0.0173
K_K2906  L_L53  L_L88  0.0170
K_K2907  L_L53  L_L89  0.0171
K_K2908  L_L53  L_L90  0.0185
K_K2909  L_L53  L_L91  0.0187
K_K2910  L_L53  L_L92  0.0184
K_K2911  L_L53  L_L93  0.0182
K_K2912  L_L53  L_L94  0.0129
K_K2913  L_L53  L_L95  0.0177
K_K2914  L_L53  L_L96  0.0128
K_K2915  L_L53  L_L97  0.0175
K_K2916  L_L53  L_L98  0.0127
K_K2917  L_L53  L_L99  0.0177
K_K2918  L_L53  L_L100  0.0129
K_K2919  L_L53  L_L101  0.0179
K_K2920  L_L53  L_L102  0.0129
K_K2921  L_L53  L_L103  0.0179
K_K2922  L_L53  L_L104  0.0128
K_K2923  L_L53  L_L105  0.0179
K_K2924  L_L53  L_L106  0.0127
K_K2925  L_L53  L_L107  0.0176
K_K2926  L_L53  L_L108  0.0128
K_K2927  L_L53  L_L109  0.0176
K_K2928  L_L53  L_L119  0.0100
* *  Branch  N_C0_18 - N_C0_24
R_R54  N_C0_18  nR_54  0.941960m  TC=0,0
L_L54  nR_54  N_C0_24  2.150429uH
K_K2929  L_L54  L_L55  0.1465
K_K2930  L_L54  L_L56  0.1805
K_K2931  L_L54  L_L57  0.1073
K_K2932  L_L54  L_L58  0.1200
K_K2933  L_L54  L_L59  0.0757
K_K2934  L_L54  L_L60  0.1805
K_K2935  L_L54  L_L61  0.0886
K_K2936  L_L54  L_L62  -0.0850
K_K2937  L_L54  L_L63  -0.0135
K_K2938  L_L54  L_L64  0.0223
K_K2939  L_L54  L_L65  -0.0135
K_K2940  L_L54  L_L66  0.0977
K_K2941  L_L54  L_L67  0.1303
K_K2942  L_L54  L_L68  0.0918
K_K2943  L_L54  L_L69  0.0836
K_K2944  L_L54  L_L70  0.0468
K_K2945  L_L54  L_L71  0.0961
K_K2946  L_L54  L_L72  0.0493
K_K2947  L_L54  L_L73  0.0916
K_K2948  L_L54  L_L74  0.0437
K_K2949  L_L54  L_L75  0.0961
K_K2950  L_L54  L_L76  0.0409
K_K2951  L_L54  L_L77  0.1290
K_K2952  L_L54  L_L78  0.0527
K_K2953  L_L54  L_L79  0.1139
K_K2954  L_L54  L_L80  0.0456
K_K2955  L_L54  L_L81  0.1408
K_K2956  L_L54  L_L82  0.0382
K_K2957  L_L54  L_L83  0.0804
K_K2958  L_L54  L_L84  0.0448
K_K2959  L_L54  L_L85  0.0837
K_K2960  L_L54  L_L86  0.0302
K_K2961  L_L54  L_L87  0.0299
K_K2962  L_L54  L_L88  0.0291
K_K2963  L_L54  L_L89  0.0294
K_K2964  L_L54  L_L90  0.0307
K_K2965  L_L54  L_L91  0.0312
K_K2966  L_L54  L_L92  0.0304
K_K2967  L_L54  L_L93  0.0299
K_K2968  L_L54  L_L94  0.0204
K_K2969  L_L54  L_L95  0.0294
K_K2970  L_L54  L_L96  0.0201
K_K2971  L_L54  L_L97  0.0289
K_K2972  L_L54  L_L98  0.0200
K_K2973  L_L54  L_L99  0.0294
K_K2974  L_L54  L_L100  0.0203
K_K2975  L_L54  L_L101  0.0299
K_K2976  L_L54  L_L102  0.0204
K_K2977  L_L54  L_L103  0.0297
K_K2978  L_L54  L_L104  0.0202
K_K2979  L_L54  L_L105  0.0298
K_K2980  L_L54  L_L106  0.0200
K_K2981  L_L54  L_L107  0.0291
K_K2982  L_L54  L_L108  0.0202
K_K2983  L_L54  L_L109  0.0290
K_K2984  L_L54  L_L110  0.0139
K_K2985  L_L54  L_L111  0.0109
K_K2986  L_L54  L_L112  0.0108
K_K2987  L_L54  L_L113  0.0137
K_K2988  L_L54  L_L114  0.0138
K_K2989  L_L54  L_L115  0.0122
K_K2990  L_L54  L_L116  0.0122
K_K2991  L_L54  L_L117  0.0123
K_K2992  L_L54  L_L118  0.0121
K_K2993  L_L54  L_L119  0.0153
* *  Branch  N_C0_24 - N_C0_5
R_R55  N_C0_24  nR_55  0.941960m  TC=0,0
L_L55  nR_55  N_C0_5  2.135276uH
K_K2994  L_L55  L_L56  0.0886
K_K2995  L_L55  L_L57  0.1748
K_K2996  L_L55  L_L58  0.0757
K_K2997  L_L55  L_L59  0.1139
K_K2998  L_L55  L_L60  0.1073
K_K2999  L_L55  L_L61  0.1748
K_K3000  L_L55  L_L62  0.0527
K_K3001  L_L55  L_L63  0.0490
K_K3002  L_L55  L_L64  0.0479
K_K3003  L_L55  L_L65  0.0514
K_K3004  L_L55  L_L66  0.0464
K_K3005  L_L55  L_L67  0.0453
K_K3006  L_L55  L_L68  0.0429
K_K3007  L_L55  L_L69  0.0438
K_K3008  L_L55  L_L70  0.0264
K_K3009  L_L55  L_L71  0.0394
K_K3010  L_L55  L_L72  0.0259
K_K3011  L_L55  L_L73  0.0449
K_K3012  L_L55  L_L74  0.0264
K_K3013  L_L55  L_L75  0.0424
K_K3014  L_L55  L_L76  0.0269
K_K3015  L_L55  L_L77  0.0367
K_K3016  L_L55  L_L78  0.0267
K_K3017  L_L55  L_L79  0.0483
K_K3018  L_L55  L_L80  0.0260
K_K3019  L_L55  L_L81  0.0413
K_K3020  L_L55  L_L82  0.0261
K_K3021  L_L55  L_L83  0.0340
K_K3022  L_L55  L_L84  0.0268
K_K3023  L_L55  L_L85  0.0405
K_K3024  L_L55  L_L86  0.0174
K_K3025  L_L55  L_L87  0.0171
K_K3026  L_L55  L_L88  0.0170
K_K3027  L_L55  L_L89  0.0173
K_K3028  L_L55  L_L90  0.0187
K_K3029  L_L55  L_L91  0.0185
K_K3030  L_L55  L_L92  0.0182
K_K3031  L_L55  L_L93  0.0184
K_K3032  L_L55  L_L94  0.0128
K_K3033  L_L55  L_L95  0.0176
K_K3034  L_L55  L_L96  0.0127
K_K3035  L_L55  L_L97  0.0176
K_K3036  L_L55  L_L98  0.0128
K_K3037  L_L55  L_L99  0.0179
K_K3038  L_L55  L_L100  0.0129
K_K3039  L_L55  L_L101  0.0179
K_K3040  L_L55  L_L102  0.0129
K_K3041  L_L55  L_L103  0.0179
K_K3042  L_L55  L_L104  0.0127
K_K3043  L_L55  L_L105  0.0177
K_K3044  L_L55  L_L106  0.0128
K_K3045  L_L55  L_L107  0.0175
K_K3046  L_L55  L_L108  0.0129
K_K3047  L_L55  L_L109  0.0177
K_K3048  L_L55  L_L119  0.0100
* *  Branch  N_C0_19 - N_C0_21
R_R56  N_C0_19  nR_56  0.941960m  TC=0,0
L_L56  nR_56  N_C0_21  2.150429uH
K_K3049  L_L56  L_L57  0.1465
K_K3050  L_L56  L_L58  0.1805
K_K3051  L_L56  L_L59  0.1073
K_K3052  L_L56  L_L60  0.1200
K_K3053  L_L56  L_L61  0.0757
K_K3054  L_L56  L_L62  -0.0135
K_K3055  L_L56  L_L63  -0.0850
K_K3056  L_L56  L_L64  -0.0135
K_K3057  L_L56  L_L65  0.0223
K_K3058  L_L56  L_L66  0.0836
K_K3059  L_L56  L_L67  0.0977
K_K3060  L_L56  L_L68  0.1303
K_K3061  L_L56  L_L69  0.0918
K_K3062  L_L56  L_L70  0.0409
K_K3063  L_L56  L_L71  0.1290
K_K3064  L_L56  L_L72  0.0468
K_K3065  L_L56  L_L73  0.0961
K_K3066  L_L56  L_L74  0.0493
K_K3067  L_L56  L_L75  0.0916
K_K3068  L_L56  L_L76  0.0437
K_K3069  L_L56  L_L77  0.0961
K_K3070  L_L56  L_L78  0.0448
K_K3071  L_L56  L_L79  0.0837
K_K3072  L_L56  L_L80  0.0527
K_K3073  L_L56  L_L81  0.1139
K_K3074  L_L56  L_L82  0.0456
K_K3075  L_L56  L_L83  0.1408
K_K3076  L_L56  L_L84  0.0382
K_K3077  L_L56  L_L85  0.0804
K_K3078  L_L56  L_L86  0.0294
K_K3079  L_L56  L_L87  0.0302
K_K3080  L_L56  L_L88  0.0299
K_K3081  L_L56  L_L89  0.0291
K_K3082  L_L56  L_L90  0.0299
K_K3083  L_L56  L_L91  0.0307
K_K3084  L_L56  L_L92  0.0312
K_K3085  L_L56  L_L93  0.0304
K_K3086  L_L56  L_L94  0.0203
K_K3087  L_L56  L_L95  0.0299
K_K3088  L_L56  L_L96  0.0204
K_K3089  L_L56  L_L97  0.0294
K_K3090  L_L56  L_L98  0.0201
K_K3091  L_L56  L_L99  0.0289
K_K3092  L_L56  L_L100  0.0200
K_K3093  L_L56  L_L101  0.0294
K_K3094  L_L56  L_L102  0.0202
K_K3095  L_L56  L_L103  0.0290
K_K3096  L_L56  L_L104  0.0204
K_K3097  L_L56  L_L105  0.0297
K_K3098  L_L56  L_L106  0.0202
K_K3099  L_L56  L_L107  0.0298
K_K3100  L_L56  L_L108  0.0200
K_K3101  L_L56  L_L109  0.0291
K_K3102  L_L56  L_L110  0.0138
K_K3103  L_L56  L_L111  0.0108
K_K3104  L_L56  L_L112  0.0109
K_K3105  L_L56  L_L113  0.0138
K_K3106  L_L56  L_L114  0.0137
K_K3107  L_L56  L_L115  0.0121
K_K3108  L_L56  L_L116  0.0123
K_K3109  L_L56  L_L117  0.0122
K_K3110  L_L56  L_L118  0.0122
K_K3111  L_L56  L_L119  0.0153
* *  Branch  N_C0_21 - N_C0_6
R_R57  N_C0_21  nR_57  0.941960m  TC=0,0
L_L57  nR_57  N_C0_6  2.135276uH
K_K3112  L_L57  L_L58  0.0886
K_K3113  L_L57  L_L59  0.1748
K_K3114  L_L57  L_L60  0.0757
K_K3115  L_L57  L_L61  0.1139
K_K3116  L_L57  L_L62  0.0514
K_K3117  L_L57  L_L63  0.0527
K_K3118  L_L57  L_L64  0.0490
K_K3119  L_L57  L_L65  0.0479
K_K3120  L_L57  L_L66  0.0438
K_K3121  L_L57  L_L67  0.0464
K_K3122  L_L57  L_L68  0.0453
K_K3123  L_L57  L_L69  0.0429
K_K3124  L_L57  L_L70  0.0269
K_K3125  L_L57  L_L71  0.0367
K_K3126  L_L57  L_L72  0.0264
K_K3127  L_L57  L_L73  0.0394
K_K3128  L_L57  L_L74  0.0259
K_K3129  L_L57  L_L75  0.0449
K_K3130  L_L57  L_L76  0.0264
K_K3131  L_L57  L_L77  0.0424
K_K3132  L_L57  L_L78  0.0268
K_K3133  L_L57  L_L79  0.0405
K_K3134  L_L57  L_L80  0.0267
K_K3135  L_L57  L_L81  0.0483
K_K3136  L_L57  L_L82  0.0260
K_K3137  L_L57  L_L83  0.0413
K_K3138  L_L57  L_L84  0.0261
K_K3139  L_L57  L_L85  0.0340
K_K3140  L_L57  L_L86  0.0173
K_K3141  L_L57  L_L87  0.0174
K_K3142  L_L57  L_L88  0.0171
K_K3143  L_L57  L_L89  0.0170
K_K3144  L_L57  L_L90  0.0184
K_K3145  L_L57  L_L91  0.0187
K_K3146  L_L57  L_L92  0.0185
K_K3147  L_L57  L_L93  0.0182
K_K3148  L_L57  L_L94  0.0129
K_K3149  L_L57  L_L95  0.0179
K_K3150  L_L57  L_L96  0.0128
K_K3151  L_L57  L_L97  0.0176
K_K3152  L_L57  L_L98  0.0127
K_K3153  L_L57  L_L99  0.0176
K_K3154  L_L57  L_L100  0.0128
K_K3155  L_L57  L_L101  0.0179
K_K3156  L_L57  L_L102  0.0129
K_K3157  L_L57  L_L103  0.0177
K_K3158  L_L57  L_L104  0.0129
K_K3159  L_L57  L_L105  0.0179
K_K3160  L_L57  L_L106  0.0127
K_K3161  L_L57  L_L107  0.0177
K_K3162  L_L57  L_L108  0.0128
K_K3163  L_L57  L_L109  0.0175
K_K3164  L_L57  L_L119  0.0100
* *  Branch  N_C0_20 - N_C0_22
R_R58  N_C0_20  nR_58  0.941960m  TC=0,0
L_L58  nR_58  N_C0_22  2.150429uH
K_K3165  L_L58  L_L59  0.1465
K_K3166  L_L58  L_L60  0.1805
K_K3167  L_L58  L_L61  0.1073
K_K3168  L_L58  L_L62  0.0223
K_K3169  L_L58  L_L63  -0.0135
K_K3170  L_L58  L_L64  -0.0850
K_K3171  L_L58  L_L65  -0.0135
K_K3172  L_L58  L_L66  0.0918
K_K3173  L_L58  L_L67  0.0836
K_K3174  L_L58  L_L68  0.0977
K_K3175  L_L58  L_L69  0.1303
K_K3176  L_L58  L_L70  0.0437
K_K3177  L_L58  L_L71  0.0961
K_K3178  L_L58  L_L72  0.0409
K_K3179  L_L58  L_L73  0.1290
K_K3180  L_L58  L_L74  0.0468
K_K3181  L_L58  L_L75  0.0961
K_K3182  L_L58  L_L76  0.0493
K_K3183  L_L58  L_L77  0.0916
K_K3184  L_L58  L_L78  0.0382
K_K3185  L_L58  L_L79  0.0804
K_K3186  L_L58  L_L80  0.0448
K_K3187  L_L58  L_L81  0.0837
K_K3188  L_L58  L_L82  0.0527
K_K3189  L_L58  L_L83  0.1139
K_K3190  L_L58  L_L84  0.0456
K_K3191  L_L58  L_L85  0.1408
K_K3192  L_L58  L_L86  0.0291
K_K3193  L_L58  L_L87  0.0294
K_K3194  L_L58  L_L88  0.0302
K_K3195  L_L58  L_L89  0.0299
K_K3196  L_L58  L_L90  0.0304
K_K3197  L_L58  L_L91  0.0299
K_K3198  L_L58  L_L92  0.0307
K_K3199  L_L58  L_L93  0.0312
K_K3200  L_L58  L_L94  0.0200
K_K3201  L_L58  L_L95  0.0294
K_K3202  L_L58  L_L96  0.0203
K_K3203  L_L58  L_L97  0.0299
K_K3204  L_L58  L_L98  0.0204
K_K3205  L_L58  L_L99  0.0294
K_K3206  L_L58  L_L100  0.0201
K_K3207  L_L58  L_L101  0.0289
K_K3208  L_L58  L_L102  0.0200
K_K3209  L_L58  L_L103  0.0291
K_K3210  L_L58  L_L104  0.0202
K_K3211  L_L58  L_L105  0.0290
K_K3212  L_L58  L_L106  0.0204
K_K3213  L_L58  L_L107  0.0297
K_K3214  L_L58  L_L108  0.0202
K_K3215  L_L58  L_L109  0.0298
K_K3216  L_L58  L_L110  0.0137
K_K3217  L_L58  L_L111  0.0107
K_K3218  L_L58  L_L112  0.0108
K_K3219  L_L58  L_L113  0.0139
K_K3220  L_L58  L_L114  0.0138
K_K3221  L_L58  L_L115  0.0122
K_K3222  L_L58  L_L116  0.0122
K_K3223  L_L58  L_L117  0.0121
K_K3224  L_L58  L_L118  0.0123
K_K3225  L_L58  L_L119  0.0153
* *  Branch  N_C0_22 - N_C0_7
R_R59  N_C0_22  nR_59  0.941960m  TC=0,0
L_L59  nR_59  N_C0_7  2.135276uH
K_K3226  L_L59  L_L60  0.0886
K_K3227  L_L59  L_L61  0.1748
K_K3228  L_L59  L_L62  0.0479
K_K3229  L_L59  L_L63  0.0514
K_K3230  L_L59  L_L64  0.0527
K_K3231  L_L59  L_L65  0.0490
K_K3232  L_L59  L_L66  0.0429
K_K3233  L_L59  L_L67  0.0438
K_K3234  L_L59  L_L68  0.0464
K_K3235  L_L59  L_L69  0.0453
K_K3236  L_L59  L_L70  0.0264
K_K3237  L_L59  L_L71  0.0424
K_K3238  L_L59  L_L72  0.0269
K_K3239  L_L59  L_L73  0.0367
K_K3240  L_L59  L_L74  0.0264
K_K3241  L_L59  L_L75  0.0394
K_K3242  L_L59  L_L76  0.0259
K_K3243  L_L59  L_L77  0.0449
K_K3244  L_L59  L_L78  0.0261
K_K3245  L_L59  L_L79  0.0340
K_K3246  L_L59  L_L80  0.0268
K_K3247  L_L59  L_L81  0.0405
K_K3248  L_L59  L_L82  0.0267
K_K3249  L_L59  L_L83  0.0483
K_K3250  L_L59  L_L84  0.0260
K_K3251  L_L59  L_L85  0.0413
K_K3252  L_L59  L_L86  0.0170
K_K3253  L_L59  L_L87  0.0173
K_K3254  L_L59  L_L88  0.0174
K_K3255  L_L59  L_L89  0.0171
K_K3256  L_L59  L_L90  0.0182
K_K3257  L_L59  L_L91  0.0184
K_K3258  L_L59  L_L92  0.0187
K_K3259  L_L59  L_L93  0.0185
K_K3260  L_L59  L_L94  0.0128
K_K3261  L_L59  L_L95  0.0179
K_K3262  L_L59  L_L96  0.0129
K_K3263  L_L59  L_L97  0.0179
K_K3264  L_L59  L_L98  0.0128
K_K3265  L_L59  L_L99  0.0176
K_K3266  L_L59  L_L100  0.0127
K_K3267  L_L59  L_L101  0.0176
K_K3268  L_L59  L_L102  0.0128
K_K3269  L_L59  L_L103  0.0175
K_K3270  L_L59  L_L104  0.0129
K_K3271  L_L59  L_L105  0.0177
K_K3272  L_L59  L_L106  0.0129
K_K3273  L_L59  L_L107  0.0179
K_K3274  L_L59  L_L108  0.0127
K_K3275  L_L59  L_L109  0.0177
K_K3276  L_L59  L_L119  0.0100
* *  Branch  N_C0_17 - N_C0_23
R_R60  N_C0_17  nR_60  0.941960m  TC=0,0
L_L60  nR_60  N_C0_23  2.150429uH
K_K3277  L_L60  L_L61  0.1465
K_K3278  L_L60  L_L62  -0.0135
K_K3279  L_L60  L_L63  0.0223
K_K3280  L_L60  L_L64  -0.0135
K_K3281  L_L60  L_L65  -0.0850
K_K3282  L_L60  L_L66  0.1303
K_K3283  L_L60  L_L67  0.0918
K_K3284  L_L60  L_L68  0.0836
K_K3285  L_L60  L_L69  0.0977
K_K3286  L_L60  L_L70  0.0493
K_K3287  L_L60  L_L71  0.0916
K_K3288  L_L60  L_L72  0.0437
K_K3289  L_L60  L_L73  0.0961
K_K3290  L_L60  L_L74  0.0409
K_K3291  L_L60  L_L75  0.1290
K_K3292  L_L60  L_L76  0.0468
K_K3293  L_L60  L_L77  0.0961
K_K3294  L_L60  L_L78  0.0456
K_K3295  L_L60  L_L79  0.1408
K_K3296  L_L60  L_L80  0.0382
K_K3297  L_L60  L_L81  0.0804
K_K3298  L_L60  L_L82  0.0448
K_K3299  L_L60  L_L83  0.0837
K_K3300  L_L60  L_L84  0.0527
K_K3301  L_L60  L_L85  0.1139
K_K3302  L_L60  L_L86  0.0299
K_K3303  L_L60  L_L87  0.0291
K_K3304  L_L60  L_L88  0.0294
K_K3305  L_L60  L_L89  0.0302
K_K3306  L_L60  L_L90  0.0312
K_K3307  L_L60  L_L91  0.0304
K_K3308  L_L60  L_L92  0.0299
K_K3309  L_L60  L_L93  0.0307
K_K3310  L_L60  L_L94  0.0201
K_K3311  L_L60  L_L95  0.0289
K_K3312  L_L60  L_L96  0.0200
K_K3313  L_L60  L_L97  0.0294
K_K3314  L_L60  L_L98  0.0203
K_K3315  L_L60  L_L99  0.0299
K_K3316  L_L60  L_L100  0.0204
K_K3317  L_L60  L_L101  0.0294
K_K3318  L_L60  L_L102  0.0202
K_K3319  L_L60  L_L103  0.0298
K_K3320  L_L60  L_L104  0.0200
K_K3321  L_L60  L_L105  0.0291
K_K3322  L_L60  L_L106  0.0202
K_K3323  L_L60  L_L107  0.0290
K_K3324  L_L60  L_L108  0.0204
K_K3325  L_L60  L_L109  0.0297
K_K3326  L_L60  L_L110  0.0138
K_K3327  L_L60  L_L111  0.0107
K_K3328  L_L60  L_L112  0.0107
K_K3329  L_L60  L_L113  0.0138
K_K3330  L_L60  L_L114  0.0139
K_K3331  L_L60  L_L115  0.0123
K_K3332  L_L60  L_L116  0.0121
K_K3333  L_L60  L_L117  0.0122
K_K3334  L_L60  L_L118  0.0122
K_K3335  L_L60  L_L119  0.0153
* *  Branch  N_C0_23 - N_C0_8
R_R61  N_C0_23  nR_61  0.941960m  TC=0,0
L_L61  nR_61  N_C0_8  2.135276uH
K_K3336  L_L61  L_L62  0.0490
K_K3337  L_L61  L_L63  0.0479
K_K3338  L_L61  L_L64  0.0514
K_K3339  L_L61  L_L65  0.0527
K_K3340  L_L61  L_L66  0.0453
K_K3341  L_L61  L_L67  0.0429
K_K3342  L_L61  L_L68  0.0438
K_K3343  L_L61  L_L69  0.0464
K_K3344  L_L61  L_L70  0.0259
K_K3345  L_L61  L_L71  0.0449
K_K3346  L_L61  L_L72  0.0264
K_K3347  L_L61  L_L73  0.0424
K_K3348  L_L61  L_L74  0.0269
K_K3349  L_L61  L_L75  0.0367
K_K3350  L_L61  L_L76  0.0264
K_K3351  L_L61  L_L77  0.0394
K_K3352  L_L61  L_L78  0.0260
K_K3353  L_L61  L_L79  0.0413
K_K3354  L_L61  L_L80  0.0261
K_K3355  L_L61  L_L81  0.0340
K_K3356  L_L61  L_L82  0.0268
K_K3357  L_L61  L_L83  0.0405
K_K3358  L_L61  L_L84  0.0267
K_K3359  L_L61  L_L85  0.0483
K_K3360  L_L61  L_L86  0.0171
K_K3361  L_L61  L_L87  0.0170
K_K3362  L_L61  L_L88  0.0173
K_K3363  L_L61  L_L89  0.0174
K_K3364  L_L61  L_L90  0.0185
K_K3365  L_L61  L_L91  0.0182
K_K3366  L_L61  L_L92  0.0184
K_K3367  L_L61  L_L93  0.0187
K_K3368  L_L61  L_L94  0.0127
K_K3369  L_L61  L_L95  0.0176
K_K3370  L_L61  L_L96  0.0128
K_K3371  L_L61  L_L97  0.0179
K_K3372  L_L61  L_L98  0.0129
K_K3373  L_L61  L_L99  0.0179
K_K3374  L_L61  L_L100  0.0128
K_K3375  L_L61  L_L101  0.0176
K_K3376  L_L61  L_L102  0.0127
K_K3377  L_L61  L_L103  0.0177
K_K3378  L_L61  L_L104  0.0128
K_K3379  L_L61  L_L105  0.0175
K_K3380  L_L61  L_L106  0.0129
K_K3381  L_L61  L_L107  0.0177
K_K3382  L_L61  L_L108  0.0129
K_K3383  L_L61  L_L109  0.0179
K_K3384  L_L61  L_L119  0.0100
* *  Branch  N_C0_17 - N_C0_18
R_R62  N_C0_17  nR_62  0.541340m  TC=0,0
L_L62  nR_62  N_C0_18  1.082976uH
K_K3385  L_L62  L_L63  -0.0103
K_K3386  L_L62  L_L64  -0.1397
K_K3387  L_L62  L_L65  -0.0103
K_K3388  L_L62  L_L66  -0.0147
K_K3389  L_L62  L_L67  -0.0147
K_K3390  L_L62  L_L68  -0.0147
K_K3391  L_L62  L_L69  -0.0147
K_K3392  L_L62  L_L70  -0.0108
K_K3393  L_L62  L_L71  -0.0119
K_K3394  L_L62  L_L72  -0.0295
K_K3395  L_L62  L_L73  -0.0476
K_K3396  L_L62  L_L74  -0.0108
K_K3397  L_L62  L_L75  -0.0119
K_K3398  L_L62  L_L77  0.0593
K_K3399  L_L62  L_L78  -0.0312
K_K3400  L_L62  L_L79  -0.0832
K_K3401  L_L62  L_L80  -0.0108
K_K3402  L_L62  L_L81  -0.0119
K_K3403  L_L62  L_L83  0.0238
K_K3404  L_L62  L_L84  -0.0108
K_K3405  L_L62  L_L85  -0.0119
K_K3406  L_L62  L_L86  0.0333
K_K3407  L_L62  L_L87  0.0324
K_K3408  L_L62  L_L88  0.0315
K_K3409  L_L62  L_L89  0.0324
K_K3410  L_L62  L_L90  -0.0120
K_K3411  L_L62  L_L91  -0.0120
K_K3412  L_L62  L_L92  -0.0120
K_K3413  L_L62  L_L93  -0.0120
K_K3414  L_L62  L_L94  0.0205
K_K3415  L_L62  L_L96  0.0202
K_K3416  L_L62  L_L97  -0.0214
K_K3417  L_L62  L_L98  0.0203
K_K3418  L_L62  L_L100  0.0206
K_K3419  L_L62  L_L102  0.0206
K_K3420  L_L62  L_L103  -0.0218
K_K3421  L_L62  L_L104  0.0203
K_K3422  L_L62  L_L106  0.0202
K_K3423  L_L62  L_L108  0.0205
K_K3424  L_L62  L_L110  0.0139
K_K3425  L_L62  L_L111  0.0108
K_K3426  L_L62  L_L112  0.0107
K_K3427  L_L62  L_L113  0.0136
K_K3428  L_L62  L_L114  0.0137
K_K3429  L_L62  L_L115  0.0122
K_K3430  L_L62  L_L116  0.0121
K_K3431  L_L62  L_L117  0.0122
K_K3432  L_L62  L_L118  0.0121
K_K3433  L_L62  L_L119  0.0151
* *  Branch  N_C0_18 - N_C0_19
R_R63  N_C0_18  nR_63  0.541340m  TC=0,0
L_L63  nR_63  N_C0_19  1.082976uH
K_K3434  L_L63  L_L64  -0.0103
K_K3435  L_L63  L_L65  -0.1397
K_K3436  L_L63  L_L66  -0.0147
K_K3437  L_L63  L_L67  -0.0147
K_K3438  L_L63  L_L68  -0.0147
K_K3439  L_L63  L_L69  -0.0147
K_K3440  L_L63  L_L71  0.0593
K_K3441  L_L63  L_L72  -0.0108
K_K3442  L_L63  L_L73  -0.0119
K_K3443  L_L63  L_L74  -0.0295
K_K3444  L_L63  L_L75  -0.0476
K_K3445  L_L63  L_L76  -0.0108
K_K3446  L_L63  L_L77  -0.0119
K_K3447  L_L63  L_L78  -0.0108
K_K3448  L_L63  L_L79  -0.0119
K_K3449  L_L63  L_L80  -0.0312
K_K3450  L_L63  L_L81  -0.0832
K_K3451  L_L63  L_L82  -0.0108
K_K3452  L_L63  L_L83  -0.0119
K_K3453  L_L63  L_L85  0.0238
K_K3454  L_L63  L_L86  0.0324
K_K3455  L_L63  L_L87  0.0333
K_K3456  L_L63  L_L88  0.0324
K_K3457  L_L63  L_L89  0.0315
K_K3458  L_L63  L_L90  -0.0120
K_K3459  L_L63  L_L91  -0.0120
K_K3460  L_L63  L_L92  -0.0120
K_K3461  L_L63  L_L93  -0.0120
K_K3462  L_L63  L_L94  0.0206
K_K3463  L_L63  L_L96  0.0205
K_K3464  L_L63  L_L98  0.0202
K_K3465  L_L63  L_L99  -0.0214
K_K3466  L_L63  L_L100  0.0203
K_K3467  L_L63  L_L102  0.0205
K_K3468  L_L63  L_L104  0.0206
K_K3469  L_L63  L_L105  -0.0218
K_K3470  L_L63  L_L106  0.0203
K_K3471  L_L63  L_L108  0.0202
K_K3472  L_L63  L_L110  0.0137
K_K3473  L_L63  L_L111  0.0108
K_K3474  L_L63  L_L112  0.0108
K_K3475  L_L63  L_L113  0.0137
K_K3476  L_L63  L_L114  0.0136
K_K3477  L_L63  L_L115  0.0121
K_K3478  L_L63  L_L116  0.0122
K_K3479  L_L63  L_L117  0.0122
K_K3480  L_L63  L_L118  0.0121
K_K3481  L_L63  L_L119  0.0151
* *  Branch  N_C0_19 - N_C0_20
R_R64  N_C0_19  nR_64  0.541340m  TC=0,0
L_L64  nR_64  N_C0_20  1.082976uH
K_K3482  L_L64  L_L65  -0.0103
K_K3483  L_L64  L_L66  -0.0147
K_K3484  L_L64  L_L67  -0.0147
K_K3485  L_L64  L_L68  -0.0147
K_K3486  L_L64  L_L69  -0.0147
K_K3487  L_L64  L_L70  -0.0108
K_K3488  L_L64  L_L71  -0.0119
K_K3489  L_L64  L_L73  0.0593
K_K3490  L_L64  L_L74  -0.0108
K_K3491  L_L64  L_L75  -0.0119
K_K3492  L_L64  L_L76  -0.0295
K_K3493  L_L64  L_L77  -0.0476
K_K3494  L_L64  L_L79  0.0238
K_K3495  L_L64  L_L80  -0.0108
K_K3496  L_L64  L_L81  -0.0119
K_K3497  L_L64  L_L82  -0.0312
K_K3498  L_L64  L_L83  -0.0832
K_K3499  L_L64  L_L84  -0.0108
K_K3500  L_L64  L_L85  -0.0119
K_K3501  L_L64  L_L86  0.0315
K_K3502  L_L64  L_L87  0.0324
K_K3503  L_L64  L_L88  0.0333
K_K3504  L_L64  L_L89  0.0324
K_K3505  L_L64  L_L90  -0.0120
K_K3506  L_L64  L_L91  -0.0120
K_K3507  L_L64  L_L92  -0.0120
K_K3508  L_L64  L_L93  -0.0120
K_K3509  L_L64  L_L94  0.0203
K_K3510  L_L64  L_L96  0.0206
K_K3511  L_L64  L_L98  0.0205
K_K3512  L_L64  L_L100  0.0202
K_K3513  L_L64  L_L101  -0.0214
K_K3514  L_L64  L_L102  0.0202
K_K3515  L_L64  L_L104  0.0205
K_K3516  L_L64  L_L106  0.0206
K_K3517  L_L64  L_L107  -0.0218
K_K3518  L_L64  L_L108  0.0203
K_K3519  L_L64  L_L110  0.0136
K_K3520  L_L64  L_L111  0.0107
K_K3521  L_L64  L_L112  0.0108
K_K3522  L_L64  L_L113  0.0139
K_K3523  L_L64  L_L114  0.0137
K_K3524  L_L64  L_L115  0.0121
K_K3525  L_L64  L_L116  0.0122
K_K3526  L_L64  L_L117  0.0121
K_K3527  L_L64  L_L118  0.0122
K_K3528  L_L64  L_L119  0.0151
* *  Branch  N_C0_20 - N_C0_17
R_R65  N_C0_20  nR_65  0.541340m  TC=0,0
L_L65  nR_65  N_C0_17  1.082976uH
K_K3529  L_L65  L_L66  -0.0147
K_K3530  L_L65  L_L67  -0.0147
K_K3531  L_L65  L_L68  -0.0147
K_K3532  L_L65  L_L69  -0.0147
K_K3533  L_L65  L_L70  -0.0295
K_K3534  L_L65  L_L71  -0.0476
K_K3535  L_L65  L_L72  -0.0108
K_K3536  L_L65  L_L73  -0.0119
K_K3537  L_L65  L_L75  0.0593
K_K3538  L_L65  L_L76  -0.0108
K_K3539  L_L65  L_L77  -0.0119
K_K3540  L_L65  L_L78  -0.0108
K_K3541  L_L65  L_L79  -0.0119
K_K3542  L_L65  L_L81  0.0238
K_K3543  L_L65  L_L82  -0.0108
K_K3544  L_L65  L_L83  -0.0119
K_K3545  L_L65  L_L84  -0.0312
K_K3546  L_L65  L_L85  -0.0832
K_K3547  L_L65  L_L86  0.0324
K_K3548  L_L65  L_L87  0.0315
K_K3549  L_L65  L_L88  0.0324
K_K3550  L_L65  L_L89  0.0333
K_K3551  L_L65  L_L90  -0.0120
K_K3552  L_L65  L_L91  -0.0120
K_K3553  L_L65  L_L92  -0.0120
K_K3554  L_L65  L_L93  -0.0120
K_K3555  L_L65  L_L94  0.0202
K_K3556  L_L65  L_L95  -0.0214
K_K3557  L_L65  L_L96  0.0203
K_K3558  L_L65  L_L98  0.0206
K_K3559  L_L65  L_L100  0.0205
K_K3560  L_L65  L_L102  0.0203
K_K3561  L_L65  L_L104  0.0202
K_K3562  L_L65  L_L106  0.0205
K_K3563  L_L65  L_L108  0.0206
K_K3564  L_L65  L_L109  -0.0218
K_K3565  L_L65  L_L110  0.0137
K_K3566  L_L65  L_L111  0.0107
K_K3567  L_L65  L_L112  0.0107
K_K3568  L_L65  L_L113  0.0137
K_K3569  L_L65  L_L114  0.0139
K_K3570  L_L65  L_L115  0.0122
K_K3571  L_L65  L_L116  0.0121
K_K3572  L_L65  L_L117  0.0121
K_K3573  L_L65  L_L118  0.0122
K_K3574  L_L65  L_L119  0.0151
* *  Branch  N_C0_25 - N_C0_17
R_R66  N_C0_25  nR_66  280.220645m  TC=0,0
R_V165  nR_66  nV_165  3312.026022m  TC=0,0
L_V165  nR_66  nV_165  0.262509uH
R_V166  nV_165  nV_166  -3124.517633m  TC=0,0
L_V166  nV_165  nV_166  -0.262397uH
R_V167  nV_166  nV_167  1038.165571m  TC=0,0
L_V167  nV_166  nV_167  0.417612uH
R_V168  nV_167  nV_168  -991.972952m  TC=0,0
L_V168  nV_167  nV_168  -0.421775uH
R_V169  nV_168  nV_169  487.174008m  TC=0,0
L_V169  nV_168  nV_169  0.866328uH
R_V170  nV_169  nV_170  -454.098794m  TC=0,0
L_V170  nV_169  nV_170  -0.837044uH
R_V171  nV_170  nV_171  -1.848338m  TC=0,0
L_V171  nV_170  nV_171  -0.012791uH
R_V172  nV_171  nV_172  10.680997m  TC=0,0
L_V172  nV_171  nV_172  0.109470uH
R_V173  nV_172  nV_173  -2.050378m  TC=0,0
L_V173  nV_172  nV_173  -0.079923uH
R_V174  nV_173  nV_174  3.965345m  TC=0,0
L_V174  nV_173  nV_174  0.321445uH
L_L66  nV_174  N_C0_17  4.631342uH
K_K3575  L_L66  L_L67  0.2323
K_K3576  L_L66  L_L68  0.1796
K_K3577  L_L66  L_L69  0.2323
K_K3578  L_L66  L_L70  0.1671
K_K3579  L_L66  L_L71  0.1441
K_K3580  L_L66  L_L72  0.1475
K_K3581  L_L66  L_L73  0.1635
K_K3582  L_L66  L_L74  0.2141
K_K3583  L_L66  L_L75  0.3945
K_K3584  L_L66  L_L76  0.4008
K_K3585  L_L66  L_L77  0.2099
K_K3586  L_L66  L_L78  0.2141
K_K3587  L_L66  L_L79  0.3945
K_K3588  L_L66  L_L80  0.1475
K_K3589  L_L66  L_L81  0.1635
K_K3590  L_L66  L_L82  0.1671
K_K3591  L_L66  L_L83  0.1441
K_K3592  L_L66  L_L84  0.4008
K_K3593  L_L66  L_L85  0.2099
K_K3594  L_L66  L_L86  -0.0121
K_K3595  L_L66  L_L87  -0.0120
K_K3596  L_L66  L_L88  -0.0120
K_K3597  L_L66  L_L89  -0.0121
K_K3598  L_L66  L_L90  0.1307
K_K3599  L_L66  L_L91  0.1027
K_K3600  L_L66  L_L92  0.0928
K_K3601  L_L66  L_L93  0.1027
K_K3602  L_L66  L_L94  0.0527
K_K3603  L_L66  L_L95  0.0894
K_K3604  L_L66  L_L96  0.0517
K_K3605  L_L66  L_L97  0.0977
K_K3606  L_L66  L_L98  0.0543
K_K3607  L_L66  L_L99  0.1366
K_K3608  L_L66  L_L100  0.0553
K_K3609  L_L66  L_L101  0.1036
K_K3610  L_L66  L_L102  0.0543
K_K3611  L_L66  L_L103  0.1366
K_K3612  L_L66  L_L104  0.0517
K_K3613  L_L66  L_L105  0.0977
K_K3614  L_L66  L_L106  0.0527
K_K3615  L_L66  L_L107  0.0894
K_K3616  L_L66  L_L108  0.0553
K_K3617  L_L66  L_L109  0.1036
K_K3618  L_L66  L_L110  0.0341
K_K3619  L_L66  L_L111  0.0261
K_K3620  L_L66  L_L112  0.0258
K_K3621  L_L66  L_L113  0.0333
K_K3622  L_L66  L_L114  0.0341
K_K3623  L_L66  L_L115  0.0302
K_K3624  L_L66  L_L116  0.0294
K_K3625  L_L66  L_L117  0.0298
K_K3626  L_L66  L_L118  0.0298
K_K3627  L_L66  L_L119  0.0357
* *  Branch  N_C0_26 - N_C0_18
R_R67  N_C0_26  nR_67  280.220645m  TC=0,0
R_V175  nR_67  nV_175  3312.026022m  TC=0,0
L_V175  nR_67  nV_175  0.262509uH
R_V176  nV_175  nV_176  -3124.517633m  TC=0,0
L_V176  nV_175  nV_176  -0.262397uH
R_V177  nV_176  nV_177  1038.165571m  TC=0,0
L_V177  nV_176  nV_177  0.417612uH
R_V178  nV_177  nV_178  -991.972952m  TC=0,0
L_V178  nV_177  nV_178  -0.421775uH
R_V179  nV_178  nV_179  487.174008m  TC=0,0
L_V179  nV_178  nV_179  0.866328uH
R_V180  nV_179  nV_180  -454.098794m  TC=0,0
L_V180  nV_179  nV_180  -0.837044uH
R_V181  nV_180  nV_181  -1.848338m  TC=0,0
L_V181  nV_180  nV_181  -0.012791uH
R_V182  nV_181  nV_182  10.680997m  TC=0,0
L_V182  nV_181  nV_182  0.109470uH
R_V183  nV_182  nV_183  -2.050378m  TC=0,0
L_V183  nV_182  nV_183  -0.079923uH
R_V184  nV_183  nV_184  3.965345m  TC=0,0
L_V184  nV_183  nV_184  0.321445uH
L_L67  nV_184  N_C0_18  4.631342uH
K_K3628  L_L67  L_L68  0.2323
K_K3629  L_L67  L_L69  0.1796
K_K3630  L_L67  L_L70  0.4008
K_K3631  L_L67  L_L71  0.2099
K_K3632  L_L67  L_L72  0.1671
K_K3633  L_L67  L_L73  0.1441
K_K3634  L_L67  L_L74  0.1475
K_K3635  L_L67  L_L75  0.1635
K_K3636  L_L67  L_L76  0.2141
K_K3637  L_L67  L_L77  0.3945
K_K3638  L_L67  L_L78  0.4008
K_K3639  L_L67  L_L79  0.2099
K_K3640  L_L67  L_L80  0.2141
K_K3641  L_L67  L_L81  0.3945
K_K3642  L_L67  L_L82  0.1475
K_K3643  L_L67  L_L83  0.1635
K_K3644  L_L67  L_L84  0.1671
K_K3645  L_L67  L_L85  0.1441
K_K3646  L_L67  L_L86  -0.0121
K_K3647  L_L67  L_L87  -0.0121
K_K3648  L_L67  L_L88  -0.0120
K_K3649  L_L67  L_L89  -0.0120
K_K3650  L_L67  L_L90  0.1027
K_K3651  L_L67  L_L91  0.1307
K_K3652  L_L67  L_L92  0.1027
K_K3653  L_L67  L_L93  0.0928
K_K3654  L_L67  L_L94  0.0553
K_K3655  L_L67  L_L95  0.1036
K_K3656  L_L67  L_L96  0.0527
K_K3657  L_L67  L_L97  0.0894
K_K3658  L_L67  L_L98  0.0517
K_K3659  L_L67  L_L99  0.0977
K_K3660  L_L67  L_L100  0.0543
K_K3661  L_L67  L_L101  0.1366
K_K3662  L_L67  L_L102  0.0553
K_K3663  L_L67  L_L103  0.1036
K_K3664  L_L67  L_L104  0.0543
K_K3665  L_L67  L_L105  0.1366
K_K3666  L_L67  L_L106  0.0517
K_K3667  L_L67  L_L107  0.0977
K_K3668  L_L67  L_L108  0.0527
K_K3669  L_L67  L_L109  0.0894
K_K3670  L_L67  L_L110  0.0341
K_K3671  L_L67  L_L111  0.0268
K_K3672  L_L67  L_L112  0.0265
K_K3673  L_L67  L_L113  0.0333
K_K3674  L_L67  L_L114  0.0333
K_K3675  L_L67  L_L115  0.0298
K_K3676  L_L67  L_L116  0.0298
K_K3677  L_L67  L_L117  0.0302
K_K3678  L_L67  L_L118  0.0294
K_K3679  L_L67  L_L119  0.0357
* *  Branch  N_C0_27 - N_C0_19
R_R68  N_C0_27  nR_68  280.220645m  TC=0,0
R_V185  nR_68  nV_185  3312.026022m  TC=0,0
L_V185  nR_68  nV_185  0.262509uH
R_V186  nV_185  nV_186  -3124.517633m  TC=0,0
L_V186  nV_185  nV_186  -0.262397uH
R_V187  nV_186  nV_187  1038.165571m  TC=0,0
L_V187  nV_186  nV_187  0.417612uH
R_V188  nV_187  nV_188  -991.972952m  TC=0,0
L_V188  nV_187  nV_188  -0.421775uH
R_V189  nV_188  nV_189  487.174008m  TC=0,0
L_V189  nV_188  nV_189  0.866328uH
R_V190  nV_189  nV_190  -454.098794m  TC=0,0
L_V190  nV_189  nV_190  -0.837044uH
R_V191  nV_190  nV_191  -1.848338m  TC=0,0
L_V191  nV_190  nV_191  -0.012791uH
R_V192  nV_191  nV_192  10.680997m  TC=0,0
L_V192  nV_191  nV_192  0.109470uH
R_V193  nV_192  nV_193  -2.050378m  TC=0,0
L_V193  nV_192  nV_193  -0.079923uH
R_V194  nV_193  nV_194  3.965345m  TC=0,0
L_V194  nV_193  nV_194  0.321445uH
L_L68  nV_194  N_C0_19  4.631342uH
K_K3680  L_L68  L_L69  0.2323
K_K3681  L_L68  L_L70  0.2141
K_K3682  L_L68  L_L71  0.3945
K_K3683  L_L68  L_L72  0.4008
K_K3684  L_L68  L_L73  0.2099
K_K3685  L_L68  L_L74  0.1671
K_K3686  L_L68  L_L75  0.1441
K_K3687  L_L68  L_L76  0.1475
K_K3688  L_L68  L_L77  0.1635
K_K3689  L_L68  L_L78  0.1671
K_K3690  L_L68  L_L79  0.1441
K_K3691  L_L68  L_L80  0.4008
K_K3692  L_L68  L_L81  0.2099
K_K3693  L_L68  L_L82  0.2141
K_K3694  L_L68  L_L83  0.3945
K_K3695  L_L68  L_L84  0.1475
K_K3696  L_L68  L_L85  0.1635
K_K3697  L_L68  L_L86  -0.0120
K_K3698  L_L68  L_L87  -0.0121
K_K3699  L_L68  L_L88  -0.0121
K_K3700  L_L68  L_L89  -0.0120
K_K3701  L_L68  L_L90  0.0928
K_K3702  L_L68  L_L91  0.1027
K_K3703  L_L68  L_L92  0.1307
K_K3704  L_L68  L_L93  0.1027
K_K3705  L_L68  L_L94  0.0543
K_K3706  L_L68  L_L95  0.1366
K_K3707  L_L68  L_L96  0.0553
K_K3708  L_L68  L_L97  0.1036
K_K3709  L_L68  L_L98  0.0527
K_K3710  L_L68  L_L99  0.0894
K_K3711  L_L68  L_L100  0.0517
K_K3712  L_L68  L_L101  0.0977
K_K3713  L_L68  L_L102  0.0527
K_K3714  L_L68  L_L103  0.0894
K_K3715  L_L68  L_L104  0.0553
K_K3716  L_L68  L_L105  0.1036
K_K3717  L_L68  L_L106  0.0543
K_K3718  L_L68  L_L107  0.1366
K_K3719  L_L68  L_L108  0.0517
K_K3720  L_L68  L_L109  0.0977
K_K3721  L_L68  L_L110  0.0333
K_K3722  L_L68  L_L111  0.0265
K_K3723  L_L68  L_L112  0.0268
K_K3724  L_L68  L_L113  0.0341
K_K3725  L_L68  L_L114  0.0333
K_K3726  L_L68  L_L115  0.0294
K_K3727  L_L68  L_L116  0.0302
K_K3728  L_L68  L_L117  0.0298
K_K3729  L_L68  L_L118  0.0298
K_K3730  L_L68  L_L119  0.0357
* *  Branch  N_C0_28 - N_C0_20
R_R69  N_C0_28  nR_69  280.220645m  TC=0,0
R_V195  nR_69  nV_195  3312.026022m  TC=0,0
L_V195  nR_69  nV_195  0.262509uH
R_V196  nV_195  nV_196  -3124.517633m  TC=0,0
L_V196  nV_195  nV_196  -0.262397uH
R_V197  nV_196  nV_197  1038.165571m  TC=0,0
L_V197  nV_196  nV_197  0.417612uH
R_V198  nV_197  nV_198  -991.972952m  TC=0,0
L_V198  nV_197  nV_198  -0.421775uH
R_V199  nV_198  nV_199  487.174008m  TC=0,0
L_V199  nV_198  nV_199  0.866328uH
R_V200  nV_199  nV_200  -454.098794m  TC=0,0
L_V200  nV_199  nV_200  -0.837044uH
R_V201  nV_200  nV_201  -1.848338m  TC=0,0
L_V201  nV_200  nV_201  -0.012791uH
R_V202  nV_201  nV_202  10.680997m  TC=0,0
L_V202  nV_201  nV_202  0.109470uH
R_V203  nV_202  nV_203  -2.050378m  TC=0,0
L_V203  nV_202  nV_203  -0.079923uH
R_V204  nV_203  nV_204  3.965345m  TC=0,0
L_V204  nV_203  nV_204  0.321445uH
L_L69  nV_204  N_C0_20  4.631342uH
K_K3731  L_L69  L_L70  0.1475
K_K3732  L_L69  L_L71  0.1635
K_K3733  L_L69  L_L72  0.2141
K_K3734  L_L69  L_L73  0.3945
K_K3735  L_L69  L_L74  0.4008
K_K3736  L_L69  L_L75  0.2099
K_K3737  L_L69  L_L76  0.1671
K_K3738  L_L69  L_L77  0.1441
K_K3739  L_L69  L_L78  0.1475
K_K3740  L_L69  L_L79  0.1635
K_K3741  L_L69  L_L80  0.1671
K_K3742  L_L69  L_L81  0.1441
K_K3743  L_L69  L_L82  0.4008
K_K3744  L_L69  L_L83  0.2099
K_K3745  L_L69  L_L84  0.2141
K_K3746  L_L69  L_L85  0.3945
K_K3747  L_L69  L_L86  -0.0120
K_K3748  L_L69  L_L87  -0.0120
K_K3749  L_L69  L_L88  -0.0121
K_K3750  L_L69  L_L89  -0.0121
K_K3751  L_L69  L_L90  0.1027
K_K3752  L_L69  L_L91  0.0928
K_K3753  L_L69  L_L92  0.1027
K_K3754  L_L69  L_L93  0.1307
K_K3755  L_L69  L_L94  0.0517
K_K3756  L_L69  L_L95  0.0977
K_K3757  L_L69  L_L96  0.0543
K_K3758  L_L69  L_L97  0.1366
K_K3759  L_L69  L_L98  0.0553
K_K3760  L_L69  L_L99  0.1036
K_K3761  L_L69  L_L100  0.0527
K_K3762  L_L69  L_L101  0.0894
K_K3763  L_L69  L_L102  0.0517
K_K3764  L_L69  L_L103  0.0977
K_K3765  L_L69  L_L104  0.0527
K_K3766  L_L69  L_L105  0.0894
K_K3767  L_L69  L_L106  0.0553
K_K3768  L_L69  L_L107  0.1036
K_K3769  L_L69  L_L108  0.0543
K_K3770  L_L69  L_L109  0.1366
K_K3771  L_L69  L_L110  0.0333
K_K3772  L_L69  L_L111  0.0258
K_K3773  L_L69  L_L112  0.0261
K_K3774  L_L69  L_L113  0.0341
K_K3775  L_L69  L_L114  0.0341
K_K3776  L_L69  L_L115  0.0298
K_K3777  L_L69  L_L116  0.0298
K_K3778  L_L69  L_L117  0.0294
K_K3779  L_L69  L_L118  0.0302
K_K3780  L_L69  L_L119  0.0357
* *  Branch  N_C0_26 - N_C0_29
R_R70  N_C0_26  nR_70  146.279471m  TC=0,0
R_V205  nR_70  nV_205  1728.928121m  TC=0,0
L_V205  nR_70  nV_205  0.137034uH
R_V206  nV_205  nV_206  -1631.045869m  TC=0,0
L_V206  nV_205  nV_206  -0.136975uH
R_V207  nV_206  nV_207  541.938394m  TC=0,0
L_V207  nV_206  nV_207  0.218000uH
R_V208  nV_207  nV_208  -517.825140m  TC=0,0
L_V208  nV_207  nV_208  -0.220173uH
R_V209  nV_208  nV_209  254.312231m  TC=0,0
L_V209  nV_208  nV_209  0.452236uH
R_V210  nV_209  nV_210  -237.046463m  TC=0,0
L_V210  nV_209  nV_210  -0.436950uH
R_V211  nV_210  nV_211  -0.964860m  TC=0,0
L_V211  nV_210  nV_211  -0.006677uH
R_V212  nV_211  nV_212  5.575644m  TC=0,0
L_V212  nV_211  nV_212  0.057145uH
R_V213  nV_212  nV_213  -1.070329m  TC=0,0
L_V213  nV_212  nV_213  -0.041721uH
R_V214  nV_213  nV_214  2.069971m  TC=0,0
L_V214  nV_213  nV_214  0.167799uH
L_L70  nV_214  N_C0_29  2.108109uH
K_K3781  L_L70  L_L71  0.1554
K_K3782  L_L70  L_L72  0.1907
K_K3783  L_L70  L_L73  0.0972
K_K3784  L_L70  L_L74  0.1289
K_K3785  L_L70  L_L75  0.0843
K_K3786  L_L70  L_L76  0.1907
K_K3787  L_L70  L_L77  0.1161
K_K3788  L_L70  L_L78  0.3924
K_K3789  L_L70  L_L79  0.1058
K_K3790  L_L70  L_L80  0.2984
K_K3791  L_L70  L_L81  0.1334
K_K3792  L_L70  L_L82  0.1527
K_K3793  L_L70  L_L83  0.1058
K_K3794  L_L70  L_L84  0.1722
K_K3795  L_L70  L_L85  0.1011
K_K3796  L_L70  L_L87  0.0631
K_K3797  L_L70  L_L89  -0.0450
K_K3798  L_L70  L_L90  0.0986
K_K3799  L_L70  L_L91  0.1374
K_K3800  L_L70  L_L92  0.1045
K_K3801  L_L70  L_L93  0.0903
K_K3802  L_L70  L_L94  0.0574
K_K3803  L_L70  L_L95  0.1216
K_K3804  L_L70  L_L96  0.0495
K_K3805  L_L70  L_L97  0.0907
K_K3806  L_L70  L_L98  0.0429
K_K3807  L_L70  L_L99  0.0873
K_K3808  L_L70  L_L100  0.0503
K_K3809  L_L70  L_L101  0.1490
K_K3810  L_L70  L_L102  0.0515
K_K3811  L_L70  L_L103  0.1034
K_K3812  L_L70  L_L104  0.0456
K_K3813  L_L70  L_L105  0.1370
K_K3814  L_L70  L_L106  0.0484
K_K3815  L_L70  L_L107  0.1034
K_K3816  L_L70  L_L108  0.0540
K_K3817  L_L70  L_L109  0.0987
K_K3818  L_L70  L_L110  0.0334
K_K3819  L_L70  L_L111  0.0264
K_K3820  L_L70  L_L112  0.0262
K_K3821  L_L70  L_L113  0.0328
K_K3822  L_L70  L_L114  0.0325
K_K3823  L_L70  L_L115  0.0292
K_K3824  L_L70  L_L116  0.0295
K_K3825  L_L70  L_L117  0.0297
K_K3826  L_L70  L_L118  0.0290
K_K3827  L_L70  L_L119  0.0340
* *  Branch  N_C0_29 - N_C0_19
R_R71  N_C0_29  nR_71  0.941960m  TC=0,0
L_L71  nR_71  N_C0_19  2.158906uH
K_K3828  L_L71  L_L72  0.1161
K_K3829  L_L71  L_L73  0.1837
K_K3830  L_L71  L_L74  0.0843
K_K3831  L_L71  L_L75  0.1234
K_K3832  L_L71  L_L76  0.0972
K_K3833  L_L71  L_L77  0.1837
K_K3834  L_L71  L_L78  0.1058
K_K3835  L_L71  L_L79  0.1466
K_K3836  L_L71  L_L80  0.1334
K_K3837  L_L71  L_L81  0.2888
K_K3838  L_L71  L_L82  0.1058
K_K3839  L_L71  L_L83  0.3807
K_K3840  L_L71  L_L84  0.1011
K_K3841  L_L71  L_L85  0.1656
K_K3842  L_L71  L_L86  0.0545
K_K3843  L_L71  L_L87  0.0582
K_K3844  L_L71  L_L88  0.0569
K_K3845  L_L71  L_L89  0.0534
K_K3846  L_L71  L_L90  0.0499
K_K3847  L_L71  L_L91  0.0524
K_K3848  L_L71  L_L92  0.0535
K_K3849  L_L71  L_L93  0.0508
K_K3850  L_L71  L_L94  0.0317
K_K3851  L_L71  L_L95  0.0550
K_K3852  L_L71  L_L96  0.0319
K_K3853  L_L71  L_L97  0.0472
K_K3854  L_L71  L_L98  0.0311
K_K3855  L_L71  L_L99  0.0406
K_K3856  L_L71  L_L100  0.0310
K_K3857  L_L71  L_L101  0.0480
K_K3858  L_L71  L_L102  0.0314
K_K3859  L_L71  L_L103  0.0461
K_K3860  L_L71  L_L104  0.0320
K_K3861  L_L71  L_L105  0.0434
K_K3862  L_L71  L_L106  0.0314
K_K3863  L_L71  L_L107  0.0492
K_K3864  L_L71  L_L108  0.0309
K_K3865  L_L71  L_L109  0.0516
K_K3866  L_L71  L_L110  0.0207
K_K3867  L_L71  L_L111  0.0164
K_K3868  L_L71  L_L112  0.0165
K_K3869  L_L71  L_L113  0.0209
K_K3870  L_L71  L_L114  0.0206
K_K3871  L_L71  L_L115  0.0183
K_K3872  L_L71  L_L116  0.0186
K_K3873  L_L71  L_L117  0.0185
K_K3874  L_L71  L_L118  0.0184
K_K3875  L_L71  L_L119  0.0225
* *  Branch  N_C0_27 - N_C0_30
R_R72  N_C0_27  nR_72  146.279471m  TC=0,0
R_V215  nR_72  nV_215  1728.928121m  TC=0,0
L_V215  nR_72  nV_215  0.137034uH
R_V216  nV_215  nV_216  -1631.045869m  TC=0,0
L_V216  nV_215  nV_216  -0.136975uH
R_V217  nV_216  nV_217  541.938394m  TC=0,0
L_V217  nV_216  nV_217  0.218000uH
R_V218  nV_217  nV_218  -517.825140m  TC=0,0
L_V218  nV_217  nV_218  -0.220173uH
R_V219  nV_218  nV_219  254.312231m  TC=0,0
L_V219  nV_218  nV_219  0.452236uH
R_V220  nV_219  nV_220  -237.046463m  TC=0,0
L_V220  nV_219  nV_220  -0.436950uH
R_V221  nV_220  nV_221  -0.964860m  TC=0,0
L_V221  nV_220  nV_221  -0.006677uH
R_V222  nV_221  nV_222  5.575644m  TC=0,0
L_V222  nV_221  nV_222  0.057145uH
R_V223  nV_222  nV_223  -1.070329m  TC=0,0
L_V223  nV_222  nV_223  -0.041721uH
R_V224  nV_223  nV_224  2.069971m  TC=0,0
L_V224  nV_223  nV_224  0.167799uH
L_L72  nV_224  N_C0_30  2.108109uH
K_K3876  L_L72  L_L73  0.1554
K_K3877  L_L72  L_L74  0.1907
K_K3878  L_L72  L_L75  0.0972
K_K3879  L_L72  L_L76  0.1289
K_K3880  L_L72  L_L77  0.0843
K_K3881  L_L72  L_L78  0.1722
K_K3882  L_L72  L_L79  0.1011
K_K3883  L_L72  L_L80  0.3924
K_K3884  L_L72  L_L81  0.1058
K_K3885  L_L72  L_L82  0.2984
K_K3886  L_L72  L_L83  0.1334
K_K3887  L_L72  L_L84  0.1527
K_K3888  L_L72  L_L85  0.1058
K_K3889  L_L72  L_L86  -0.0450
K_K3890  L_L72  L_L88  0.0631
K_K3891  L_L72  L_L90  0.0903
K_K3892  L_L72  L_L91  0.0986
K_K3893  L_L72  L_L92  0.1374
K_K3894  L_L72  L_L93  0.1045
K_K3895  L_L72  L_L94  0.0503
K_K3896  L_L72  L_L95  0.1490
K_K3897  L_L72  L_L96  0.0574
K_K3898  L_L72  L_L97  0.1216
K_K3899  L_L72  L_L98  0.0495
K_K3900  L_L72  L_L99  0.0907
K_K3901  L_L72  L_L100  0.0429
K_K3902  L_L72  L_L101  0.0873
K_K3903  L_L72  L_L102  0.0540
K_K3904  L_L72  L_L103  0.0987
K_K3905  L_L72  L_L104  0.0515
K_K3906  L_L72  L_L105  0.1034
K_K3907  L_L72  L_L106  0.0456
K_K3908  L_L72  L_L107  0.1370
K_K3909  L_L72  L_L108  0.0484
K_K3910  L_L72  L_L109  0.1034
K_K3911  L_L72  L_L110  0.0325
K_K3912  L_L72  L_L111  0.0258
K_K3913  L_L72  L_L112  0.0263
K_K3914  L_L72  L_L113  0.0337
K_K3915  L_L72  L_L114  0.0328
K_K3916  L_L72  L_L115  0.0290
K_K3917  L_L72  L_L116  0.0297
K_K3918  L_L72  L_L117  0.0292
K_K3919  L_L72  L_L118  0.0295
K_K3920  L_L72  L_L119  0.0340
* *  Branch  N_C0_30 - N_C0_20
R_R73  N_C0_30  nR_73  0.941960m  TC=0,0
L_L73  nR_73  N_C0_20  2.158906uH
K_K3921  L_L73  L_L74  0.1161
K_K3922  L_L73  L_L75  0.1837
K_K3923  L_L73  L_L76  0.0843
K_K3924  L_L73  L_L77  0.1234
K_K3925  L_L73  L_L78  0.1011
K_K3926  L_L73  L_L79  0.1656
K_K3927  L_L73  L_L80  0.1058
K_K3928  L_L73  L_L81  0.1466
K_K3929  L_L73  L_L82  0.1334
K_K3930  L_L73  L_L83  0.2888
K_K3931  L_L73  L_L84  0.1058
K_K3932  L_L73  L_L85  0.3807
K_K3933  L_L73  L_L86  0.0534
K_K3934  L_L73  L_L87  0.0545
K_K3935  L_L73  L_L88  0.0582
K_K3936  L_L73  L_L89  0.0569
K_K3937  L_L73  L_L90  0.0508
K_K3938  L_L73  L_L91  0.0499
K_K3939  L_L73  L_L92  0.0524
K_K3940  L_L73  L_L93  0.0535
K_K3941  L_L73  L_L94  0.0310
K_K3942  L_L73  L_L95  0.0480
K_K3943  L_L73  L_L96  0.0317
K_K3944  L_L73  L_L97  0.0550
K_K3945  L_L73  L_L98  0.0319
K_K3946  L_L73  L_L99  0.0472
K_K3947  L_L73  L_L100  0.0311
K_K3948  L_L73  L_L101  0.0406
K_K3949  L_L73  L_L102  0.0309
K_K3950  L_L73  L_L103  0.0516
K_K3951  L_L73  L_L104  0.0314
K_K3952  L_L73  L_L105  0.0461
K_K3953  L_L73  L_L106  0.0320
K_K3954  L_L73  L_L107  0.0434
K_K3955  L_L73  L_L108  0.0314
K_K3956  L_L73  L_L109  0.0492
K_K3957  L_L73  L_L110  0.0206
K_K3958  L_L73  L_L111  0.0161
K_K3959  L_L73  L_L112  0.0163
K_K3960  L_L73  L_L113  0.0210
K_K3961  L_L73  L_L114  0.0209
K_K3962  L_L73  L_L115  0.0184
K_K3963  L_L73  L_L116  0.0185
K_K3964  L_L73  L_L117  0.0183
K_K3965  L_L73  L_L118  0.0186
K_K3966  L_L73  L_L119  0.0225
* *  Branch  N_C0_28 - N_C0_31
R_R74  N_C0_28  nR_74  146.279471m  TC=0,0
R_V225  nR_74  nV_225  1728.928121m  TC=0,0
L_V225  nR_74  nV_225  0.137034uH
R_V226  nV_225  nV_226  -1631.045869m  TC=0,0
L_V226  nV_225  nV_226  -0.136975uH
R_V227  nV_226  nV_227  541.938394m  TC=0,0
L_V227  nV_226  nV_227  0.218000uH
R_V228  nV_227  nV_228  -517.825140m  TC=0,0
L_V228  nV_227  nV_228  -0.220173uH
R_V229  nV_228  nV_229  254.312231m  TC=0,0
L_V229  nV_228  nV_229  0.452236uH
R_V230  nV_229  nV_230  -237.046463m  TC=0,0
L_V230  nV_229  nV_230  -0.436950uH
R_V231  nV_230  nV_231  -0.964860m  TC=0,0
L_V231  nV_230  nV_231  -0.006677uH
R_V232  nV_231  nV_232  5.575644m  TC=0,0
L_V232  nV_231  nV_232  0.057145uH
R_V233  nV_232  nV_233  -1.070329m  TC=0,0
L_V233  nV_232  nV_233  -0.041721uH
R_V234  nV_233  nV_234  2.069971m  TC=0,0
L_V234  nV_233  nV_234  0.167799uH
L_L74  nV_234  N_C0_31  2.108109uH
K_K3967  L_L74  L_L75  0.1554
K_K3968  L_L74  L_L76  0.1907
K_K3969  L_L74  L_L77  0.0972
K_K3970  L_L74  L_L78  0.1527
K_K3971  L_L74  L_L79  0.1058
K_K3972  L_L74  L_L80  0.1722
K_K3973  L_L74  L_L81  0.1011
K_K3974  L_L74  L_L82  0.3924
K_K3975  L_L74  L_L83  0.1058
K_K3976  L_L74  L_L84  0.2984
K_K3977  L_L74  L_L85  0.1334
K_K3978  L_L74  L_L87  -0.0450
K_K3979  L_L74  L_L89  0.0631
K_K3980  L_L74  L_L90  0.1045
K_K3981  L_L74  L_L91  0.0903
K_K3982  L_L74  L_L92  0.0986
K_K3983  L_L74  L_L93  0.1374
K_K3984  L_L74  L_L94  0.0429
K_K3985  L_L74  L_L95  0.0873
K_K3986  L_L74  L_L96  0.0503
K_K3987  L_L74  L_L97  0.1490
K_K3988  L_L74  L_L98  0.0574
K_K3989  L_L74  L_L99  0.1216
K_K3990  L_L74  L_L100  0.0495
K_K3991  L_L74  L_L101  0.0907
K_K3992  L_L74  L_L102  0.0484
K_K3993  L_L74  L_L103  0.1034
K_K3994  L_L74  L_L104  0.0540
K_K3995  L_L74  L_L105  0.0987
K_K3996  L_L74  L_L106  0.0515
K_K3997  L_L74  L_L107  0.1034
K_K3998  L_L74  L_L108  0.0456
K_K3999  L_L74  L_L109  0.1370
K_K4000  L_L74  L_L110  0.0328
K_K4001  L_L74  L_L111  0.0253
K_K4002  L_L74  L_L112  0.0255
K_K4003  L_L74  L_L113  0.0334
K_K4004  L_L74  L_L114  0.0337
K_K4005  L_L74  L_L115  0.0295
K_K4006  L_L74  L_L116  0.0292
K_K4007  L_L74  L_L117  0.0290
K_K4008  L_L74  L_L118  0.0297
K_K4009  L_L74  L_L119  0.0340
* *  Branch  N_C0_31 - N_C0_17
R_R75  N_C0_31  nR_75  0.941960m  TC=0,0
L_L75  nR_75  N_C0_17  2.158906uH
K_K4010  L_L75  L_L76  0.1161
K_K4011  L_L75  L_L77  0.1837
K_K4012  L_L75  L_L78  0.1058
K_K4013  L_L75  L_L79  0.3807
K_K4014  L_L75  L_L80  0.1011
K_K4015  L_L75  L_L81  0.1656
K_K4016  L_L75  L_L82  0.1058
K_K4017  L_L75  L_L83  0.1466
K_K4018  L_L75  L_L84  0.1334
K_K4019  L_L75  L_L85  0.2888
K_K4020  L_L75  L_L86  0.0569
K_K4021  L_L75  L_L87  0.0534
K_K4022  L_L75  L_L88  0.0545
K_K4023  L_L75  L_L89  0.0582
K_K4024  L_L75  L_L90  0.0535
K_K4025  L_L75  L_L91  0.0508
K_K4026  L_L75  L_L92  0.0499
K_K4027  L_L75  L_L93  0.0524
K_K4028  L_L75  L_L94  0.0311
K_K4029  L_L75  L_L95  0.0406
K_K4030  L_L75  L_L96  0.0310
K_K4031  L_L75  L_L97  0.0480
K_K4032  L_L75  L_L98  0.0317
K_K4033  L_L75  L_L99  0.0550
K_K4034  L_L75  L_L100  0.0319
K_K4035  L_L75  L_L101  0.0472
K_K4036  L_L75  L_L102  0.0314
K_K4037  L_L75  L_L103  0.0492
K_K4038  L_L75  L_L104  0.0309
K_K4039  L_L75  L_L105  0.0516
K_K4040  L_L75  L_L106  0.0314
K_K4041  L_L75  L_L107  0.0461
K_K4042  L_L75  L_L108  0.0320
K_K4043  L_L75  L_L109  0.0434
K_K4044  L_L75  L_L110  0.0209
K_K4045  L_L75  L_L111  0.0162
K_K4046  L_L75  L_L112  0.0161
K_K4047  L_L75  L_L113  0.0207
K_K4048  L_L75  L_L114  0.0210
K_K4049  L_L75  L_L115  0.0186
K_K4050  L_L75  L_L116  0.0183
K_K4051  L_L75  L_L117  0.0184
K_K4052  L_L75  L_L118  0.0185
K_K4053  L_L75  L_L119  0.0225
* *  Branch  N_C0_25 - N_C0_32
R_R76  N_C0_25  nR_76  146.279471m  TC=0,0
R_V235  nR_76  nV_235  1728.928121m  TC=0,0
L_V235  nR_76  nV_235  0.137034uH
R_V236  nV_235  nV_236  -1631.045869m  TC=0,0
L_V236  nV_235  nV_236  -0.136975uH
R_V237  nV_236  nV_237  541.938394m  TC=0,0
L_V237  nV_236  nV_237  0.218000uH
R_V238  nV_237  nV_238  -517.825140m  TC=0,0
L_V238  nV_237  nV_238  -0.220173uH
R_V239  nV_238  nV_239  254.312231m  TC=0,0
L_V239  nV_238  nV_239  0.452236uH
R_V240  nV_239  nV_240  -237.046463m  TC=0,0
L_V240  nV_239  nV_240  -0.436950uH
R_V241  nV_240  nV_241  -0.964860m  TC=0,0
L_V241  nV_240  nV_241  -0.006677uH
R_V242  nV_241  nV_242  5.575644m  TC=0,0
L_V242  nV_241  nV_242  0.057145uH
R_V243  nV_242  nV_243  -1.070329m  TC=0,0
L_V243  nV_242  nV_243  -0.041721uH
R_V244  nV_243  nV_244  2.069971m  TC=0,0
L_V244  nV_243  nV_244  0.167799uH
L_L76  nV_244  N_C0_32  2.108109uH
K_K4054  L_L76  L_L77  0.1554
K_K4055  L_L76  L_L78  0.2984
K_K4056  L_L76  L_L79  0.1334
K_K4057  L_L76  L_L80  0.1527
K_K4058  L_L76  L_L81  0.1058
K_K4059  L_L76  L_L82  0.1722
K_K4060  L_L76  L_L83  0.1011
K_K4061  L_L76  L_L84  0.3924
K_K4062  L_L76  L_L85  0.1058
K_K4063  L_L76  L_L86  0.0631
K_K4064  L_L76  L_L88  -0.0450
K_K4065  L_L76  L_L90  0.1374
K_K4066  L_L76  L_L91  0.1045
K_K4067  L_L76  L_L92  0.0903
K_K4068  L_L76  L_L93  0.0986
K_K4069  L_L76  L_L94  0.0495
K_K4070  L_L76  L_L95  0.0907
K_K4071  L_L76  L_L96  0.0429
K_K4072  L_L76  L_L97  0.0873
K_K4073  L_L76  L_L98  0.0503
K_K4074  L_L76  L_L99  0.1490
K_K4075  L_L76  L_L100  0.0574
K_K4076  L_L76  L_L101  0.1216
K_K4077  L_L76  L_L102  0.0456
K_K4078  L_L76  L_L103  0.1370
K_K4079  L_L76  L_L104  0.0484
K_K4080  L_L76  L_L105  0.1034
K_K4081  L_L76  L_L106  0.0540
K_K4082  L_L76  L_L107  0.0987
K_K4083  L_L76  L_L108  0.0515
K_K4084  L_L76  L_L109  0.1034
K_K4085  L_L76  L_L110  0.0337
K_K4086  L_L76  L_L111  0.0258
K_K4087  L_L76  L_L112  0.0254
K_K4088  L_L76  L_L113  0.0325
K_K4089  L_L76  L_L114  0.0334
K_K4090  L_L76  L_L115  0.0297
K_K4091  L_L76  L_L116  0.0290
K_K4092  L_L76  L_L117  0.0295
K_K4093  L_L76  L_L118  0.0292
K_K4094  L_L76  L_L119  0.0340
* *  Branch  N_C0_32 - N_C0_18
R_R77  N_C0_32  nR_77  0.941960m  TC=0,0
L_L77  nR_77  N_C0_18  2.158906uH
K_K4095  L_L77  L_L78  0.1334
K_K4096  L_L77  L_L79  0.2888
K_K4097  L_L77  L_L80  0.1058
K_K4098  L_L77  L_L81  0.3807
K_K4099  L_L77  L_L82  0.1011
K_K4100  L_L77  L_L83  0.1656
K_K4101  L_L77  L_L84  0.1058
K_K4102  L_L77  L_L85  0.1466
K_K4103  L_L77  L_L86  0.0582
K_K4104  L_L77  L_L87  0.0569
K_K4105  L_L77  L_L88  0.0534
K_K4106  L_L77  L_L89  0.0545
K_K4107  L_L77  L_L90  0.0524
K_K4108  L_L77  L_L91  0.0535
K_K4109  L_L77  L_L92  0.0508
K_K4110  L_L77  L_L93  0.0499
K_K4111  L_L77  L_L94  0.0319
K_K4112  L_L77  L_L95  0.0472
K_K4113  L_L77  L_L96  0.0311
K_K4114  L_L77  L_L97  0.0406
K_K4115  L_L77  L_L98  0.0310
K_K4116  L_L77  L_L99  0.0480
K_K4117  L_L77  L_L100  0.0317
K_K4118  L_L77  L_L101  0.0550
K_K4119  L_L77  L_L102  0.0320
K_K4120  L_L77  L_L103  0.0434
K_K4121  L_L77  L_L104  0.0314
K_K4122  L_L77  L_L105  0.0492
K_K4123  L_L77  L_L106  0.0309
K_K4124  L_L77  L_L107  0.0516
K_K4125  L_L77  L_L108  0.0314
K_K4126  L_L77  L_L109  0.0461
K_K4127  L_L77  L_L110  0.0210
K_K4128  L_L77  L_L111  0.0164
K_K4129  L_L77  L_L112  0.0163
K_K4130  L_L77  L_L113  0.0206
K_K4131  L_L77  L_L114  0.0207
K_K4132  L_L77  L_L115  0.0185
K_K4133  L_L77  L_L116  0.0184
K_K4134  L_L77  L_L117  0.0186
K_K4135  L_L77  L_L118  0.0183
K_K4136  L_L77  L_L119  0.0225
* *  Branch  N_C0_26 - N_C0_32
R_R78  N_C0_26  nR_78  146.279471m  TC=0,0
R_V245  nR_78  nV_245  1728.928121m  TC=0,0
L_V245  nR_78  nV_245  0.137034uH
R_V246  nV_245  nV_246  -1631.045869m  TC=0,0
L_V246  nV_245  nV_246  -0.136975uH
R_V247  nV_246  nV_247  541.938394m  TC=0,0
L_V247  nV_246  nV_247  0.218000uH
R_V248  nV_247  nV_248  -517.825140m  TC=0,0
L_V248  nV_247  nV_248  -0.220173uH
R_V249  nV_248  nV_249  254.312231m  TC=0,0
L_V249  nV_248  nV_249  0.452236uH
R_V250  nV_249  nV_250  -237.046463m  TC=0,0
L_V250  nV_249  nV_250  -0.436950uH
R_V251  nV_250  nV_251  -0.964860m  TC=0,0
L_V251  nV_250  nV_251  -0.006677uH
R_V252  nV_251  nV_252  5.575644m  TC=0,0
L_V252  nV_251  nV_252  0.057145uH
R_V253  nV_252  nV_253  -1.070329m  TC=0,0
L_V253  nV_252  nV_253  -0.041721uH
R_V254  nV_253  nV_254  2.069971m  TC=0,0
L_V254  nV_253  nV_254  0.167799uH
L_L78  nV_254  N_C0_32  2.108109uH
K_K4137  L_L78  L_L79  0.1554
K_K4138  L_L78  L_L80  0.1907
K_K4139  L_L78  L_L81  0.1161
K_K4140  L_L78  L_L82  0.1289
K_K4141  L_L78  L_L83  0.0843
K_K4142  L_L78  L_L84  0.1907
K_K4143  L_L78  L_L85  0.0972
K_K4144  L_L78  L_L86  -0.0809
K_K4145  L_L78  L_L88  0.0272
K_K4146  L_L78  L_L90  0.1045
K_K4147  L_L78  L_L91  0.1374
K_K4148  L_L78  L_L92  0.0986
K_K4149  L_L78  L_L93  0.0903
K_K4150  L_L78  L_L94  0.0515
K_K4151  L_L78  L_L95  0.1034
K_K4152  L_L78  L_L96  0.0540
K_K4153  L_L78  L_L97  0.0987
K_K4154  L_L78  L_L98  0.0484
K_K4155  L_L78  L_L99  0.1034
K_K4156  L_L78  L_L100  0.0456
K_K4157  L_L78  L_L101  0.1370
K_K4158  L_L78  L_L102  0.0574
K_K4159  L_L78  L_L103  0.1216
K_K4160  L_L78  L_L104  0.0503
K_K4161  L_L78  L_L105  0.1490
K_K4162  L_L78  L_L106  0.0429
K_K4163  L_L78  L_L107  0.0873
K_K4164  L_L78  L_L108  0.0495
K_K4165  L_L78  L_L109  0.0907
K_K4166  L_L78  L_L110  0.0337
K_K4167  L_L78  L_L111  0.0263
K_K4168  L_L78  L_L112  0.0258
K_K4169  L_L78  L_L113  0.0325
K_K4170  L_L78  L_L114  0.0328
K_K4171  L_L78  L_L115  0.0295
K_K4172  L_L78  L_L116  0.0292
K_K4173  L_L78  L_L117  0.0297
K_K4174  L_L78  L_L118  0.0290
K_K4175  L_L78  L_L119  0.0340
* *  Branch  N_C0_32 - N_C0_17
R_R79  N_C0_32  nR_79  0.941960m  TC=0,0
L_L79  nR_79  N_C0_17  2.158906uH
K_K4176  L_L79  L_L80  0.0972
K_K4177  L_L79  L_L81  0.1837
K_K4178  L_L79  L_L82  0.0843
K_K4179  L_L79  L_L83  0.1234
K_K4180  L_L79  L_L84  0.1161
K_K4181  L_L79  L_L85  0.1837
K_K4182  L_L79  L_L86  0.0582
K_K4183  L_L79  L_L87  0.0545
K_K4184  L_L79  L_L88  0.0534
K_K4185  L_L79  L_L89  0.0569
K_K4186  L_L79  L_L90  0.0535
K_K4187  L_L79  L_L91  0.0524
K_K4188  L_L79  L_L92  0.0499
K_K4189  L_L79  L_L93  0.0508
K_K4190  L_L79  L_L94  0.0314
K_K4191  L_L79  L_L95  0.0461
K_K4192  L_L79  L_L96  0.0309
K_K4193  L_L79  L_L97  0.0516
K_K4194  L_L79  L_L98  0.0314
K_K4195  L_L79  L_L99  0.0492
K_K4196  L_L79  L_L100  0.0320
K_K4197  L_L79  L_L101  0.0434
K_K4198  L_L79  L_L102  0.0317
K_K4199  L_L79  L_L103  0.0550
K_K4200  L_L79  L_L104  0.0310
K_K4201  L_L79  L_L105  0.0480
K_K4202  L_L79  L_L106  0.0311
K_K4203  L_L79  L_L107  0.0406
K_K4204  L_L79  L_L108  0.0319
K_K4205  L_L79  L_L109  0.0472
K_K4206  L_L79  L_L110  0.0210
K_K4207  L_L79  L_L111  0.0163
K_K4208  L_L79  L_L112  0.0161
K_K4209  L_L79  L_L113  0.0206
K_K4210  L_L79  L_L114  0.0209
K_K4211  L_L79  L_L115  0.0186
K_K4212  L_L79  L_L116  0.0183
K_K4213  L_L79  L_L117  0.0185
K_K4214  L_L79  L_L118  0.0184
K_K4215  L_L79  L_L119  0.0225
* *  Branch  N_C0_27 - N_C0_29
R_R80  N_C0_27  nR_80  146.279471m  TC=0,0
R_V255  nR_80  nV_255  1728.928121m  TC=0,0
L_V255  nR_80  nV_255  0.137034uH
R_V256  nV_255  nV_256  -1631.045869m  TC=0,0
L_V256  nV_255  nV_256  -0.136975uH
R_V257  nV_256  nV_257  541.938394m  TC=0,0
L_V257  nV_256  nV_257  0.218000uH
R_V258  nV_257  nV_258  -517.825140m  TC=0,0
L_V258  nV_257  nV_258  -0.220173uH
R_V259  nV_258  nV_259  254.312231m  TC=0,0
L_V259  nV_258  nV_259  0.452236uH
R_V260  nV_259  nV_260  -237.046463m  TC=0,0
L_V260  nV_259  nV_260  -0.436950uH
R_V261  nV_260  nV_261  -0.964860m  TC=0,0
L_V261  nV_260  nV_261  -0.006677uH
R_V262  nV_261  nV_262  5.575644m  TC=0,0
L_V262  nV_261  nV_262  0.057145uH
R_V263  nV_262  nV_263  -1.070329m  TC=0,0
L_V263  nV_262  nV_263  -0.041721uH
R_V264  nV_263  nV_264  2.069971m  TC=0,0
L_V264  nV_263  nV_264  0.167799uH
L_L80  nV_264  N_C0_29  2.108109uH
K_K4216  L_L80  L_L81  0.1554
K_K4217  L_L80  L_L82  0.1907
K_K4218  L_L80  L_L83  0.1161
K_K4219  L_L80  L_L84  0.1289
K_K4220  L_L80  L_L85  0.0843
K_K4221  L_L80  L_L87  -0.0809
K_K4222  L_L80  L_L89  0.0272
K_K4223  L_L80  L_L90  0.0903
K_K4224  L_L80  L_L91  0.1045
K_K4225  L_L80  L_L92  0.1374
K_K4226  L_L80  L_L93  0.0986
K_K4227  L_L80  L_L94  0.0456
K_K4228  L_L80  L_L95  0.1370
K_K4229  L_L80  L_L96  0.0515
K_K4230  L_L80  L_L97  0.1034
K_K4231  L_L80  L_L98  0.0540
K_K4232  L_L80  L_L99  0.0987
K_K4233  L_L80  L_L100  0.0484
K_K4234  L_L80  L_L101  0.1034
K_K4235  L_L80  L_L102  0.0495
K_K4236  L_L80  L_L103  0.0907
K_K4237  L_L80  L_L104  0.0574
K_K4238  L_L80  L_L105  0.1216
K_K4239  L_L80  L_L106  0.0503
K_K4240  L_L80  L_L107  0.1490
K_K4241  L_L80  L_L108  0.0429
K_K4242  L_L80  L_L109  0.0873
K_K4243  L_L80  L_L110  0.0328
K_K4244  L_L80  L_L111  0.0262
K_K4245  L_L80  L_L112  0.0264
K_K4246  L_L80  L_L113  0.0334
K_K4247  L_L80  L_L114  0.0325
K_K4248  L_L80  L_L115  0.0290
K_K4249  L_L80  L_L116  0.0297
K_K4250  L_L80  L_L117  0.0295
K_K4251  L_L80  L_L118  0.0292
K_K4252  L_L80  L_L119  0.0340
* *  Branch  N_C0_29 - N_C0_18
R_R81  N_C0_29  nR_81  0.941960m  TC=0,0
L_L81  nR_81  N_C0_18  2.158906uH
K_K4253  L_L81  L_L82  0.0972
K_K4254  L_L81  L_L83  0.1837
K_K4255  L_L81  L_L84  0.0843
K_K4256  L_L81  L_L85  0.1234
K_K4257  L_L81  L_L86  0.0569
K_K4258  L_L81  L_L87  0.0582
K_K4259  L_L81  L_L88  0.0545
K_K4260  L_L81  L_L89  0.0534
K_K4261  L_L81  L_L90  0.0508
K_K4262  L_L81  L_L91  0.0535
K_K4263  L_L81  L_L92  0.0524
K_K4264  L_L81  L_L93  0.0499
K_K4265  L_L81  L_L94  0.0320
K_K4266  L_L81  L_L95  0.0434
K_K4267  L_L81  L_L96  0.0314
K_K4268  L_L81  L_L97  0.0461
K_K4269  L_L81  L_L98  0.0309
K_K4270  L_L81  L_L99  0.0516
K_K4271  L_L81  L_L100  0.0314
K_K4272  L_L81  L_L101  0.0492
K_K4273  L_L81  L_L102  0.0319
K_K4274  L_L81  L_L103  0.0472
K_K4275  L_L81  L_L104  0.0317
K_K4276  L_L81  L_L105  0.0550
K_K4277  L_L81  L_L106  0.0310
K_K4278  L_L81  L_L107  0.0480
K_K4279  L_L81  L_L108  0.0311
K_K4280  L_L81  L_L109  0.0406
K_K4281  L_L81  L_L110  0.0209
K_K4282  L_L81  L_L111  0.0165
K_K4283  L_L81  L_L112  0.0164
K_K4284  L_L81  L_L113  0.0207
K_K4285  L_L81  L_L114  0.0206
K_K4286  L_L81  L_L115  0.0184
K_K4287  L_L81  L_L116  0.0185
K_K4288  L_L81  L_L117  0.0186
K_K4289  L_L81  L_L118  0.0183
K_K4290  L_L81  L_L119  0.0225
* *  Branch  N_C0_28 - N_C0_30
R_R82  N_C0_28  nR_82  146.279471m  TC=0,0
R_V265  nR_82  nV_265  1728.928121m  TC=0,0
L_V265  nR_82  nV_265  0.137034uH
R_V266  nV_265  nV_266  -1631.045869m  TC=0,0
L_V266  nV_265  nV_266  -0.136975uH
R_V267  nV_266  nV_267  541.938394m  TC=0,0
L_V267  nV_266  nV_267  0.218000uH
R_V268  nV_267  nV_268  -517.825140m  TC=0,0
L_V268  nV_267  nV_268  -0.220173uH
R_V269  nV_268  nV_269  254.312231m  TC=0,0
L_V269  nV_268  nV_269  0.452236uH
R_V270  nV_269  nV_270  -237.046463m  TC=0,0
L_V270  nV_269  nV_270  -0.436950uH
R_V271  nV_270  nV_271  -0.964860m  TC=0,0
L_V271  nV_270  nV_271  -0.006677uH
R_V272  nV_271  nV_272  5.575644m  TC=0,0
L_V272  nV_271  nV_272  0.057145uH
R_V273  nV_272  nV_273  -1.070329m  TC=0,0
L_V273  nV_272  nV_273  -0.041721uH
R_V274  nV_273  nV_274  2.069971m  TC=0,0
L_V274  nV_273  nV_274  0.167799uH
L_L82  nV_274  N_C0_30  2.108109uH
K_K4291  L_L82  L_L83  0.1554
K_K4292  L_L82  L_L84  0.1907
K_K4293  L_L82  L_L85  0.1161
K_K4294  L_L82  L_L86  0.0272
K_K4295  L_L82  L_L88  -0.0809
K_K4296  L_L82  L_L90  0.0986
K_K4297  L_L82  L_L91  0.0903
K_K4298  L_L82  L_L92  0.1045
K_K4299  L_L82  L_L93  0.1374
K_K4300  L_L82  L_L94  0.0484
K_K4301  L_L82  L_L95  0.1034
K_K4302  L_L82  L_L96  0.0456
K_K4303  L_L82  L_L97  0.1370
K_K4304  L_L82  L_L98  0.0515
K_K4305  L_L82  L_L99  0.1034
K_K4306  L_L82  L_L100  0.0540
K_K4307  L_L82  L_L101  0.0987
K_K4308  L_L82  L_L102  0.0429
K_K4309  L_L82  L_L103  0.0873
K_K4310  L_L82  L_L104  0.0495
K_K4311  L_L82  L_L105  0.0907
K_K4312  L_L82  L_L106  0.0574
K_K4313  L_L82  L_L107  0.1216
K_K4314  L_L82  L_L108  0.0503
K_K4315  L_L82  L_L109  0.1490
K_K4316  L_L82  L_L110  0.0325
K_K4317  L_L82  L_L111  0.0254
K_K4318  L_L82  L_L112  0.0258
K_K4319  L_L82  L_L113  0.0337
K_K4320  L_L82  L_L114  0.0334
K_K4321  L_L82  L_L115  0.0292
K_K4322  L_L82  L_L116  0.0295
K_K4323  L_L82  L_L117  0.0290
K_K4324  L_L82  L_L118  0.0297
K_K4325  L_L82  L_L119  0.0340
* *  Branch  N_C0_30 - N_C0_19
R_R83  N_C0_30  nR_83  0.941960m  TC=0,0
L_L83  nR_83  N_C0_19  2.158906uH
K_K4326  L_L83  L_L84  0.0972
K_K4327  L_L83  L_L85  0.1837
K_K4328  L_L83  L_L86  0.0534
K_K4329  L_L83  L_L87  0.0569
K_K4330  L_L83  L_L88  0.0582
K_K4331  L_L83  L_L89  0.0545
K_K4332  L_L83  L_L90  0.0499
K_K4333  L_L83  L_L91  0.0508
K_K4334  L_L83  L_L92  0.0535
K_K4335  L_L83  L_L93  0.0524
K_K4336  L_L83  L_L94  0.0314
K_K4337  L_L83  L_L95  0.0492
K_K4338  L_L83  L_L96  0.0320
K_K4339  L_L83  L_L97  0.0434
K_K4340  L_L83  L_L98  0.0314
K_K4341  L_L83  L_L99  0.0461
K_K4342  L_L83  L_L100  0.0309
K_K4343  L_L83  L_L101  0.0516
K_K4344  L_L83  L_L102  0.0311
K_K4345  L_L83  L_L103  0.0406
K_K4346  L_L83  L_L104  0.0319
K_K4347  L_L83  L_L105  0.0472
K_K4348  L_L83  L_L106  0.0317
K_K4349  L_L83  L_L107  0.0550
K_K4350  L_L83  L_L108  0.0310
K_K4351  L_L83  L_L109  0.0480
K_K4352  L_L83  L_L110  0.0206
K_K4353  L_L83  L_L111  0.0163
K_K4354  L_L83  L_L112  0.0164
K_K4355  L_L83  L_L113  0.0210
K_K4356  L_L83  L_L114  0.0207
K_K4357  L_L83  L_L115  0.0183
K_K4358  L_L83  L_L116  0.0186
K_K4359  L_L83  L_L117  0.0184
K_K4360  L_L83  L_L118  0.0185
K_K4361  L_L83  L_L119  0.0225
* *  Branch  N_C0_25 - N_C0_31
R_R84  N_C0_25  nR_84  146.279471m  TC=0,0
R_V275  nR_84  nV_275  1728.928121m  TC=0,0
L_V275  nR_84  nV_275  0.137034uH
R_V276  nV_275  nV_276  -1631.045869m  TC=0,0
L_V276  nV_275  nV_276  -0.136975uH
R_V277  nV_276  nV_277  541.938394m  TC=0,0
L_V277  nV_276  nV_277  0.218000uH
R_V278  nV_277  nV_278  -517.825140m  TC=0,0
L_V278  nV_277  nV_278  -0.220173uH
R_V279  nV_278  nV_279  254.312231m  TC=0,0
L_V279  nV_278  nV_279  0.452236uH
R_V280  nV_279  nV_280  -237.046463m  TC=0,0
L_V280  nV_279  nV_280  -0.436950uH
R_V281  nV_280  nV_281  -0.964860m  TC=0,0
L_V281  nV_280  nV_281  -0.006677uH
R_V282  nV_281  nV_282  5.575644m  TC=0,0
L_V282  nV_281  nV_282  0.057145uH
R_V283  nV_282  nV_283  -1.070329m  TC=0,0
L_V283  nV_282  nV_283  -0.041721uH
R_V284  nV_283  nV_284  2.069971m  TC=0,0
L_V284  nV_283  nV_284  0.167799uH
L_L84  nV_284  N_C0_31  2.108109uH
K_K4362  L_L84  L_L85  0.1554
K_K4363  L_L84  L_L87  0.0272
K_K4364  L_L84  L_L89  -0.0809
K_K4365  L_L84  L_L90  0.1374
K_K4366  L_L84  L_L91  0.0986
K_K4367  L_L84  L_L92  0.0903
K_K4368  L_L84  L_L93  0.1045
K_K4369  L_L84  L_L94  0.0540
K_K4370  L_L84  L_L95  0.0987
K_K4371  L_L84  L_L96  0.0484
K_K4372  L_L84  L_L97  0.1034
K_K4373  L_L84  L_L98  0.0456
K_K4374  L_L84  L_L99  0.1370
K_K4375  L_L84  L_L100  0.0515
K_K4376  L_L84  L_L101  0.1034
K_K4377  L_L84  L_L102  0.0503
K_K4378  L_L84  L_L103  0.1490
K_K4379  L_L84  L_L104  0.0429
K_K4380  L_L84  L_L105  0.0873
K_K4381  L_L84  L_L106  0.0495
K_K4382  L_L84  L_L107  0.0907
K_K4383  L_L84  L_L108  0.0574
K_K4384  L_L84  L_L109  0.1216
K_K4385  L_L84  L_L110  0.0334
K_K4386  L_L84  L_L111  0.0255
K_K4387  L_L84  L_L112  0.0253
K_K4388  L_L84  L_L113  0.0328
K_K4389  L_L84  L_L114  0.0337
K_K4390  L_L84  L_L115  0.0297
K_K4391  L_L84  L_L116  0.0290
K_K4392  L_L84  L_L117  0.0292
K_K4393  L_L84  L_L118  0.0295
K_K4394  L_L84  L_L119  0.0340
* *  Branch  N_C0_31 - N_C0_20
R_R85  N_C0_31  nR_85  0.941960m  TC=0,0
L_L85  nR_85  N_C0_20  2.158906uH
K_K4395  L_L85  L_L86  0.0545
K_K4396  L_L85  L_L87  0.0534
K_K4397  L_L85  L_L88  0.0569
K_K4398  L_L85  L_L89  0.0582
K_K4399  L_L85  L_L90  0.0524
K_K4400  L_L85  L_L91  0.0499
K_K4401  L_L85  L_L92  0.0508
K_K4402  L_L85  L_L93  0.0535
K_K4403  L_L85  L_L94  0.0309
K_K4404  L_L85  L_L95  0.0516
K_K4405  L_L85  L_L96  0.0314
K_K4406  L_L85  L_L97  0.0492
K_K4407  L_L85  L_L98  0.0320
K_K4408  L_L85  L_L99  0.0434
K_K4409  L_L85  L_L100  0.0314
K_K4410  L_L85  L_L101  0.0461
K_K4411  L_L85  L_L102  0.0310
K_K4412  L_L85  L_L103  0.0480
K_K4413  L_L85  L_L104  0.0311
K_K4414  L_L85  L_L105  0.0406
K_K4415  L_L85  L_L106  0.0319
K_K4416  L_L85  L_L107  0.0472
K_K4417  L_L85  L_L108  0.0317
K_K4418  L_L85  L_L109  0.0550
K_K4419  L_L85  L_L110  0.0207
K_K4420  L_L85  L_L111  0.0161
K_K4421  L_L85  L_L112  0.0162
K_K4422  L_L85  L_L113  0.0209
K_K4423  L_L85  L_L114  0.0210
K_K4424  L_L85  L_L115  0.0185
K_K4425  L_L85  L_L116  0.0184
K_K4426  L_L85  L_L117  0.0183
K_K4427  L_L85  L_L118  0.0186
K_K4428  L_L85  L_L119  0.0225
* *  Branch  N_C0_25 - N_C0_26
R_R86  N_C0_25  nR_86  0.541340m  TC=0,0
L_L86  nR_86  N_C0_26  1.086664uH
K_K4429  L_L86  L_L88  -0.1358
K_K4430  L_L86  L_L90  -0.0102
K_K4431  L_L86  L_L91  -0.0102
K_K4432  L_L86  L_L92  -0.0102
K_K4433  L_L86  L_L93  -0.0102
K_K4434  L_L86  L_L96  -0.0263
K_K4435  L_L86  L_L97  -0.0443
K_K4436  L_L86  L_L100  0.0127
K_K4437  L_L86  L_L101  0.0637
K_K4438  L_L86  L_L102  -0.0279
K_K4439  L_L86  L_L103  -0.0802
K_K4440  L_L86  L_L106  0.0111
K_K4441  L_L86  L_L107  0.0278
K_K4442  L_L86  L_L110  0.0355
K_K4443  L_L86  L_L111  0.0273
K_K4444  L_L86  L_L112  0.0267
K_K4445  L_L86  L_L113  0.0338
K_K4446  L_L86  L_L114  0.0346
K_K4447  L_L86  L_L115  0.0311
K_K4448  L_L86  L_L116  0.0303
K_K4449  L_L86  L_L117  0.0311
K_K4450  L_L86  L_L118  0.0303
* *  Branch  N_C0_26 - N_C0_27
R_R87  N_C0_26  nR_87  0.541340m  TC=0,0
L_L87  nR_87  N_C0_27  1.086664uH
K_K4451  L_L87  L_L89  -0.1358
K_K4452  L_L87  L_L90  -0.0102
K_K4453  L_L87  L_L91  -0.0102
K_K4454  L_L87  L_L92  -0.0102
K_K4455  L_L87  L_L93  -0.0102
K_K4456  L_L87  L_L94  0.0127
K_K4457  L_L87  L_L95  0.0637
K_K4458  L_L87  L_L98  -0.0263
K_K4459  L_L87  L_L99  -0.0443
K_K4460  L_L87  L_L104  -0.0279
K_K4461  L_L87  L_L105  -0.0802
K_K4462  L_L87  L_L108  0.0111
K_K4463  L_L87  L_L109  0.0278
K_K4464  L_L87  L_L110  0.0346
K_K4465  L_L87  L_L111  0.0277
K_K4466  L_L87  L_L112  0.0277
K_K4467  L_L87  L_L113  0.0346
K_K4468  L_L87  L_L114  0.0338
K_K4469  L_L87  L_L115  0.0303
K_K4470  L_L87  L_L116  0.0311
K_K4471  L_L87  L_L117  0.0311
K_K4472  L_L87  L_L118  0.0303
* *  Branch  N_C0_27 - N_C0_28
R_R88  N_C0_27  nR_88  0.541340m  TC=0,0
L_L88  nR_88  N_C0_28  1.086664uH
K_K4473  L_L88  L_L90  -0.0102
K_K4474  L_L88  L_L91  -0.0102
K_K4475  L_L88  L_L92  -0.0102
K_K4476  L_L88  L_L93  -0.0102
K_K4477  L_L88  L_L96  0.0127
K_K4478  L_L88  L_L97  0.0637
K_K4479  L_L88  L_L100  -0.0263
K_K4480  L_L88  L_L101  -0.0443
K_K4481  L_L88  L_L102  0.0111
K_K4482  L_L88  L_L103  0.0278
K_K4483  L_L88  L_L106  -0.0279
K_K4484  L_L88  L_L107  -0.0802
K_K4485  L_L88  L_L110  0.0338
K_K4486  L_L88  L_L111  0.0267
K_K4487  L_L88  L_L112  0.0273
K_K4488  L_L88  L_L113  0.0355
K_K4489  L_L88  L_L114  0.0346
K_K4490  L_L88  L_L115  0.0303
K_K4491  L_L88  L_L116  0.0311
K_K4492  L_L88  L_L117  0.0303
K_K4493  L_L88  L_L118  0.0311
* *  Branch  N_C0_28 - N_C0_25
R_R89  N_C0_28  nR_89  0.541340m  TC=0,0
L_L89  nR_89  N_C0_25  1.086664uH
K_K4494  L_L89  L_L90  -0.0102
K_K4495  L_L89  L_L91  -0.0102
K_K4496  L_L89  L_L92  -0.0102
K_K4497  L_L89  L_L93  -0.0102
K_K4498  L_L89  L_L94  -0.0263
K_K4499  L_L89  L_L95  -0.0443
K_K4500  L_L89  L_L98  0.0127
K_K4501  L_L89  L_L99  0.0637
K_K4502  L_L89  L_L104  0.0111
K_K4503  L_L89  L_L105  0.0278
K_K4504  L_L89  L_L108  -0.0279
K_K4505  L_L89  L_L109  -0.0802
K_K4506  L_L89  L_L110  0.0346
K_K4507  L_L89  L_L111  0.0263
K_K4508  L_L89  L_L112  0.0263
K_K4509  L_L89  L_L113  0.0346
K_K4510  L_L89  L_L114  0.0355
K_K4511  L_L89  L_L115  0.0311
K_K4512  L_L89  L_L116  0.0303
K_K4513  L_L89  L_L117  0.0303
K_K4514  L_L89  L_L118  0.0311
* *  Branch  N_C0_33 - N_C0_25
R_R90  N_C0_33  nR_90  280.220640m  TC=0,0
R_V285  nR_90  nV_285  3312.022957m  TC=0,0
L_V285  nR_90  nV_285  0.262509uH
R_V286  nV_285  nV_286  -3124.514572m  TC=0,0
L_V286  nV_285  nV_286  -0.262397uH
R_V287  nV_286  nV_287  1038.166348m  TC=0,0
L_V287  nV_286  nV_287  0.417612uH
R_V288  nV_287  nV_288  -991.973732m  TC=0,0
L_V288  nV_287  nV_288  -0.421775uH
R_V289  nV_288  nV_289  487.173174m  TC=0,0
L_V289  nV_288  nV_289  0.866326uH
R_V290  nV_289  nV_290  -454.097960m  TC=0,0
L_V290  nV_289  nV_290  -0.837042uH
R_V291  nV_290  nV_291  -1.848335m  TC=0,0
L_V291  nV_290  nV_291  -0.012791uH
R_V292  nV_291  nV_292  10.680995m  TC=0,0
L_V292  nV_291  nV_292  0.109470uH
R_V293  nV_292  nV_293  -2.050378m  TC=0,0
L_V293  nV_292  nV_293  -0.079923uH
R_V294  nV_293  nV_294  3.965345m  TC=0,0
L_V294  nV_293  nV_294  0.321445uH
L_L90  nV_294  N_C0_25  4.659526uH
K_K4515  L_L90  L_L91  0.2369
K_K4516  L_L90  L_L92  0.1845
K_K4517  L_L90  L_L93  0.2369
K_K4518  L_L90  L_L94  0.1707
K_K4519  L_L90  L_L95  0.1504
K_K4520  L_L90  L_L96  0.1511
K_K4521  L_L90  L_L97  0.1700
K_K4522  L_L90  L_L98  0.2174
K_K4523  L_L90  L_L99  0.4027
K_K4524  L_L90  L_L100  0.4033
K_K4525  L_L90  L_L101  0.2167
K_K4526  L_L90  L_L102  0.2174
K_K4527  L_L90  L_L103  0.4027
K_K4528  L_L90  L_L104  0.1511
K_K4529  L_L90  L_L105  0.1700
K_K4530  L_L90  L_L106  0.1707
K_K4531  L_L90  L_L107  0.1504
K_K4532  L_L90  L_L108  0.4033
K_K4533  L_L90  L_L109  0.2167
K_K4534  L_L90  L_L111  0.0817
K_K4535  L_L90  L_L112  0.0765
K_K4536  L_L90  L_L116  0.0914
K_K4537  L_L90  L_L117  0.0984
K_K4538  L_L90  L_L118  0.0984
K_K4539  L_L90  L_L119  0.1158
* *  Branch  N_C0_34 - N_C0_26
R_R91  N_C0_34  nR_91  280.220640m  TC=0,0
R_V295  nR_91  nV_295  3312.022957m  TC=0,0
L_V295  nR_91  nV_295  0.262509uH
R_V296  nV_295  nV_296  -3124.514572m  TC=0,0
L_V296  nV_295  nV_296  -0.262397uH
R_V297  nV_296  nV_297  1038.166348m  TC=0,0
L_V297  nV_296  nV_297  0.417612uH
R_V298  nV_297  nV_298  -991.973732m  TC=0,0
L_V298  nV_297  nV_298  -0.421775uH
R_V299  nV_298  nV_299  487.173174m  TC=0,0
L_V299  nV_298  nV_299  0.866326uH
R_V300  nV_299  nV_300  -454.097960m  TC=0,0
L_V300  nV_299  nV_300  -0.837042uH
R_V301  nV_300  nV_301  -1.848335m  TC=0,0
L_V301  nV_300  nV_301  -0.012791uH
R_V302  nV_301  nV_302  10.680995m  TC=0,0
L_V302  nV_301  nV_302  0.109470uH
R_V303  nV_302  nV_303  -2.050378m  TC=0,0
L_V303  nV_302  nV_303  -0.079923uH
R_V304  nV_303  nV_304  3.965345m  TC=0,0
L_V304  nV_303  nV_304  0.321445uH
L_L91  nV_304  N_C0_26  4.659526uH
K_K4540  L_L91  L_L92  0.2369
K_K4541  L_L91  L_L93  0.1845
K_K4542  L_L91  L_L94  0.4033
K_K4543  L_L91  L_L95  0.2167
K_K4544  L_L91  L_L96  0.1707
K_K4545  L_L91  L_L97  0.1504
K_K4546  L_L91  L_L98  0.1511
K_K4547  L_L91  L_L99  0.1700
K_K4548  L_L91  L_L100  0.2174
K_K4549  L_L91  L_L101  0.4027
K_K4550  L_L91  L_L102  0.4033
K_K4551  L_L91  L_L103  0.2167
K_K4552  L_L91  L_L104  0.2174
K_K4553  L_L91  L_L105  0.4027
K_K4554  L_L91  L_L106  0.1511
K_K4555  L_L91  L_L107  0.1700
K_K4556  L_L91  L_L108  0.1707
K_K4557  L_L91  L_L109  0.1504
K_K4558  L_L91  L_L111  0.0962
K_K4559  L_L91  L_L112  0.0881
K_K4560  L_L91  L_L115  0.0984
K_K4561  L_L91  L_L116  0.0984
K_K4562  L_L91  L_L118  0.0914
K_K4563  L_L91  L_L119  0.1158
* *  Branch  N_C0_35 - N_C0_27
R_R92  N_C0_35  nR_92  280.220640m  TC=0,0
R_V305  nR_92  nV_305  3312.022957m  TC=0,0
L_V305  nR_92  nV_305  0.262509uH
R_V306  nV_305  nV_306  -3124.514572m  TC=0,0
L_V306  nV_305  nV_306  -0.262397uH
R_V307  nV_306  nV_307  1038.166348m  TC=0,0
L_V307  nV_306  nV_307  0.417612uH
R_V308  nV_307  nV_308  -991.973732m  TC=0,0
L_V308  nV_307  nV_308  -0.421775uH
R_V309  nV_308  nV_309  487.173174m  TC=0,0
L_V309  nV_308  nV_309  0.866326uH
R_V310  nV_309  nV_310  -454.097960m  TC=0,0
L_V310  nV_309  nV_310  -0.837042uH
R_V311  nV_310  nV_311  -1.848335m  TC=0,0
L_V311  nV_310  nV_311  -0.012791uH
R_V312  nV_311  nV_312  10.680995m  TC=0,0
L_V312  nV_311  nV_312  0.109470uH
R_V313  nV_312  nV_313  -2.050378m  TC=0,0
L_V313  nV_312  nV_313  -0.079923uH
R_V314  nV_313  nV_314  3.965345m  TC=0,0
L_V314  nV_313  nV_314  0.321445uH
L_L92  nV_314  N_C0_27  4.659526uH
K_K4564  L_L92  L_L93  0.2369
K_K4565  L_L92  L_L94  0.2174
K_K4566  L_L92  L_L95  0.4027
K_K4567  L_L92  L_L96  0.4033
K_K4568  L_L92  L_L97  0.2167
K_K4569  L_L92  L_L98  0.1707
K_K4570  L_L92  L_L99  0.1504
K_K4571  L_L92  L_L100  0.1511
K_K4572  L_L92  L_L101  0.1700
K_K4573  L_L92  L_L102  0.1707
K_K4574  L_L92  L_L103  0.1504
K_K4575  L_L92  L_L104  0.4033
K_K4576  L_L92  L_L105  0.2167
K_K4577  L_L92  L_L106  0.2174
K_K4578  L_L92  L_L107  0.4027
K_K4579  L_L92  L_L108  0.1511
K_K4580  L_L92  L_L109  0.1700
K_K4581  L_L92  L_L111  0.0881
K_K4582  L_L92  L_L112  0.0962
K_K4583  L_L92  L_L115  0.0914
K_K4584  L_L92  L_L117  0.0984
K_K4585  L_L92  L_L118  0.0984
K_K4586  L_L92  L_L119  0.1158
* *  Branch  N_C0_36 - N_C0_28
R_R93  N_C0_36  nR_93  280.220640m  TC=0,0
R_V315  nR_93  nV_315  3312.022957m  TC=0,0
L_V315  nR_93  nV_315  0.262509uH
R_V316  nV_315  nV_316  -3124.514572m  TC=0,0
L_V316  nV_315  nV_316  -0.262397uH
R_V317  nV_316  nV_317  1038.166348m  TC=0,0
L_V317  nV_316  nV_317  0.417612uH
R_V318  nV_317  nV_318  -991.973732m  TC=0,0
L_V318  nV_317  nV_318  -0.421775uH
R_V319  nV_318  nV_319  487.173174m  TC=0,0
L_V319  nV_318  nV_319  0.866326uH
R_V320  nV_319  nV_320  -454.097960m  TC=0,0
L_V320  nV_319  nV_320  -0.837042uH
R_V321  nV_320  nV_321  -1.848335m  TC=0,0
L_V321  nV_320  nV_321  -0.012791uH
R_V322  nV_321  nV_322  10.680995m  TC=0,0
L_V322  nV_321  nV_322  0.109470uH
R_V323  nV_322  nV_323  -2.050378m  TC=0,0
L_V323  nV_322  nV_323  -0.079923uH
R_V324  nV_323  nV_324  3.965345m  TC=0,0
L_V324  nV_323  nV_324  0.321445uH
L_L93  nV_324  N_C0_28  4.659526uH
K_K4587  L_L93  L_L94  0.1511
K_K4588  L_L93  L_L95  0.1700
K_K4589  L_L93  L_L96  0.2174
K_K4590  L_L93  L_L97  0.4027
K_K4591  L_L93  L_L98  0.4033
K_K4592  L_L93  L_L99  0.2167
K_K4593  L_L93  L_L100  0.1707
K_K4594  L_L93  L_L101  0.1504
K_K4595  L_L93  L_L102  0.1511
K_K4596  L_L93  L_L103  0.1700
K_K4597  L_L93  L_L104  0.1707
K_K4598  L_L93  L_L105  0.1504
K_K4599  L_L93  L_L106  0.4033
K_K4600  L_L93  L_L107  0.2167
K_K4601  L_L93  L_L108  0.2174
K_K4602  L_L93  L_L109  0.4027
K_K4603  L_L93  L_L111  0.0765
K_K4604  L_L93  L_L112  0.0817
K_K4605  L_L93  L_L115  0.0984
K_K4606  L_L93  L_L116  0.0984
K_K4607  L_L93  L_L117  0.0914
K_K4608  L_L93  L_L119  0.1158
* *  Branch  N_C0_34 - N_C0_37
R_R94  N_C0_34  nR_94  146.279471m  TC=0,0
R_V325  nR_94  nV_325  1728.928172m  TC=0,0
L_V325  nR_94  nV_325  0.137034uH
R_V326  nV_325  nV_326  -1631.045920m  TC=0,0
L_V326  nV_325  nV_326  -0.136975uH
R_V327  nV_326  nV_327  541.938377m  TC=0,0
L_V327  nV_326  nV_327  0.218000uH
R_V328  nV_327  nV_328  -517.825122m  TC=0,0
L_V328  nV_327  nV_328  -0.220173uH
R_V329  nV_328  nV_329  254.312280m  TC=0,0
L_V329  nV_328  nV_329  0.452236uH
R_V330  nV_329  nV_330  -237.046511m  TC=0,0
L_V330  nV_329  nV_330  -0.436950uH
R_V331  nV_330  nV_331  -0.964861m  TC=0,0
L_V331  nV_330  nV_331  -0.006677uH
R_V332  nV_331  nV_332  5.575644m  TC=0,0
L_V332  nV_331  nV_332  0.057145uH
R_V333  nV_332  nV_333  -1.070329m  TC=0,0
L_V333  nV_332  nV_333  -0.041721uH
R_V334  nV_333  nV_334  2.069971m  TC=0,0
L_V334  nV_333  nV_334  0.167799uH
L_L94  nV_334  N_C0_37  2.114632uH
K_K4609  L_L94  L_L95  0.1605
K_K4610  L_L94  L_L96  0.1932
K_K4611  L_L94  L_L97  0.1017
K_K4612  L_L94  L_L98  0.1316
K_K4613  L_L94  L_L99  0.0887
K_K4614  L_L94  L_L100  0.1932
K_K4615  L_L94  L_L101  0.1208
K_K4616  L_L94  L_L102  0.3943
K_K4617  L_L94  L_L103  0.1104
K_K4618  L_L94  L_L104  0.3005
K_K4619  L_L94  L_L105  0.1383
K_K4620  L_L94  L_L106  0.1553
K_K4621  L_L94  L_L107  0.1104
K_K4622  L_L94  L_L108  0.1747
K_K4623  L_L94  L_L109  0.1057
K_K4624  L_L94  L_L111  0.0669
K_K4625  L_L94  L_L112  0.0351
K_K4626  L_L94  L_L114  -0.0426
K_K4627  L_L94  L_L115  -0.0338
K_K4628  L_L94  L_L116  0.0242
K_K4629  L_L94  L_L117  -0.0554
K_K4630  L_L94  L_L118  0.0191
K_K4631  L_L94  L_L119  0.1204
* *  Branch  N_C0_37 - N_C0_27
R_R95  N_C0_37  nR_95  146.279470m  TC=0,0
R_V335  nR_95  nV_335  1728.927709m  TC=0,0
L_V335  nR_95  nV_335  0.137034uH
R_V336  nV_335  nV_336  -1631.045458m  TC=0,0
L_V336  nV_335  nV_336  -0.136975uH
R_V337  nV_336  nV_337  541.938500m  TC=0,0
L_V337  nV_336  nV_337  0.218000uH
R_V338  nV_337  nV_338  -517.825245m  TC=0,0
L_V338  nV_337  nV_338  -0.220173uH
R_V339  nV_338  nV_339  254.312116m  TC=0,0
L_V339  nV_338  nV_339  0.452236uH
R_V340  nV_339  nV_340  -237.046348m  TC=0,0
L_V340  nV_339  nV_340  -0.436949uH
R_V341  nV_340  nV_341  -0.964860m  TC=0,0
L_V341  nV_340  nV_341  -0.006677uH
R_V342  nV_341  nV_342  5.575644m  TC=0,0
L_V342  nV_341  nV_342  0.057145uH
R_V343  nV_342  nV_343  -1.070329m  TC=0,0
L_V343  nV_342  nV_343  -0.041721uH
R_V344  nV_343  nV_344  2.069971m  TC=0,0
L_V344  nV_343  nV_344  0.167799uH
L_L95  nV_344  N_C0_27  2.111869uH
K_K4632  L_L95  L_L96  0.1208
K_K4633  L_L95  L_L97  0.1922
K_K4634  L_L95  L_L98  0.0887
K_K4635  L_L95  L_L99  0.1305
K_K4636  L_L95  L_L100  0.1017
K_K4637  L_L95  L_L101  0.1922
K_K4638  L_L95  L_L102  0.1104
K_K4639  L_L95  L_L103  0.1542
K_K4640  L_L95  L_L104  0.1383
K_K4641  L_L95  L_L105  0.2996
K_K4642  L_L95  L_L106  0.1104
K_K4643  L_L95  L_L107  0.3935
K_K4644  L_L95  L_L108  0.1057
K_K4645  L_L95  L_L109  0.1736
K_K4646  L_L95  L_L110  0.0577
K_K4647  L_L95  L_L111  0.0473
K_K4648  L_L95  L_L112  0.0483
K_K4649  L_L95  L_L113  0.0601
K_K4650  L_L95  L_L114  0.0566
K_K4651  L_L95  L_L115  0.0509
K_K4652  L_L95  L_L116  0.0542
K_K4653  L_L95  L_L117  0.0530
K_K4654  L_L95  L_L118  0.0520
K_K4655  L_L95  L_L119  0.0553
* *  Branch  N_C0_35 - N_C0_38
R_R96  N_C0_35  nR_96  146.279471m  TC=0,0
R_V345  nR_96  nV_345  1728.928172m  TC=0,0
L_V345  nR_96  nV_345  0.137034uH
R_V346  nV_345  nV_346  -1631.045920m  TC=0,0
L_V346  nV_345  nV_346  -0.136975uH
R_V347  nV_346  nV_347  541.938377m  TC=0,0
L_V347  nV_346  nV_347  0.218000uH
R_V348  nV_347  nV_348  -517.825122m  TC=0,0
L_V348  nV_347  nV_348  -0.220173uH
R_V349  nV_348  nV_349  254.312280m  TC=0,0
L_V349  nV_348  nV_349  0.452236uH
R_V350  nV_349  nV_350  -237.046511m  TC=0,0
L_V350  nV_349  nV_350  -0.436950uH
R_V351  nV_350  nV_351  -0.964861m  TC=0,0
L_V351  nV_350  nV_351  -0.006677uH
R_V352  nV_351  nV_352  5.575644m  TC=0,0
L_V352  nV_351  nV_352  0.057145uH
R_V353  nV_352  nV_353  -1.070329m  TC=0,0
L_V353  nV_352  nV_353  -0.041721uH
R_V354  nV_353  nV_354  2.069971m  TC=0,0
L_V354  nV_353  nV_354  0.167799uH
L_L96  nV_354  N_C0_38  2.114632uH
K_K4656  L_L96  L_L97  0.1605
K_K4657  L_L96  L_L98  0.1932
K_K4658  L_L96  L_L99  0.1017
K_K4659  L_L96  L_L100  0.1316
K_K4660  L_L96  L_L101  0.0887
K_K4661  L_L96  L_L102  0.1747
K_K4662  L_L96  L_L103  0.1057
K_K4663  L_L96  L_L104  0.3943
K_K4664  L_L96  L_L105  0.1104
K_K4665  L_L96  L_L106  0.3005
K_K4666  L_L96  L_L107  0.1383
K_K4667  L_L96  L_L108  0.1553
K_K4668  L_L96  L_L109  0.1104
K_K4669  L_L96  L_L110  -0.0426
K_K4670  L_L96  L_L113  0.0652
K_K4671  L_L96  L_L115  0.0191
K_K4672  L_L96  L_L116  -0.0554
K_K4673  L_L96  L_L117  -0.0338
K_K4674  L_L96  L_L118  0.0242
K_K4675  L_L96  L_L119  0.1204
* *  Branch  N_C0_38 - N_C0_28
R_R97  N_C0_38  nR_97  146.279470m  TC=0,0
R_V355  nR_97  nV_355  1728.927709m  TC=0,0
L_V355  nR_97  nV_355  0.137034uH
R_V356  nV_355  nV_356  -1631.045458m  TC=0,0
L_V356  nV_355  nV_356  -0.136975uH
R_V357  nV_356  nV_357  541.938500m  TC=0,0
L_V357  nV_356  nV_357  0.218000uH
R_V358  nV_357  nV_358  -517.825245m  TC=0,0
L_V358  nV_357  nV_358  -0.220173uH
R_V359  nV_358  nV_359  254.312116m  TC=0,0
L_V359  nV_358  nV_359  0.452236uH
R_V360  nV_359  nV_360  -237.046348m  TC=0,0
L_V360  nV_359  nV_360  -0.436949uH
R_V361  nV_360  nV_361  -0.964860m  TC=0,0
L_V361  nV_360  nV_361  -0.006677uH
R_V362  nV_361  nV_362  5.575644m  TC=0,0
L_V362  nV_361  nV_362  0.057145uH
R_V363  nV_362  nV_363  -1.070329m  TC=0,0
L_V363  nV_362  nV_363  -0.041721uH
R_V364  nV_363  nV_364  2.069971m  TC=0,0
L_V364  nV_363  nV_364  0.167799uH
L_L97  nV_364  N_C0_28  2.111869uH
K_K4676  L_L97  L_L98  0.1208
K_K4677  L_L97  L_L99  0.1922
K_K4678  L_L97  L_L100  0.0887
K_K4679  L_L97  L_L101  0.1305
K_K4680  L_L97  L_L102  0.1057
K_K4681  L_L97  L_L103  0.1736
K_K4682  L_L97  L_L104  0.1104
K_K4683  L_L97  L_L105  0.1542
K_K4684  L_L97  L_L106  0.1383
K_K4685  L_L97  L_L107  0.2996
K_K4686  L_L97  L_L108  0.1104
K_K4687  L_L97  L_L109  0.3935
K_K4688  L_L97  L_L110  0.0566
K_K4689  L_L97  L_L111  0.0441
K_K4690  L_L97  L_L112  0.0458
K_K4691  L_L97  L_L113  0.0614
K_K4692  L_L97  L_L114  0.0601
K_K4693  L_L97  L_L115  0.0520
K_K4694  L_L97  L_L116  0.0530
K_K4695  L_L97  L_L117  0.0509
K_K4696  L_L97  L_L118  0.0542
K_K4697  L_L97  L_L119  0.0553
* *  Branch  N_C0_36 - N_C0_39
R_R98  N_C0_36  nR_98  146.279471m  TC=0,0
R_V365  nR_98  nV_365  1728.928172m  TC=0,0
L_V365  nR_98  nV_365  0.137034uH
R_V366  nV_365  nV_366  -1631.045920m  TC=0,0
L_V366  nV_365  nV_366  -0.136975uH
R_V367  nV_366  nV_367  541.938377m  TC=0,0
L_V367  nV_366  nV_367  0.218000uH
R_V368  nV_367  nV_368  -517.825122m  TC=0,0
L_V368  nV_367  nV_368  -0.220173uH
R_V369  nV_368  nV_369  254.312280m  TC=0,0
L_V369  nV_368  nV_369  0.452236uH
R_V370  nV_369  nV_370  -237.046511m  TC=0,0
L_V370  nV_369  nV_370  -0.436950uH
R_V371  nV_370  nV_371  -0.964861m  TC=0,0
L_V371  nV_370  nV_371  -0.006677uH
R_V372  nV_371  nV_372  5.575644m  TC=0,0
L_V372  nV_371  nV_372  0.057145uH
R_V373  nV_372  nV_373  -1.070329m  TC=0,0
L_V373  nV_372  nV_373  -0.041721uH
R_V374  nV_373  nV_374  2.069971m  TC=0,0
L_V374  nV_373  nV_374  0.167799uH
L_L98  nV_374  N_C0_39  2.114632uH
K_K4698  L_L98  L_L99  0.1605
K_K4699  L_L98  L_L100  0.1932
K_K4700  L_L98  L_L101  0.1017
K_K4701  L_L98  L_L102  0.1553
K_K4702  L_L98  L_L103  0.1104
K_K4703  L_L98  L_L104  0.1747
K_K4704  L_L98  L_L105  0.1057
K_K4705  L_L98  L_L106  0.3943
K_K4706  L_L98  L_L107  0.1104
K_K4707  L_L98  L_L108  0.3005
K_K4708  L_L98  L_L109  0.1383
K_K4709  L_L98  L_L111  0.0914
K_K4710  L_L98  L_L112  0.0982
K_K4711  L_L98  L_L114  0.0652
K_K4712  L_L98  L_L115  0.0242
K_K4713  L_L98  L_L116  -0.0338
K_K4714  L_L98  L_L117  0.0191
K_K4715  L_L98  L_L118  -0.0554
K_K4716  L_L98  L_L119  0.1204
* *  Branch  N_C0_39 - N_C0_25
R_R99  N_C0_39  nR_99  146.279470m  TC=0,0
R_V375  nR_99  nV_375  1728.927709m  TC=0,0
L_V375  nR_99  nV_375  0.137034uH
R_V376  nV_375  nV_376  -1631.045458m  TC=0,0
L_V376  nV_375  nV_376  -0.136975uH
R_V377  nV_376  nV_377  541.938500m  TC=0,0
L_V377  nV_376  nV_377  0.218000uH
R_V378  nV_377  nV_378  -517.825245m  TC=0,0
L_V378  nV_377  nV_378  -0.220173uH
R_V379  nV_378  nV_379  254.312116m  TC=0,0
L_V379  nV_378  nV_379  0.452236uH
R_V380  nV_379  nV_380  -237.046348m  TC=0,0
L_V380  nV_379  nV_380  -0.436949uH
R_V381  nV_380  nV_381  -0.964860m  TC=0,0
L_V381  nV_380  nV_381  -0.006677uH
R_V382  nV_381  nV_382  5.575644m  TC=0,0
L_V382  nV_381  nV_382  0.057145uH
R_V383  nV_382  nV_383  -1.070329m  TC=0,0
L_V383  nV_382  nV_383  -0.041721uH
R_V384  nV_383  nV_384  2.069971m  TC=0,0
L_V384  nV_383  nV_384  0.167799uH
L_L99  nV_384  N_C0_25  2.111869uH
K_K4717  L_L99  L_L100  0.1208
K_K4718  L_L99  L_L101  0.1922
K_K4719  L_L99  L_L102  0.1104
K_K4720  L_L99  L_L103  0.3935
K_K4721  L_L99  L_L104  0.1057
K_K4722  L_L99  L_L105  0.1736
K_K4723  L_L99  L_L106  0.1104
K_K4724  L_L99  L_L107  0.1542
K_K4725  L_L99  L_L108  0.1383
K_K4726  L_L99  L_L109  0.2996
K_K4727  L_L99  L_L110  0.0601
K_K4728  L_L99  L_L111  0.0445
K_K4729  L_L99  L_L112  0.0437
K_K4730  L_L99  L_L113  0.0577
K_K4731  L_L99  L_L114  0.0614
K_K4732  L_L99  L_L115  0.0542
K_K4733  L_L99  L_L116  0.0509
K_K4734  L_L99  L_L117  0.0520
K_K4735  L_L99  L_L118  0.0530
K_K4736  L_L99  L_L119  0.0553
* *  Branch  N_C0_33 - N_C0_40
R_R100  N_C0_33  nR_100  146.279471m  TC=0,0
R_V385  nR_100  nV_385  1728.928172m  TC=0,0
L_V385  nR_100  nV_385  0.137034uH
R_V386  nV_385  nV_386  -1631.045920m  TC=0,0
L_V386  nV_385  nV_386  -0.136975uH
R_V387  nV_386  nV_387  541.938377m  TC=0,0
L_V387  nV_386  nV_387  0.218000uH
R_V388  nV_387  nV_388  -517.825122m  TC=0,0
L_V388  nV_387  nV_388  -0.220173uH
R_V389  nV_388  nV_389  254.312280m  TC=0,0
L_V389  nV_388  nV_389  0.452236uH
R_V390  nV_389  nV_390  -237.046511m  TC=0,0
L_V390  nV_389  nV_390  -0.436950uH
R_V391  nV_390  nV_391  -0.964861m  TC=0,0
L_V391  nV_390  nV_391  -0.006677uH
R_V392  nV_391  nV_392  5.575644m  TC=0,0
L_V392  nV_391  nV_392  0.057145uH
R_V393  nV_392  nV_393  -1.070329m  TC=0,0
L_V393  nV_392  nV_393  -0.041721uH
R_V394  nV_393  nV_394  2.069971m  TC=0,0
L_V394  nV_393  nV_394  0.167799uH
L_L100  nV_394  N_C0_40  2.114632uH
K_K4737  L_L100  L_L101  0.1605
K_K4738  L_L100  L_L102  0.3005
K_K4739  L_L100  L_L103  0.1383
K_K4740  L_L100  L_L104  0.1553
K_K4741  L_L100  L_L105  0.1104
K_K4742  L_L100  L_L106  0.1747
K_K4743  L_L100  L_L107  0.1057
K_K4744  L_L100  L_L108  0.3943
K_K4745  L_L100  L_L109  0.1104
K_K4746  L_L100  L_L110  0.0652
K_K4747  L_L100  L_L112  0.0946
K_K4748  L_L100  L_L113  -0.0426
K_K4749  L_L100  L_L115  -0.0554
K_K4750  L_L100  L_L116  0.0191
K_K4751  L_L100  L_L117  0.0242
K_K4752  L_L100  L_L118  -0.0338
K_K4753  L_L100  L_L119  0.1204
* *  Branch  N_C0_40 - N_C0_26
R_R101  N_C0_40  nR_101  146.279470m  TC=0,0
R_V395  nR_101  nV_395  1728.927709m  TC=0,0
L_V395  nR_101  nV_395  0.137034uH
R_V396  nV_395  nV_396  -1631.045458m  TC=0,0
L_V396  nV_395  nV_396  -0.136975uH
R_V397  nV_396  nV_397  541.938500m  TC=0,0
L_V397  nV_396  nV_397  0.218000uH
R_V398  nV_397  nV_398  -517.825245m  TC=0,0
L_V398  nV_397  nV_398  -0.220173uH
R_V399  nV_398  nV_399  254.312116m  TC=0,0
L_V399  nV_398  nV_399  0.452236uH
R_V400  nV_399  nV_400  -237.046348m  TC=0,0
L_V400  nV_399  nV_400  -0.436949uH
R_V401  nV_400  nV_401  -0.964860m  TC=0,0
L_V401  nV_400  nV_401  -0.006677uH
R_V402  nV_401  nV_402  5.575644m  TC=0,0
L_V402  nV_401  nV_402  0.057145uH
R_V403  nV_402  nV_403  -1.070329m  TC=0,0
L_V403  nV_402  nV_403  -0.041721uH
R_V404  nV_403  nV_404  2.069971m  TC=0,0
L_V404  nV_403  nV_404  0.167799uH
L_L101  nV_404  N_C0_26  2.111869uH
K_K4754  L_L101  L_L102  0.1383
K_K4755  L_L101  L_L103  0.2996
K_K4756  L_L101  L_L104  0.1104
K_K4757  L_L101  L_L105  0.3935
K_K4758  L_L101  L_L106  0.1057
K_K4759  L_L101  L_L107  0.1736
K_K4760  L_L101  L_L108  0.1104
K_K4761  L_L101  L_L109  0.1542
K_K4762  L_L101  L_L110  0.0614
K_K4763  L_L101  L_L111  0.0478
K_K4764  L_L101  L_L112  0.0458
K_K4765  L_L101  L_L113  0.0566
K_K4766  L_L101  L_L114  0.0577
K_K4767  L_L101  L_L115  0.0530
K_K4768  L_L101  L_L116  0.0520
K_K4769  L_L101  L_L117  0.0542
K_K4770  L_L101  L_L118  0.0509
K_K4771  L_L101  L_L119  0.0553
* *  Branch  N_C0_34 - N_C0_40
R_R102  N_C0_34  nR_102  146.279471m  TC=0,0
R_V405  nR_102  nV_405  1728.928172m  TC=0,0
L_V405  nR_102  nV_405  0.137034uH
R_V406  nV_405  nV_406  -1631.045920m  TC=0,0
L_V406  nV_405  nV_406  -0.136975uH
R_V407  nV_406  nV_407  541.938377m  TC=0,0
L_V407  nV_406  nV_407  0.218000uH
R_V408  nV_407  nV_408  -517.825122m  TC=0,0
L_V408  nV_407  nV_408  -0.220173uH
R_V409  nV_408  nV_409  254.312280m  TC=0,0
L_V409  nV_408  nV_409  0.452236uH
R_V410  nV_409  nV_410  -237.046511m  TC=0,0
L_V410  nV_409  nV_410  -0.436950uH
R_V411  nV_410  nV_411  -0.964861m  TC=0,0
L_V411  nV_410  nV_411  -0.006677uH
R_V412  nV_411  nV_412  5.575644m  TC=0,0
L_V412  nV_411  nV_412  0.057145uH
R_V413  nV_412  nV_413  -1.070329m  TC=0,0
L_V413  nV_412  nV_413  -0.041721uH
R_V414  nV_413  nV_414  2.069971m  TC=0,0
L_V414  nV_413  nV_414  0.167799uH
L_L102  nV_414  N_C0_40  2.114632uH
K_K4772  L_L102  L_L103  0.1605
K_K4773  L_L102  L_L104  0.1932
K_K4774  L_L102  L_L105  0.1208
K_K4775  L_L102  L_L106  0.1316
K_K4776  L_L102  L_L107  0.0887
K_K4777  L_L102  L_L108  0.1932
K_K4778  L_L102  L_L109  0.1017
K_K4779  L_L102  L_L110  -0.0785
K_K4780  L_L102  L_L113  0.0294
K_K4781  L_L102  L_L115  0.0242
K_K4782  L_L102  L_L116  -0.0338
K_K4783  L_L102  L_L117  -0.0554
K_K4784  L_L102  L_L118  0.0191
K_K4785  L_L102  L_L119  0.1204
* *  Branch  N_C0_40 - N_C0_25
R_R103  N_C0_40  nR_103  146.279470m  TC=0,0
R_V415  nR_103  nV_415  1728.927709m  TC=0,0
L_V415  nR_103  nV_415  0.137034uH
R_V416  nV_415  nV_416  -1631.045458m  TC=0,0
L_V416  nV_415  nV_416  -0.136975uH
R_V417  nV_416  nV_417  541.938500m  TC=0,0
L_V417  nV_416  nV_417  0.218000uH
R_V418  nV_417  nV_418  -517.825245m  TC=0,0
L_V418  nV_417  nV_418  -0.220173uH
R_V419  nV_418  nV_419  254.312116m  TC=0,0
L_V419  nV_418  nV_419  0.452236uH
R_V420  nV_419  nV_420  -237.046348m  TC=0,0
L_V420  nV_419  nV_420  -0.436949uH
R_V421  nV_420  nV_421  -0.964860m  TC=0,0
L_V421  nV_420  nV_421  -0.006677uH
R_V422  nV_421  nV_422  5.575644m  TC=0,0
L_V422  nV_421  nV_422  0.057145uH
R_V423  nV_422  nV_423  -1.070329m  TC=0,0
L_V423  nV_422  nV_423  -0.041721uH
R_V424  nV_423  nV_424  2.069971m  TC=0,0
L_V424  nV_423  nV_424  0.167799uH
L_L103  nV_424  N_C0_25  2.111869uH
K_K4786  L_L103  L_L104  0.1017
K_K4787  L_L103  L_L105  0.1922
K_K4788  L_L103  L_L106  0.0887
K_K4789  L_L103  L_L107  0.1305
K_K4790  L_L103  L_L108  0.1208
K_K4791  L_L103  L_L109  0.1922
K_K4792  L_L103  L_L110  0.0614
K_K4793  L_L103  L_L111  0.0458
K_K4794  L_L103  L_L112  0.0441
K_K4795  L_L103  L_L113  0.0566
K_K4796  L_L103  L_L114  0.0601
K_K4797  L_L103  L_L115  0.0542
K_K4798  L_L103  L_L116  0.0509
K_K4799  L_L103  L_L117  0.0530
K_K4800  L_L103  L_L118  0.0520
K_K4801  L_L103  L_L119  0.0553
* *  Branch  N_C0_35 - N_C0_37
R_R104  N_C0_35  nR_104  146.279471m  TC=0,0
R_V425  nR_104  nV_425  1728.928172m  TC=0,0
L_V425  nR_104  nV_425  0.137034uH
R_V426  nV_425  nV_426  -1631.045920m  TC=0,0
L_V426  nV_425  nV_426  -0.136975uH
R_V427  nV_426  nV_427  541.938377m  TC=0,0
L_V427  nV_426  nV_427  0.218000uH
R_V428  nV_427  nV_428  -517.825122m  TC=0,0
L_V428  nV_427  nV_428  -0.220173uH
R_V429  nV_428  nV_429  254.312280m  TC=0,0
L_V429  nV_428  nV_429  0.452236uH
R_V430  nV_429  nV_430  -237.046511m  TC=0,0
L_V430  nV_429  nV_430  -0.436950uH
R_V431  nV_430  nV_431  -0.964861m  TC=0,0
L_V431  nV_430  nV_431  -0.006677uH
R_V432  nV_431  nV_432  5.575644m  TC=0,0
L_V432  nV_431  nV_432  0.057145uH
R_V433  nV_432  nV_433  -1.070329m  TC=0,0
L_V433  nV_432  nV_433  -0.041721uH
R_V434  nV_433  nV_434  2.069971m  TC=0,0
L_V434  nV_433  nV_434  0.167799uH
L_L104  nV_434  N_C0_37  2.114632uH
K_K4802  L_L104  L_L105  0.1605
K_K4803  L_L104  L_L106  0.1932
K_K4804  L_L104  L_L107  0.1208
K_K4805  L_L104  L_L108  0.1316
K_K4806  L_L104  L_L109  0.0887
K_K4807  L_L104  L_L111  -0.0455
K_K4808  L_L104  L_L112  -0.0773
K_K4809  L_L104  L_L114  0.0294
K_K4810  L_L104  L_L115  0.0191
K_K4811  L_L104  L_L116  -0.0554
K_K4812  L_L104  L_L117  0.0242
K_K4813  L_L104  L_L118  -0.0338
K_K4814  L_L104  L_L119  0.1204
* *  Branch  N_C0_37 - N_C0_26
R_R105  N_C0_37  nR_105  146.279470m  TC=0,0
R_V435  nR_105  nV_435  1728.927709m  TC=0,0
L_V435  nR_105  nV_435  0.137034uH
R_V436  nV_435  nV_436  -1631.045458m  TC=0,0
L_V436  nV_435  nV_436  -0.136975uH
R_V437  nV_436  nV_437  541.938500m  TC=0,0
L_V437  nV_436  nV_437  0.218000uH
R_V438  nV_437  nV_438  -517.825245m  TC=0,0
L_V438  nV_437  nV_438  -0.220173uH
R_V439  nV_438  nV_439  254.312116m  TC=0,0
L_V439  nV_438  nV_439  0.452236uH
R_V440  nV_439  nV_440  -237.046348m  TC=0,0
L_V440  nV_439  nV_440  -0.436949uH
R_V441  nV_440  nV_441  -0.964860m  TC=0,0
L_V441  nV_440  nV_441  -0.006677uH
R_V442  nV_441  nV_442  5.575644m  TC=0,0
L_V442  nV_441  nV_442  0.057145uH
R_V443  nV_442  nV_443  -1.070329m  TC=0,0
L_V443  nV_442  nV_443  -0.041721uH
R_V444  nV_443  nV_444  2.069971m  TC=0,0
L_V444  nV_443  nV_444  0.167799uH
L_L105  nV_444  N_C0_26  2.111869uH
K_K4815  L_L105  L_L106  0.1017
K_K4816  L_L105  L_L107  0.1922
K_K4817  L_L105  L_L108  0.0887
K_K4818  L_L105  L_L109  0.1305
K_K4819  L_L105  L_L110  0.0601
K_K4820  L_L105  L_L111  0.0483
K_K4821  L_L105  L_L112  0.0473
K_K4822  L_L105  L_L113  0.0577
K_K4823  L_L105  L_L114  0.0566
K_K4824  L_L105  L_L115  0.0520
K_K4825  L_L105  L_L116  0.0530
K_K4826  L_L105  L_L117  0.0542
K_K4827  L_L105  L_L118  0.0509
K_K4828  L_L105  L_L119  0.0553
* *  Branch  N_C0_36 - N_C0_38
R_R106  N_C0_36  nR_106  146.279471m  TC=0,0
R_V445  nR_106  nV_445  1728.928172m  TC=0,0
L_V445  nR_106  nV_445  0.137034uH
R_V446  nV_445  nV_446  -1631.045920m  TC=0,0
L_V446  nV_445  nV_446  -0.136975uH
R_V447  nV_446  nV_447  541.938377m  TC=0,0
L_V447  nV_446  nV_447  0.218000uH
R_V448  nV_447  nV_448  -517.825122m  TC=0,0
L_V448  nV_447  nV_448  -0.220173uH
R_V449  nV_448  nV_449  254.312280m  TC=0,0
L_V449  nV_448  nV_449  0.452236uH
R_V450  nV_449  nV_450  -237.046511m  TC=0,0
L_V450  nV_449  nV_450  -0.436950uH
R_V451  nV_450  nV_451  -0.964861m  TC=0,0
L_V451  nV_450  nV_451  -0.006677uH
R_V452  nV_451  nV_452  5.575644m  TC=0,0
L_V452  nV_451  nV_452  0.057145uH
R_V453  nV_452  nV_453  -1.070329m  TC=0,0
L_V453  nV_452  nV_453  -0.041721uH
R_V454  nV_453  nV_454  2.069971m  TC=0,0
L_V454  nV_453  nV_454  0.167799uH
L_L106  nV_454  N_C0_38  2.114632uH
K_K4829  L_L106  L_L107  0.1605
K_K4830  L_L106  L_L108  0.1932
K_K4831  L_L106  L_L109  0.1208
K_K4832  L_L106  L_L110  0.0294
K_K4833  L_L106  L_L111  0.0946
K_K4834  L_L106  L_L113  -0.0785
K_K4835  L_L106  L_L115  -0.0338
K_K4836  L_L106  L_L116  0.0242
K_K4837  L_L106  L_L117  0.0191
K_K4838  L_L106  L_L118  -0.0554
K_K4839  L_L106  L_L119  0.1204
* *  Branch  N_C0_38 - N_C0_27
R_R107  N_C0_38  nR_107  146.279470m  TC=0,0
R_V455  nR_107  nV_455  1728.927709m  TC=0,0
L_V455  nR_107  nV_455  0.137034uH
R_V456  nV_455  nV_456  -1631.045458m  TC=0,0
L_V456  nV_455  nV_456  -0.136975uH
R_V457  nV_456  nV_457  541.938500m  TC=0,0
L_V457  nV_456  nV_457  0.218000uH
R_V458  nV_457  nV_458  -517.825245m  TC=0,0
L_V458  nV_457  nV_458  -0.220173uH
R_V459  nV_458  nV_459  254.312116m  TC=0,0
L_V459  nV_458  nV_459  0.452236uH
R_V460  nV_459  nV_460  -237.046348m  TC=0,0
L_V460  nV_459  nV_460  -0.436949uH
R_V461  nV_460  nV_461  -0.964860m  TC=0,0
L_V461  nV_460  nV_461  -0.006677uH
R_V462  nV_461  nV_462  5.575644m  TC=0,0
L_V462  nV_461  nV_462  0.057145uH
R_V463  nV_462  nV_463  -1.070329m  TC=0,0
L_V463  nV_462  nV_463  -0.041721uH
R_V464  nV_463  nV_464  2.069971m  TC=0,0
L_V464  nV_463  nV_464  0.167799uH
L_L107  nV_464  N_C0_27  2.111869uH
K_K4840  L_L107  L_L108  0.1017
K_K4841  L_L107  L_L109  0.1922
K_K4842  L_L107  L_L110  0.0566
K_K4843  L_L107  L_L111  0.0458
K_K4844  L_L107  L_L112  0.0478
K_K4845  L_L107  L_L113  0.0614
K_K4846  L_L107  L_L114  0.0577
K_K4847  L_L107  L_L115  0.0509
K_K4848  L_L107  L_L116  0.0542
K_K4849  L_L107  L_L117  0.0520
K_K4850  L_L107  L_L118  0.0530
K_K4851  L_L107  L_L119  0.0553
* *  Branch  N_C0_33 - N_C0_39
R_R108  N_C0_33  nR_108  146.279471m  TC=0,0
R_V465  nR_108  nV_465  1728.928172m  TC=0,0
L_V465  nR_108  nV_465  0.137034uH
R_V466  nV_465  nV_466  -1631.045920m  TC=0,0
L_V466  nV_465  nV_466  -0.136975uH
R_V467  nV_466  nV_467  541.938377m  TC=0,0
L_V467  nV_466  nV_467  0.218000uH
R_V468  nV_467  nV_468  -517.825122m  TC=0,0
L_V468  nV_467  nV_468  -0.220173uH
R_V469  nV_468  nV_469  254.312280m  TC=0,0
L_V469  nV_468  nV_469  0.452236uH
R_V470  nV_469  nV_470  -237.046511m  TC=0,0
L_V470  nV_469  nV_470  -0.436950uH
R_V471  nV_470  nV_471  -0.964861m  TC=0,0
L_V471  nV_470  nV_471  -0.006677uH
R_V472  nV_471  nV_472  5.575644m  TC=0,0
L_V472  nV_471  nV_472  0.057145uH
R_V473  nV_472  nV_473  -1.070329m  TC=0,0
L_V473  nV_472  nV_473  -0.041721uH
R_V474  nV_473  nV_474  2.069971m  TC=0,0
L_V474  nV_473  nV_474  0.167799uH
L_L108  nV_474  N_C0_39  2.114632uH
K_K4852  L_L108  L_L109  0.1605
K_K4853  L_L108  L_L111  0.0982
K_K4854  L_L108  L_L112  0.0914
K_K4855  L_L108  L_L114  -0.0785
K_K4856  L_L108  L_L115  -0.0554
K_K4857  L_L108  L_L116  0.0191
K_K4858  L_L108  L_L117  -0.0338
K_K4859  L_L108  L_L118  0.0242
K_K4860  L_L108  L_L119  0.1204
* *  Branch  N_C0_39 - N_C0_28
R_R109  N_C0_39  nR_109  146.279470m  TC=0,0
R_V475  nR_109  nV_475  1728.927709m  TC=0,0
L_V475  nR_109  nV_475  0.137034uH
R_V476  nV_475  nV_476  -1631.045458m  TC=0,0
L_V476  nV_475  nV_476  -0.136975uH
R_V477  nV_476  nV_477  541.938500m  TC=0,0
L_V477  nV_476  nV_477  0.218000uH
R_V478  nV_477  nV_478  -517.825245m  TC=0,0
L_V478  nV_477  nV_478  -0.220173uH
R_V479  nV_478  nV_479  254.312116m  TC=0,0
L_V479  nV_478  nV_479  0.452236uH
R_V480  nV_479  nV_480  -237.046348m  TC=0,0
L_V480  nV_479  nV_480  -0.436949uH
R_V481  nV_480  nV_481  -0.964860m  TC=0,0
L_V481  nV_480  nV_481  -0.006677uH
R_V482  nV_481  nV_482  5.575644m  TC=0,0
L_V482  nV_481  nV_482  0.057145uH
R_V483  nV_482  nV_483  -1.070329m  TC=0,0
L_V483  nV_482  nV_483  -0.041721uH
R_V484  nV_483  nV_484  2.069971m  TC=0,0
L_V484  nV_483  nV_484  0.167799uH
L_L109  nV_484  N_C0_28  2.111869uH
K_K4861  L_L109  L_L110  0.0577
K_K4862  L_L109  L_L111  0.0437
K_K4863  L_L109  L_L112  0.0445
K_K4864  L_L109  L_L113  0.0601
K_K4865  L_L109  L_L114  0.0614
K_K4866  L_L109  L_L115  0.0530
K_K4867  L_L109  L_L116  0.0520
K_K4868  L_L109  L_L117  0.0509
K_K4869  L_L109  L_L118  0.0542
K_K4870  L_L109  L_L119  0.0553
* *  Branch  N_C0_33 - N_C0_34
R_R110  N_C0_33  nR_110  0.541340m  TC=0,0
L_L110  nR_110  N_C0_34  1.088518uH
K_K4871  L_L110  L_L113  -0.1339
K_K4872  L_L110  L_L115  -0.2633
K_K4873  L_L110  L_L116  0.1026
K_K4874  L_L110  L_L117  0.2542
K_K4875  L_L110  L_L118  -0.1117
* *  Branch  N_C0_34 - N_C0_CONN_TOP
R_R111  N_C0_34  nR_111  0.270670m  TC=0,0
L_L111  nR_111  N_C0_CONN_TOP  0.444404uH
K_K4876  L_L111  L_L112  0.2236
K_K4877  L_L111  L_L114  -0.1048
K_K4878  L_L111  L_L115  -0.0930
K_K4879  L_L111  L_L116  0.1151
K_K4880  L_L111  L_L117  -0.2899
K_K4881  L_L111  L_L118  0.0747
* *  Branch  N_C0_CONN_TOP - N_C0_35
R_R112  N_C0_CONN_TOP  nR_112  0.270670m  TC=0,0
L_L112  nR_112  N_C0_35  0.444404uH
K_K4882  L_L112  L_L114  -0.1048
K_K4883  L_L112  L_L115  -0.0818
K_K4884  L_L112  L_L116  0.2828
K_K4885  L_L112  L_L117  -0.1222
K_K4886  L_L112  L_L118  0.0859
* *  Branch  N_C0_35 - N_C0_36
R_R113  N_C0_35  nR_113  0.541340m  TC=0,0
L_L113  nR_113  N_C0_36  1.088518uH
K_K4887  L_L113  L_L115  0.1026
K_K4888  L_L113  L_L116  -0.2633
K_K4889  L_L113  L_L117  -0.1117
K_K4890  L_L113  L_L118  0.2542
* *  Branch  N_C0_36 - N_C0_33
R_R114  N_C0_36  nR_114  0.541340m  TC=0,0
L_L114  nR_114  N_C0_33  1.088518uH
K_K4891  L_L114  L_L115  0.2542
K_K4892  L_L114  L_L116  -0.1117
K_K4893  L_L114  L_L117  0.1026
K_K4894  L_L114  L_L118  -0.2633
* *  Branch  N_C0_42 - N_C0_33
R_R115  N_C0_42  nR_115  0.382785m  TC=0,0
L_L115  nR_115  N_C0_33  0.698935uH
K_K4895  L_L115  L_L116  -0.2098
* *  Branch  N_C0_42 - N_C0_35
R_R116  N_C0_42  nR_116  0.382785m  TC=0,0
L_L116  nR_116  N_C0_35  0.698935uH
* *  Branch  N_C0_42 - N_C0_34
R_R117  N_C0_42  nR_117  0.382785m  TC=0,0
L_L117  nR_117  N_C0_34  0.698935uH
K_K4896  L_L117  L_L118  -0.2098
* *  Branch  N_C0_42 - N_C0_36
R_R118  N_C0_42  nR_118  0.382785m  TC=0,0
L_L118  nR_118  N_C0_36  0.698935uH
* *  Branch  N_TOP - N_C0_42
R_R119  N_TOP  nR_119  168.132386m  TC=0,0
R_V485  nR_119  nV_485  1987.215601m  TC=0,0
L_V485  nR_119  nV_485  0.157506uH
R_V486  nV_485  nV_486  -1874.710569m  TC=0,0
L_V486  nV_485  nV_486  -0.157438uH
R_V487  nV_486  nV_487  622.899348m  TC=0,0
L_V487  nV_486  nV_487  0.250567uH
R_V488  nV_487  nV_488  -595.183777m  TC=0,0
L_V488  nV_487  nV_488  -0.253065uH
R_V489  nV_488  nV_489  292.304369m  TC=0,0
L_V489  nV_488  nV_489  0.519796uH
R_V490  nV_489  nV_490  -272.459241m  TC=0,0
L_V490  nV_489  nV_490  -0.502226uH
R_V491  nV_490  nV_491  -1.109002m  TC=0,0
L_V491  nV_490  nV_491  -0.007675uH
R_V492  nV_491  nV_492  6.408598m  TC=0,0
L_V492  nV_491  nV_492  0.065682uH
R_V493  nV_492  nV_493  -1.230227m  TC=0,0
L_V493  nV_492  nV_493  -0.047954uH
R_V494  nV_493  nV_494  2.379207m  TC=0,0
L_V494  nV_493  nV_494  0.192867uH
L_L119  nV_494  N_C0_42  2.513197uH
* *  Node  N_S0_170 to other nodes
C_C1  N_S0_170  0  1.452895e+01pF
C_C2  N_S0_170  N_C1_170  2.643252e+02pF
C_C3  N_S0_170  N_C2_170  2.643252e+02pF
C_C4  N_S0_170  N_S0_OUT  2.131204e+00pF
C_C5  N_S0_170  N_C0_5  1.740967e+00pF
C_C6  N_S0_170  N_C0_6  1.141590e+01pF
C_C7  N_S0_170  N_C0_7  1.141590e+01pF
C_C8  N_S0_170  N_C0_8  1.740967e+00pF
C_C9  N_S0_170  N_C0_9  1.881637e+01pF
C_C10  N_S0_170  N_C0_10  1.426921e+00pF
C_C11  N_S0_170  N_C0_12  1.426921e+00pF
C_C12  N_S0_170  N_C0_21  4.523057e+00pF
* *  Node  NTMP0000000001 to other nodes
C_C13  NTMP0000000001  0  7.638139e+00pF
C_C14  NTMP0000000001  N_S0_UP  2.438609e+00pF
C_C15  NTMP0000000001  NTMP0000000003  3.364185e+02pF
C_C16  NTMP0000000001  NTMP0000000005  3.364185e+02pF
C_C17  NTMP0000000001  N_C0_17  1.791576e+00pF
C_C18  NTMP0000000001  N_C0_18  1.051526e+01pF
C_C19  NTMP0000000001  N_C0_19  1.051526e+01pF
C_C20  NTMP0000000001  N_C0_20  1.791576e+00pF
C_C21  NTMP0000000001  N_C0_21  2.088415e+01pF
C_C22  NTMP0000000001  N_C0_25  1.574551e+00pF
C_C23  NTMP0000000001  N_C0_26  8.645951e+00pF
C_C24  NTMP0000000001  N_C0_27  8.645952e+00pF
C_C25  NTMP0000000001  N_C0_28  1.574551e+00pF
C_C26  NTMP0000000001  N_C0_29  2.714972e+01pF
C_C27  NTMP0000000001  N_C0_30  1.438713e+00pF
C_C28  NTMP0000000001  N_C0_32  1.438713e+00pF
* *  Node  N_S0_UP to other nodes
C_C29  N_S0_UP  0  5.283704e+00pF
C_C30  N_S0_UP  N_C1_UP  1.682598e+02pF
C_C31  N_S0_UP  N_C2_UP  1.682598e+02pF
C_C32  N_S0_UP  N_C0_26  2.501355e+00pF
C_C33  N_S0_UP  N_C0_27  2.501354e+00pF
C_C34  N_S0_UP  N_C0_34  4.295386e+00pF
C_C35  N_S0_UP  N_C0_35  4.295170e+00pF
C_C36  N_S0_UP  N_C0_37  2.725969e+01pF
C_C37  N_S0_UP  N_C0_38  1.394773e+00pF
C_C38  N_S0_UP  N_C0_40  1.394767e+00pF
C_C39  N_S0_UP  N_C0_42  1.043922e+00pF
* *  Node  N_C1_170 to other nodes
C_C40  N_C1_170  N_C2_170  3.358610e+01pF
* *  Node  NTMP0000000003 to other nodes
C_C41  NTMP0000000003  NTMP0000000005  4.280125e+01pF
* *  Node  N_C1_UP to other nodes
C_C42  N_C1_UP  N_C2_UP  2.140293e+01pF
* *  Node  N_C2_170 to other nodes
* *  Node  NTMP0000000005 to other nodes
* *  Node  N_C2_UP to other nodes
* *  Node  N_S0_OUT to other nodes
C_C43  N_S0_OUT  0  1.840793e+01pF
C_C44  N_S0_OUT  N_C1_OUT  9.624664e+01pF
C_C45  N_S0_OUT  N_C2_OUT  9.624664e+01pF
* *  Node  N_C1_OUT to other nodes
C_C46  N_C1_OUT  N_C2_OUT  1.223213e+01pF
* *  Node  N_C2_OUT to other nodes
* *  Node  N_C0_1 to other nodes
C_C47  N_C0_1  0  5.507031e+01pF
C_C48  N_C0_1  N_C0_2  3.656734e+00pF
C_C49  N_C0_1  N_C0_4  3.658441e+00pF
C_C50  N_C0_1  N_C0_5  1.820159e+00pF
C_C51  N_C0_1  N_C0_11  6.738759e+00pF
C_C52  N_C0_1  N_C0_12  6.739926e+00pF
C_C53  N_C0_1  J4  1.573377e+02pF
* *  Node  N_C0_2 to other nodes
C_C54  N_C0_2  0  5.456220e+01pF
C_C55  N_C0_2  N_C0_3  3.624624e+00pF
C_C56  N_C0_2  N_C0_6  1.809655e+00pF
C_C57  N_C0_2  N_C0_9  6.578322e+00pF
C_C58  N_C0_2  N_C0_12  6.718055e+00pF
C_C59  N_C0_2  J1  1.573380e+02pF
* *  Node  N_C0_3 to other nodes
C_C60  N_C0_3  0  5.456220e+01pF
C_C61  N_C0_3  N_C0_4  3.656343e+00pF
C_C62  N_C0_3  N_C0_7  1.809655e+00pF
C_C63  N_C0_3  N_C0_9  6.578321e+00pF
C_C64  N_C0_3  N_C0_10  6.718055e+00pF
C_C65  N_C0_3  J2  1.573380e+02pF
* *  Node  N_C0_4 to other nodes
C_C66  N_C0_4  0  5.507031e+01pF
C_C67  N_C0_4  N_C0_8  1.820159e+00pF
C_C68  N_C0_4  N_C0_10  6.739926e+00pF
C_C69  N_C0_4  N_C0_11  6.738759e+00pF
C_C70  N_C0_4  J3  1.573377e+02pF
* *  Node  N_C0_5 to other nodes
C_C71  N_C0_5  0  2.009239e+01pF
C_C72  N_C0_5  N_C0_6  1.094049e+01pF
C_C73  N_C0_5  N_C0_7  3.332826e+00pF
C_C74  N_C0_5  N_C0_8  1.121461e+01pF
C_C75  N_C0_5  N_C0_10  1.112659e+00pF
C_C76  N_C0_5  N_C0_11  7.050775e+00pF
C_C77  N_C0_5  N_C0_12  7.032281e+00pF
C_C78  N_C0_5  N_C0_17  2.376476e+00pF
C_C79  N_C0_5  N_C0_22  1.118819e+00pF
C_C80  N_C0_5  N_C0_23  7.218469e+00pF
C_C81  N_C0_5  N_C0_24  7.208590e+00pF
* *  Node  N_C0_6 to other nodes
C_C82  N_C0_6  0  1.843626e+01pF
C_C83  N_C0_6  N_C0_7  9.151144e+00pF
C_C84  N_C0_6  N_C0_8  3.331952e+00pF
C_C85  N_C0_6  N_C0_9  4.193572e+00pF
C_C86  N_C0_6  N_C0_11  1.064136e+00pF
C_C87  N_C0_6  N_C0_12  6.863674e+00pF
C_C88  N_C0_6  N_C0_18  2.327370e+00pF
C_C89  N_C0_6  N_C0_21  6.358750e+00pF
C_C90  N_C0_6  N_C0_22  1.045431e+00pF
C_C91  N_C0_6  N_C0_23  1.098428e+00pF
C_C92  N_C0_6  N_C0_24  7.135192e+00pF
* *  Node  N_C0_7 to other nodes
C_C93  N_C0_7  0  1.843626e+01pF
C_C94  N_C0_7  N_C0_8  1.093962e+01pF
C_C95  N_C0_7  N_C0_9  4.193572e+00pF
C_C96  N_C0_7  N_C0_10  6.863674e+00pF
C_C97  N_C0_7  N_C0_11  1.064136e+00pF
C_C98  N_C0_7  N_C0_19  2.327371e+00pF
C_C99  N_C0_7  N_C0_21  6.358750e+00pF
C_C100  N_C0_7  N_C0_22  7.135192e+00pF
C_C101  N_C0_7  N_C0_23  1.098428e+00pF
C_C102  N_C0_7  N_C0_24  1.045431e+00pF
* *  Node  N_C0_8 to other nodes
C_C103  N_C0_8  0  2.009239e+01pF
C_C104  N_C0_8  N_C0_10  7.032281e+00pF
C_C105  N_C0_8  N_C0_11  7.050775e+00pF
C_C106  N_C0_8  N_C0_12  1.112659e+00pF
C_C107  N_C0_8  N_C0_20  2.376476e+00pF
C_C108  N_C0_8  N_C0_22  7.208590e+00pF
C_C109  N_C0_8  N_C0_23  7.218469e+00pF
C_C110  N_C0_8  N_C0_24  1.118819e+00pF
* *  Node  N_C0_9 to other nodes
C_C111  N_C0_9  0  7.539083e+00pF
C_C112  N_C0_9  N_C0_10  7.339036e+00pF
C_C113  N_C0_9  N_C0_11  2.500039e+00pF
C_C114  N_C0_9  N_C0_12  7.339036e+00pF
* *  Node  N_C0_10 to other nodes
C_C115  N_C0_10  0  1.107616e+01pF
C_C116  N_C0_10  N_C0_11  7.687361e+00pF
C_C117  N_C0_10  N_C0_12  2.596164e+00pF
* *  Node  N_C0_11 to other nodes
C_C118  N_C0_11  0  1.140088e+01pF
C_C119  N_C0_11  N_C0_12  7.686878e+00pF
* *  Node  N_C0_12 to other nodes
C_C120  N_C0_12  0  1.107616e+01pF
* *  Node  J1 to other nodes
C_C121  J1  0  4.739039e+00pF
* *  Node  J4 to other nodes
C_C122  J4  0  4.743710e+00pF
* *  Node  J3 to other nodes
C_C123  J3  0  4.743710e+00pF
* *  Node  J2 to other nodes
C_C124  J2  0  4.739039e+00pF
* *  Node  N_C0_17 to other nodes
C_C125  N_C0_17  0  1.697910e+01pF
C_C126  N_C0_17  N_C0_18  1.113362e+01pF
C_C127  N_C0_17  N_C0_19  3.489842e+00pF
C_C128  N_C0_17  N_C0_20  1.136691e+01pF
C_C129  N_C0_17  N_C0_22  1.211253e+00pF
C_C130  N_C0_17  N_C0_23  7.249517e+00pF
C_C131  N_C0_17  N_C0_24  7.234928e+00pF
C_C132  N_C0_17  N_C0_25  2.455434e+00pF
C_C133  N_C0_17  N_C0_30  1.157672e+00pF
C_C134  N_C0_17  N_C0_31  7.266080e+00pF
C_C135  N_C0_17  N_C0_32  7.257735e+00pF
* *  Node  N_C0_18 to other nodes
C_C136  N_C0_18  0  1.621629e+01pF
C_C137  N_C0_18  N_C0_19  9.598127e+00pF
C_C138  N_C0_18  N_C0_20  3.489857e+00pF
C_C139  N_C0_18  N_C0_21  3.288279e+00pF
C_C140  N_C0_18  N_C0_22  1.071009e+00pF
C_C141  N_C0_18  N_C0_23  1.160623e+00pF
C_C142  N_C0_18  N_C0_24  7.094682e+00pF
C_C143  N_C0_18  N_C0_26  2.303619e+00pF
C_C144  N_C0_18  N_C0_29  6.694213e+00pF
C_C145  N_C0_18  N_C0_30  1.105605e+00pF
C_C146  N_C0_18  N_C0_31  1.144688e+00pF
C_C147  N_C0_18  N_C0_32  7.205661e+00pF
* *  Node  N_C0_19 to other nodes
C_C148  N_C0_19  0  1.621629e+01pF
C_C149  N_C0_19  N_C0_20  1.113364e+01pF
C_C150  N_C0_19  N_C0_21  3.288279e+00pF
C_C151  N_C0_19  N_C0_22  7.094682e+00pF
C_C152  N_C0_19  N_C0_23  1.160623e+00pF
C_C153  N_C0_19  N_C0_24  1.071009e+00pF
C_C154  N_C0_19  N_C0_27  2.303620e+00pF
C_C155  N_C0_19  N_C0_29  6.694213e+00pF
C_C156  N_C0_19  N_C0_30  7.205661e+00pF
C_C157  N_C0_19  N_C0_31  1.144688e+00pF
C_C158  N_C0_19  N_C0_32  1.105605e+00pF
* *  Node  N_C0_20 to other nodes
C_C159  N_C0_20  0  1.697910e+01pF
C_C160  N_C0_20  N_C0_22  7.234928e+00pF
C_C161  N_C0_20  N_C0_23  7.249517e+00pF
C_C162  N_C0_20  N_C0_24  1.211253e+00pF
C_C163  N_C0_20  N_C0_28  2.455434e+00pF
C_C164  N_C0_20  N_C0_30  7.257736e+00pF
C_C165  N_C0_20  N_C0_31  7.266080e+00pF
C_C166  N_C0_20  N_C0_32  1.157672e+00pF
* *  Node  N_C0_21 to other nodes
C_C167  N_C0_21  0  5.717620e+00pF
C_C168  N_C0_21  N_C0_22  7.514043e+00pF
C_C169  N_C0_21  N_C0_23  2.559415e+00pF
C_C170  N_C0_21  N_C0_24  7.514043e+00pF
* *  Node  N_C0_22 to other nodes
C_C171  N_C0_22  0  7.685498e+00pF
C_C172  N_C0_22  N_C0_23  7.905951e+00pF
C_C173  N_C0_22  N_C0_24  2.725500e+00pF
* *  Node  N_C0_23 to other nodes
C_C174  N_C0_23  0  7.797054e+00pF
C_C175  N_C0_23  N_C0_24  7.905939e+00pF
* *  Node  N_C0_24 to other nodes
C_C176  N_C0_24  0  7.685497e+00pF
* *  Node  N_C0_25 to other nodes
C_C177  N_C0_25  0  1.668325e+01pF
C_C178  N_C0_25  N_C0_26  1.120585e+01pF
C_C179  N_C0_25  N_C0_27  3.558515e+00pF
C_C180  N_C0_25  N_C0_28  1.141713e+01pF
C_C181  N_C0_25  N_C0_30  1.232013e+00pF
C_C182  N_C0_25  N_C0_31  7.274891e+00pF
C_C183  N_C0_25  N_C0_32  7.258867e+00pF
C_C184  N_C0_25  N_C0_33  2.311466e+00pF
C_C185  N_C0_25  N_C0_38  1.184165e+00pF
C_C186  N_C0_25  N_C0_39  7.295256e+00pF
C_C187  N_C0_25  N_C0_40  7.284924e+00pF
* *  Node  N_C0_26 to other nodes
C_C188  N_C0_26  0  1.595187e+01pF
C_C189  N_C0_26  N_C0_27  1.000500e+01pF
C_C190  N_C0_26  N_C0_28  3.558512e+00pF
C_C191  N_C0_26  N_C0_29  3.235808e+00pF
C_C192  N_C0_26  N_C0_30  1.083276e+00pF
C_C193  N_C0_26  N_C0_31  1.178930e+00pF
C_C194  N_C0_26  N_C0_32  7.110095e+00pF
C_C195  N_C0_26  N_C0_34  2.122645e+00pF
C_C196  N_C0_26  N_C0_37  6.124939e+00pF
C_C197  N_C0_26  N_C0_38  1.174421e+00pF
C_C198  N_C0_26  N_C0_39  1.194826e+00pF
C_C199  N_C0_26  N_C0_40  7.273187e+00pF
* *  Node  N_C0_27 to other nodes
C_C200  N_C0_27  0  1.595197e+01pF
C_C201  N_C0_27  N_C0_28  1.120585e+01pF
C_C202  N_C0_27  N_C0_29  3.235808e+00pF
C_C203  N_C0_27  N_C0_30  7.110096e+00pF
C_C204  N_C0_27  N_C0_31  1.178931e+00pF
C_C205  N_C0_27  N_C0_32  1.083276e+00pF
C_C206  N_C0_27  N_C0_35  2.122812e+00pF
C_C207  N_C0_27  N_C0_37  6.124945e+00pF
C_C208  N_C0_27  N_C0_38  7.273189e+00pF
C_C209  N_C0_27  N_C0_39  1.194823e+00pF
C_C210  N_C0_27  N_C0_40  1.174422e+00pF
* *  Node  N_C0_28 to other nodes
C_C211  N_C0_28  0  1.668325e+01pF
C_C212  N_C0_28  N_C0_30  7.258867e+00pF
C_C213  N_C0_28  N_C0_31  7.274891e+00pF
C_C214  N_C0_28  N_C0_32  1.232013e+00pF
C_C215  N_C0_28  N_C0_36  2.311250e+00pF
C_C216  N_C0_28  N_C0_38  7.284925e+00pF
C_C217  N_C0_28  N_C0_39  7.295255e+00pF
C_C218  N_C0_28  N_C0_40  1.184162e+00pF
* *  Node  N_C0_29 to other nodes
C_C219  N_C0_29  0  5.262360e+00pF
C_C220  N_C0_29  N_C0_30  7.358533e+00pF
C_C221  N_C0_29  N_C0_31  2.487666e+00pF
C_C222  N_C0_29  N_C0_32  7.358533e+00pF
C_C223  N_C0_29  N_C0_37  1.016018e+00pF
* *  Node  N_C0_30 to other nodes
C_C224  N_C0_30  0  7.042845e+00pF
C_C225  N_C0_30  N_C0_31  7.915437e+00pF
C_C226  N_C0_30  N_C0_32  2.729828e+00pF
* *  Node  N_C0_31 to other nodes
C_C227  N_C0_31  0  7.107332e+00pF
C_C228  N_C0_31  N_C0_32  7.915437e+00pF
* *  Node  N_C0_32 to other nodes
C_C229  N_C0_32  0  7.042841e+00pF
* *  Node  N_C0_33 to other nodes
C_C230  N_C0_33  0  1.391256e+01pF
C_C231  N_C0_33  N_C0_34  6.523523e+00pF
C_C232  N_C0_33  N_C0_35  1.668990e+00pF
C_C233  N_C0_33  N_C0_36  6.813352e+00pF
C_C234  N_C0_33  N_C0_38  1.107743e+00pF
C_C235  N_C0_33  N_C0_39  7.074895e+00pF
C_C236  N_C0_33  N_C0_40  7.058084e+00pF
C_C237  N_C0_33  N_C0_42  6.683403e+00pF
C_C238  N_C0_33  N_TOP  1.184048e+00pF
* *  Node  N_C0_34 to other nodes
C_C239  N_C0_34  0  1.273176e+01pF
C_C240  N_C0_34  N_C0_35  4.027172e+00pF
C_C241  N_C0_34  N_C0_36  1.666392e+00pF
C_C242  N_C0_34  N_C0_37  4.983253e+00pF
C_C243  N_C0_34  N_C0_39  1.063241e+00pF
C_C244  N_C0_34  N_C0_40  7.072741e+00pF
C_C245  N_C0_34  N_C0_CONN_TOP  4.482625e+00pF
C_C246  N_C0_34  N_C0_42  5.486544e+00pF
C_C247  N_C0_34  N_TOP  1.065362e+00pF
* *  Node  N_C0_35 to other nodes
C_C248  N_C0_35  0  1.273208e+01pF
C_C249  N_C0_35  N_C0_36  6.528538e+00pF
C_C250  N_C0_35  N_C0_37  4.983681e+00pF
C_C251  N_C0_35  N_C0_38  7.073082e+00pF
C_C252  N_C0_35  N_C0_39  1.063411e+00pF
C_C253  N_C0_35  N_C0_CONN_TOP  4.477048e+00pF
C_C254  N_C0_35  N_C0_42  5.486124e+00pF
C_C255  N_C0_35  N_TOP  1.065363e+00pF
* *  Node  N_C0_36 to other nodes
C_C256  N_C0_36  0  1.390751e+01pF
C_C257  N_C0_36  N_C0_38  7.057289e+00pF
C_C258  N_C0_36  N_C0_39  7.074735e+00pF
C_C259  N_C0_36  N_C0_40  1.107428e+00pF
C_C260  N_C0_36  N_C0_42  6.681287e+00pF
C_C261  N_C0_36  N_TOP  1.183495e+00pF
* *  Node  N_C0_37 to other nodes
C_C262  N_C0_37  0  4.936436e+00pF
C_C263  N_C0_37  N_C0_38  7.232497e+00pF
C_C264  N_C0_37  N_C0_39  2.447355e+00pF
C_C265  N_C0_37  N_C0_40  7.232503e+00pF
* *  Node  N_C0_38 to other nodes
C_C266  N_C0_38  0  7.461690e+00pF
C_C267  N_C0_38  N_C0_39  7.917440e+00pF
C_C268  N_C0_38  N_C0_40  2.725629e+00pF
* *  Node  N_C0_39 to other nodes
C_C269  N_C0_39  0  7.585376e+00pF
C_C270  N_C0_39  N_C0_40  7.917447e+00pF
* *  Node  N_C0_40 to other nodes
C_C271  N_C0_40  0  7.461582e+00pF
* *  Node  N_C0_CONN_TOP to other nodes
C_C272  N_C0_CONN_TOP  0  2.559381e+00pF
C_C273  N_C0_CONN_TOP  N_C0_42  2.981115e+00pF
* *  Node  N_C0_42 to other nodes
C_C274  N_C0_42  0  8.374150e+00pF
C_C275  N_C0_42  N_TOP  3.614810e+00pF
* *  Node  N_TOP to other nodes
C_C276  N_TOP  0  1.350815e+01pF
.ENDS 4corner_tower_1sdc
